* thermal network
.option numdgt=6
Vamb amb 0 45.0
R0 n_0_0_0 n_1_0_0 32.69273494920007
R1 n_0_0_0 n_0_1_0 624.2415416457985
R2 n_0_0_0 n_0_0_1 148.24482274846264
R3 n_0_0_1 n_1_0_1 45.76982892888009
R4 n_0_0_1 n_0_1_1 873.9381583041178
R5 n_0_0_1 n_0_0_2 336.9200517010514
R6 n_0_0_2 n_1_0_2 81.73183737300018
R7 n_0_0_2 n_0_1_2 1560.6038541144962
R8 n_0_0_2 n_0_0_3 315.3571683921841
R9 n_0_0_3 n_1_0_3 1144.2457232220013
R10 n_0_0_3 n_0_1_3 21848.453957602927
R11 n_0_0_3 n_0_0_4 4.192782865613088
R12 n_0_0_4 n_1_0_4 34.67411282490913
R13 n_0_0_4 n_0_1_4 662.0743623516038
R14 n_0_0_4 n_0_0_5 3.465463388925103
R15 n_0_0_5 n_1_0_5 217.9515663280002
R16 n_0_0_5 n_0_1_5 4161.610277638653
R17 n_0_0_5 n_0_0_6 1.1979379616037393
R18 n_0_0_6 n_1_0_6 36.32526105466671
R19 n_0_0_6 n_0_1_6 693.6017129397754
R20 n_0_0_6 n_0_0_7 1.6257729478907874
R21 n_0_0_7 n_1_0_7 62.27187609371455
R22 n_0_0_7 n_0_1_7 1189.0315078967617
R23 n_0_0_7 n_0_0_8 1.1979379616037358
R24 n_0_0_8 n_1_0_8 62.27187609371455
R25 n_0_0_8 n_0_1_8 1189.0315078967617
R26 n_0_0_8 n_0_0_9 1.1979379616037358
R27 n_0_0_9 n_1_0_9 62.27187609371455
R28 n_0_0_9 n_0_1_9 1189.0315078967617
R29 n_0_0_9 n_0_0_10 1.1979379616037358
R30 n_0_0_10 n_1_0_10 62.27187609371455
R31 n_0_0_10 n_0_1_10 1189.0315078967617
R32 n_0_0_10 n_0_0_11 1.1979379616037282
R33 n_0_0_11 n_1_0_11 62.27187609371534
R34 n_0_0_11 n_0_1_11 1189.031507896777
R35 n_0_0_11 n_0_0_12 1.1979379616037242
R36 n_0_0_12 n_1_0_12 62.271876093714965
R37 n_0_0_12 n_0_1_12 1189.0315078967692
R38 n_0_0_12 n_0_0_13 1.1979379616037358
R39 n_0_0_13 n_1_0_13 62.27187609371416
R40 n_0_0_13 n_0_1_13 1189.0315078967542
R41 n_0_0_13 n_0_0_14 5.989689808018694
R42 n_0_0_14 n_1_0_14 6.919097343746047
R43 n_0_0_14 n_0_1_14 132.11461198852882
R44 n_0_0_14 n_0_0_15 185.08141506777935
R45 n_0_0_15 n_1_0_15 2288.491446443982
R46 n_0_0_15 n_0_1_15 43696.90791520547
R47 n_0_1_0 n_1_1_0 32.69273494920007
R48 n_0_1_0 n_0_2_0 624.2415416457985
R49 n_0_1_0 n_0_1_1 148.24482274846264
R50 n_0_1_1 n_1_1_1 45.76982892888009
R51 n_0_1_1 n_0_2_1 873.9381583041178
R52 n_0_1_1 n_0_1_2 336.9200517010514
R53 n_0_1_2 n_1_1_2 81.73183737300018
R54 n_0_1_2 n_0_2_2 1560.6038541144962
R55 n_0_1_2 n_0_1_3 315.3571683921841
R56 n_0_1_3 n_1_1_3 1144.2457232220013
R57 n_0_1_3 n_0_2_3 21848.453957602927
R58 n_0_1_3 n_0_1_4 4.192782865613088
R59 n_0_1_4 n_1_1_4 34.67411282490913
R60 n_0_1_4 n_0_2_4 662.0743623516038
R61 n_0_1_4 n_0_1_5 3.465463388925103
R62 n_0_1_5 n_1_1_5 217.9515663280002
R63 n_0_1_5 n_0_2_5 4161.610277638653
R64 n_0_1_5 n_0_1_6 1.1979379616037393
R65 n_0_1_6 n_1_1_6 36.32526105466671
R66 n_0_1_6 n_0_2_6 693.6017129397754
R67 n_0_1_6 n_0_1_7 1.6257729478907874
R68 n_0_1_7 n_1_1_7 62.27187609371455
R69 n_0_1_7 n_0_2_7 1189.0315078967617
R70 n_0_1_7 n_0_1_8 1.1979379616037358
R71 n_0_1_8 n_1_1_8 62.27187609371455
R72 n_0_1_8 n_0_2_8 1189.0315078967617
R73 n_0_1_8 n_0_1_9 1.1979379616037358
R74 n_0_1_9 n_1_1_9 62.27187609371455
R75 n_0_1_9 n_0_2_9 1189.0315078967617
R76 n_0_1_9 n_0_1_10 1.1979379616037358
R77 n_0_1_10 n_1_1_10 62.27187609371455
R78 n_0_1_10 n_0_2_10 1189.0315078967617
R79 n_0_1_10 n_0_1_11 1.1979379616037282
R80 n_0_1_11 n_1_1_11 62.27187609371534
R81 n_0_1_11 n_0_2_11 1189.031507896777
R82 n_0_1_11 n_0_1_12 1.1979379616037242
R83 n_0_1_12 n_1_1_12 62.271876093714965
R84 n_0_1_12 n_0_2_12 1189.0315078967692
R85 n_0_1_12 n_0_1_13 1.1979379616037358
R86 n_0_1_13 n_1_1_13 62.27187609371416
R87 n_0_1_13 n_0_2_13 1189.0315078967542
R88 n_0_1_13 n_0_1_14 5.989689808018694
R89 n_0_1_14 n_1_1_14 6.919097343746047
R90 n_0_1_14 n_0_2_14 132.11461198852882
R91 n_0_1_14 n_0_1_15 185.08141506777935
R92 n_0_1_15 n_1_1_15 2288.491446443982
R93 n_0_1_15 n_0_2_15 43696.90791520547
R94 n_0_2_0 n_1_2_0 32.69273494920007
R95 n_0_2_0 n_0_3_0 624.2415416457985
R96 n_0_2_0 n_0_2_1 148.24482274846264
R97 n_0_2_1 n_1_2_1 45.76982892888009
R98 n_0_2_1 n_0_3_1 873.9381583041178
R99 n_0_2_1 n_0_2_2 336.9200517010514
R100 n_0_2_2 n_1_2_2 81.73183737300018
R101 n_0_2_2 n_0_3_2 1560.6038541144962
R102 n_0_2_2 n_0_2_3 315.3571683921841
R103 n_0_2_3 n_1_2_3 1144.2457232220013
R104 n_0_2_3 n_0_3_3 21848.453957602927
R105 n_0_2_3 n_0_2_4 4.192782865613088
R106 n_0_2_4 n_1_2_4 34.67411282490913
R107 n_0_2_4 n_0_3_4 662.0743623516038
R108 n_0_2_4 n_0_2_5 3.465463388925103
R109 n_0_2_5 n_1_2_5 217.9515663280002
R110 n_0_2_5 n_0_3_5 4161.610277638653
R111 n_0_2_5 n_0_2_6 1.1979379616037393
R112 n_0_2_6 n_1_2_6 36.32526105466671
R113 n_0_2_6 n_0_3_6 693.6017129397754
R114 n_0_2_6 n_0_2_7 1.6257729478907874
R115 n_0_2_7 n_1_2_7 62.27187609371455
R116 n_0_2_7 n_0_3_7 1189.0315078967617
R117 n_0_2_7 n_0_2_8 1.1979379616037358
R118 n_0_2_8 n_1_2_8 62.27187609371455
R119 n_0_2_8 n_0_3_8 1189.0315078967617
R120 n_0_2_8 n_0_2_9 1.1979379616037358
R121 n_0_2_9 n_1_2_9 62.27187609371455
R122 n_0_2_9 n_0_3_9 1189.0315078967617
R123 n_0_2_9 n_0_2_10 1.1979379616037358
R124 n_0_2_10 n_1_2_10 62.27187609371455
R125 n_0_2_10 n_0_3_10 1189.0315078967617
R126 n_0_2_10 n_0_2_11 1.1979379616037282
R127 n_0_2_11 n_1_2_11 62.27187609371534
R128 n_0_2_11 n_0_3_11 1189.031507896777
R129 n_0_2_11 n_0_2_12 1.1979379616037242
R130 n_0_2_12 n_1_2_12 62.271876093714965
R131 n_0_2_12 n_0_3_12 1189.0315078967692
R132 n_0_2_12 n_0_2_13 1.1979379616037358
R133 n_0_2_13 n_1_2_13 62.27187609371416
R134 n_0_2_13 n_0_3_13 1189.0315078967542
R135 n_0_2_13 n_0_2_14 5.989689808018694
R136 n_0_2_14 n_1_2_14 6.919097343746047
R137 n_0_2_14 n_0_3_14 132.11461198852882
R138 n_0_2_14 n_0_2_15 185.08141506777935
R139 n_0_2_15 n_1_2_15 2288.491446443982
R140 n_0_2_15 n_0_3_15 43696.90791520547
R141 n_0_3_0 n_1_3_0 32.69273494920007
R142 n_0_3_0 n_0_4_0 326.2736359366225
R143 n_0_3_0 n_0_3_1 148.24482274846264
R144 n_0_3_1 n_1_3_1 45.76982892888009
R145 n_0_3_1 n_0_4_1 456.7830903112714
R146 n_0_3_1 n_0_3_2 336.9200517010514
R147 n_0_3_2 n_1_3_2 81.73183737300018
R148 n_0_3_2 n_0_4_2 815.6840898415562
R149 n_0_3_2 n_0_3_3 315.3571683921841
R150 n_0_3_3 n_1_3_3 1144.2457232220013
R151 n_0_3_3 n_0_4_3 11419.577257781777
R152 n_0_3_3 n_0_3_4 4.192782865613088
R153 n_0_3_4 n_1_3_4 34.67411282490913
R154 n_0_3_4 n_0_4_4 346.0477956903568
R155 n_0_3_4 n_0_3_5 3.465463388925103
R156 n_0_3_5 n_1_3_5 217.9515663280002
R157 n_0_3_5 n_0_4_5 2175.157572910815
R158 n_0_3_5 n_0_3_6 1.1979379616037393
R159 n_0_3_6 n_1_3_6 36.32526105466671
R160 n_0_3_6 n_0_4_6 362.5262621518024
R161 n_0_3_6 n_0_3_7 1.6257729478907874
R162 n_0_3_7 n_1_3_7 62.27187609371455
R163 n_0_3_7 n_0_4_7 621.4735922602347
R164 n_0_3_7 n_0_3_8 1.1979379616037358
R165 n_0_3_8 n_1_3_8 62.27187609371455
R166 n_0_3_8 n_0_4_8 621.4735922602347
R167 n_0_3_8 n_0_3_9 1.1979379616037358
R168 n_0_3_9 n_1_3_9 62.27187609371455
R169 n_0_3_9 n_0_4_9 621.4735922602347
R170 n_0_3_9 n_0_3_10 1.1979379616037358
R171 n_0_3_10 n_1_3_10 62.27187609371455
R172 n_0_3_10 n_0_4_10 621.4735922602347
R173 n_0_3_10 n_0_3_11 1.1979379616037282
R174 n_0_3_11 n_1_3_11 62.27187609371534
R175 n_0_3_11 n_0_4_11 621.4735922602426
R176 n_0_3_11 n_0_3_12 1.1979379616037242
R177 n_0_3_12 n_1_3_12 62.271876093714965
R178 n_0_3_12 n_0_4_12 621.4735922602385
R179 n_0_3_12 n_0_3_13 1.1979379616037358
R180 n_0_3_13 n_1_3_13 62.27187609371416
R181 n_0_3_13 n_0_4_13 621.4735922602308
R182 n_0_3_13 n_0_3_14 5.989689808018694
R183 n_0_3_14 n_1_3_14 6.919097343746047
R184 n_0_3_14 n_0_4_14 69.05262136224816
R185 n_0_3_14 n_0_3_15 185.08141506777935
R186 n_0_3_15 n_1_3_15 2288.491446443982
R187 n_0_3_15 n_0_4_15 22839.15451556335
R188 n_0_4_0 n_1_4_0 720.9905238734129
R189 n_0_4_0 n_0_5_0 28.305730227446713
R190 n_0_4_0 n_0_4_1 3269.323064620219
R191 n_0_4_1 n_1_4_1 1009.3867334227781
R192 n_0_4_1 n_0_5_1 39.628022318425394
R193 n_0_4_1 n_0_4_2 7430.279692318681
R194 n_0_4_2 n_1_4_2 1802.4763096835325
R195 n_0_4_2 n_0_5_2 70.76432556861678
R196 n_0_4_2 n_0_4_3 6954.741792010285
R197 n_0_4_3 n_1_4_3 25234.668335569433
R198 n_0_4_3 n_0_5_3 990.700557960634
R199 n_0_4_3 n_0_4_4 92.46570283774366
R200 n_0_4_4 n_1_4_4 764.6869192596798
R201 n_0_4_4 n_0_5_4 30.02122902911012
R202 n_0_4_4 n_0_4_5 76.42573397813507
R203 n_0_4_5 n_1_4_5 4806.603492489416
R204 n_0_4_5 n_0_5_5 188.70486818297792
R205 n_0_4_5 n_0_4_6 26.418772239355334
R206 n_0_4_6 n_1_4_6 801.1005820815693
R207 n_0_4_6 n_0_5_6 31.45081136382965
R208 n_0_4_6 n_0_4_7 35.854048039125054
R209 n_0_4_7 n_1_4_7 1373.3152835684089
R210 n_0_4_7 n_0_5_7 53.91567662370814
R211 n_0_4_7 n_0_4_8 26.418772239355253
R212 n_0_4_8 n_1_4_8 1373.3152835684089
R213 n_0_4_8 n_0_5_8 53.91567662370814
R214 n_0_4_8 n_0_4_9 26.418772239355253
R215 n_0_4_9 n_1_4_9 1373.3152835684089
R216 n_0_4_9 n_0_5_9 53.91567662370814
R217 n_0_4_9 n_0_4_10 26.418772239355253
R218 n_0_4_10 n_1_4_10 1373.3152835684089
R219 n_0_4_10 n_0_5_10 53.91567662370814
R220 n_0_4_10 n_0_4_11 26.418772239355086
R221 n_0_4_11 n_1_4_11 1373.3152835684261
R222 n_0_4_11 n_0_5_11 53.91567662370883
R223 n_0_4_11 n_0_4_12 26.418772239355
R224 n_0_4_12 n_1_4_12 1373.3152835684175
R225 n_0_4_12 n_0_5_12 53.915676623708485
R226 n_0_4_12 n_0_4_13 26.41877223935525
R227 n_0_4_13 n_1_4_13 1373.3152835684
R228 n_0_4_13 n_0_5_13 53.9156766237078
R229 n_0_4_13 n_0_4_14 132.0938611967766
R230 n_0_4_14 n_1_4_14 152.59058706315622
R231 n_0_4_14 n_0_5_14 5.990630735967559
R232 n_0_4_14 n_0_4_15 4081.700310980434
R233 n_0_4_15 n_1_4_15 50469.336671138415
R234 n_0_4_15 n_0_5_15 1981.4011159212505
R235 n_0_5_0 n_1_5_0 720.9905238734003
R236 n_0_5_0 n_0_6_0 28.305730227446965
R237 n_0_5_0 n_0_5_1 3269.323064620161
R238 n_0_5_1 n_1_5_1 1009.3867334227601
R239 n_0_5_1 n_0_6_1 39.62802231842574
R240 n_0_5_1 n_0_5_2 7430.279692318548
R241 n_0_5_2 n_1_5_2 1802.4763096835004
R242 n_0_5_2 n_0_6_2 70.76432556861741
R243 n_0_5_2 n_0_5_3 6954.741792010161
R244 n_0_5_3 n_1_5_3 25234.668335568982
R245 n_0_5_3 n_0_6_3 990.7005579606428
R246 n_0_5_3 n_0_5_4 92.46570283774201
R247 n_0_5_4 n_1_5_4 764.6869192596662
R248 n_0_5_4 n_0_6_4 30.021229029110387
R249 n_0_5_4 n_0_5_5 76.4257339781337
R250 n_0_5_5 n_1_5_5 4806.603492489331
R251 n_0_5_5 n_0_6_5 188.7048681829796
R252 n_0_5_5 n_0_5_6 26.418772239354865
R253 n_0_5_6 n_1_5_6 801.100582081555
R254 n_0_5_6 n_0_6_6 31.45081136382993
R255 n_0_5_6 n_0_5_7 35.85404803912442
R256 n_0_5_7 n_1_5_7 1373.3152835683845
R257 n_0_5_7 n_0_6_7 53.91567662370862
R258 n_0_5_7 n_0_5_8 26.418772239354784
R259 n_0_5_8 n_1_5_8 1373.3152835683845
R260 n_0_5_8 n_0_6_8 53.91567662370862
R261 n_0_5_8 n_0_5_9 26.418772239354784
R262 n_0_5_9 n_1_5_9 1373.3152835683845
R263 n_0_5_9 n_0_6_9 53.91567662370862
R264 n_0_5_9 n_0_5_10 26.418772239354784
R265 n_0_5_10 n_1_5_10 1373.3152835683845
R266 n_0_5_10 n_0_6_10 53.91567662370862
R267 n_0_5_10 n_0_5_11 26.418772239354617
R268 n_0_5_11 n_1_5_11 1373.3152835684016
R269 n_0_5_11 n_0_6_11 53.91567662370932
R270 n_0_5_11 n_0_5_12 26.41877223935453
R271 n_0_5_12 n_1_5_12 1373.315283568393
R272 n_0_5_12 n_0_6_12 53.91567662370896
R273 n_0_5_12 n_0_5_13 26.41877223935478
R274 n_0_5_13 n_1_5_13 1373.3152835683757
R275 n_0_5_13 n_0_6_13 53.91567662370828
R276 n_0_5_13 n_0_5_14 132.09386119677424
R277 n_0_5_14 n_1_5_14 152.59058706315346
R278 n_0_5_14 n_0_6_14 5.9906307359676125
R279 n_0_5_14 n_0_5_15 4081.7003109803613
R280 n_0_5_15 n_1_5_15 50469.33667113751
R281 n_0_5_15 n_0_6_15 1981.4011159212682
R282 n_0_6_0 n_1_6_0 720.9905238734003
R283 n_0_6_0 n_0_7_0 28.305730227446713
R284 n_0_6_0 n_0_6_1 3269.323064620161
R285 n_0_6_1 n_1_6_1 1009.3867334227601
R286 n_0_6_1 n_0_7_1 39.628022318425394
R287 n_0_6_1 n_0_6_2 7430.279692318548
R288 n_0_6_2 n_1_6_2 1802.4763096835004
R289 n_0_6_2 n_0_7_2 70.76432556861678
R290 n_0_6_2 n_0_6_3 6954.741792010161
R291 n_0_6_3 n_1_6_3 25234.668335568982
R292 n_0_6_3 n_0_7_3 990.700557960634
R293 n_0_6_3 n_0_6_4 92.46570283774201
R294 n_0_6_4 n_1_6_4 764.6869192596662
R295 n_0_6_4 n_0_7_4 30.02122902911012
R296 n_0_6_4 n_0_6_5 76.4257339781337
R297 n_0_6_5 n_1_6_5 4806.603492489331
R298 n_0_6_5 n_0_7_5 188.70486818297792
R299 n_0_6_5 n_0_6_6 26.418772239354865
R300 n_0_6_6 n_1_6_6 801.100582081555
R301 n_0_6_6 n_0_7_6 31.45081136382965
R302 n_0_6_6 n_0_6_7 35.85404803912442
R303 n_0_6_7 n_1_6_7 1373.3152835683845
R304 n_0_6_7 n_0_7_7 53.91567662370814
R305 n_0_6_7 n_0_6_8 26.418772239354784
R306 n_0_6_8 n_1_6_8 1373.3152835683845
R307 n_0_6_8 n_0_7_8 53.91567662370814
R308 n_0_6_8 n_0_6_9 26.418772239354784
R309 n_0_6_9 n_1_6_9 1373.3152835683845
R310 n_0_6_9 n_0_7_9 53.91567662370814
R311 n_0_6_9 n_0_6_10 26.418772239354784
R312 n_0_6_10 n_1_6_10 1373.3152835683845
R313 n_0_6_10 n_0_7_10 53.91567662370814
R314 n_0_6_10 n_0_6_11 26.418772239354617
R315 n_0_6_11 n_1_6_11 1373.3152835684016
R316 n_0_6_11 n_0_7_11 53.91567662370883
R317 n_0_6_11 n_0_6_12 26.41877223935453
R318 n_0_6_12 n_1_6_12 1373.315283568393
R319 n_0_6_12 n_0_7_12 53.915676623708485
R320 n_0_6_12 n_0_6_13 26.41877223935478
R321 n_0_6_13 n_1_6_13 1373.3152835683757
R322 n_0_6_13 n_0_7_13 53.9156766237078
R323 n_0_6_13 n_0_6_14 132.09386119677424
R324 n_0_6_14 n_1_6_14 152.59058706315346
R325 n_0_6_14 n_0_7_14 5.990630735967559
R326 n_0_6_14 n_0_6_15 4081.7003109803613
R327 n_0_6_15 n_1_6_15 50469.33667113751
R328 n_0_6_15 n_0_7_15 1981.4011159212505
R329 n_0_7_0 n_1_7_0 720.9905238734129
R330 n_0_7_0 n_0_8_0 827.2137876682008
R331 n_0_7_0 n_0_7_1 3269.323064620219
R332 n_0_7_1 n_1_7_1 1009.3867334227781
R333 n_0_7_1 n_0_8_1 1158.099302735481
R334 n_0_7_1 n_0_7_2 7430.279692318681
R335 n_0_7_2 n_1_7_2 1802.4763096835325
R336 n_0_7_2 n_0_8_2 2068.034469170502
R337 n_0_7_2 n_0_7_3 6954.741792010285
R338 n_0_7_3 n_1_7_3 25234.668335569433
R339 n_0_7_3 n_0_8_3 28952.482568387
R340 n_0_7_3 n_0_7_4 92.46570283774366
R341 n_0_7_4 n_1_7_4 764.6869192596798
R342 n_0_7_4 n_0_8_4 877.3479566177879
R343 n_0_7_4 n_0_7_5 76.42573397813507
R344 n_0_7_5 n_1_7_5 4806.603492489416
R345 n_0_7_5 n_0_8_5 5514.758584454667
R346 n_0_7_5 n_0_7_6 26.418772239355334
R347 n_0_7_6 n_1_7_6 801.1005820815693
R348 n_0_7_6 n_0_8_6 919.1264307424444
R349 n_0_7_6 n_0_7_7 35.854048039125054
R350 n_0_7_7 n_1_7_7 1373.3152835684089
R351 n_0_7_7 n_0_8_7 1575.6453098441953
R352 n_0_7_7 n_0_7_8 26.418772239355253
R353 n_0_7_8 n_1_7_8 1373.3152835684089
R354 n_0_7_8 n_0_8_8 1575.6453098441953
R355 n_0_7_8 n_0_7_9 26.418772239355253
R356 n_0_7_9 n_1_7_9 1373.3152835684089
R357 n_0_7_9 n_0_8_9 1575.6453098441953
R358 n_0_7_9 n_0_7_10 26.418772239355253
R359 n_0_7_10 n_1_7_10 1373.3152835684089
R360 n_0_7_10 n_0_8_10 1575.6453098441953
R361 n_0_7_10 n_0_7_11 26.418772239355086
R362 n_0_7_11 n_1_7_11 1373.3152835684261
R363 n_0_7_11 n_0_8_11 1575.6453098442157
R364 n_0_7_11 n_0_7_12 26.418772239355
R365 n_0_7_12 n_1_7_12 1373.3152835684175
R366 n_0_7_12 n_0_8_12 1575.6453098442053
R367 n_0_7_12 n_0_7_13 26.41877223935525
R368 n_0_7_13 n_1_7_13 1373.3152835684
R369 n_0_7_13 n_0_8_13 1575.6453098441855
R370 n_0_7_13 n_0_7_14 132.0938611967766
R371 n_0_7_14 n_1_7_14 152.59058706315622
R372 n_0_7_14 n_0_8_14 175.07170109379913
R373 n_0_7_14 n_0_7_15 4081.700310980434
R374 n_0_7_15 n_1_7_15 50469.336671138415
R375 n_0_7_15 n_0_8_15 57904.96513677349
R376 n_0_8_0 n_1_8_0 12.550205463809338
R377 n_0_8_0 n_0_9_0 1626.1218451089555
R378 n_0_8_0 n_0_8_1 56.90875931090389
R379 n_0_8_1 n_1_8_1 17.57028764933307
R380 n_0_8_1 n_0_9_1 2276.5705831525374
R381 n_0_8_1 n_0_8_2 129.33808934296337
R382 n_0_8_2 n_1_8_2 31.37551365952334
R383 n_0_8_2 n_0_9_2 4065.3046127723887
R384 n_0_8_2 n_0_8_3 121.06045162501373
R385 n_0_8_3 n_1_8_3 439.25719123332635
R386 n_0_8_3 n_0_9_3 56914.26457881339
R387 n_0_8_3 n_0_8_4 1.6095406673791013
R388 n_0_8_4 n_1_8_4 13.310823976767468
R389 n_0_8_4 n_0_9_4 1724.6746842064663
R390 n_0_8_4 n_0_8_5 1.3303346332419101
R391 n_0_8_5 n_1_8_5 83.66803642539551
R392 n_0_8_5 n_0_9_5 10840.81230072636
R393 n_0_8_5 n_0_8_6 0.4598687621083147
R394 n_0_8_6 n_1_8_6 13.944672737565918
R395 n_0_8_6 n_0_9_6 1806.80205012106
R396 n_0_8_6 n_0_8_7 0.6241076057184264
R397 n_0_8_7 n_1_8_7 23.90515326439879
R398 n_0_8_7 n_0_9_7 3097.374943064684
R399 n_0_8_7 n_0_8_8 0.45986876210831323
R400 n_0_8_8 n_1_8_8 23.90515326439879
R401 n_0_8_8 n_0_9_8 3097.374943064684
R402 n_0_8_8 n_0_8_9 0.45986876210831323
R403 n_0_8_9 n_1_8_9 23.90515326439879
R404 n_0_8_9 n_0_9_9 3097.374943064684
R405 n_0_8_9 n_0_8_10 0.45986876210831323
R406 n_0_8_10 n_1_8_10 23.90515326439879
R407 n_0_8_10 n_0_9_10 3097.374943064684
R408 n_0_8_10 n_0_8_11 0.4598687621083103
R409 n_0_8_11 n_1_8_11 23.905153264399097
R410 n_0_8_11 n_0_9_11 3097.374943064724
R411 n_0_8_11 n_0_8_12 0.45986876210830885
R412 n_0_8_12 n_1_8_12 23.905153264398944
R413 n_0_8_12 n_0_9_12 3097.374943064704
R414 n_0_8_12 n_0_8_13 0.45986876210831323
R415 n_0_8_13 n_1_8_13 23.905153264398635
R416 n_0_8_13 n_0_9_13 3097.3749430646644
R417 n_0_8_13 n_0_8_14 2.299343810541572
R418 n_0_8_14 n_1_8_14 2.6561281404887485
R419 n_0_8_14 n_0_9_14 344.1527714516309
R420 n_0_8_14 n_0_8_15 71.04972374573522
R421 n_0_8_15 n_1_8_15 878.514382466645
R422 n_0_8_15 n_0_9_15 113828.52915762577
R423 n_0_9_0 n_1_9_0 12.550205463809327
R424 n_0_9_0 n_0_10_0 1626.1218451089555
R425 n_0_9_0 n_0_9_1 56.90875931090386
R426 n_0_9_1 n_1_9_1 17.57028764933306
R427 n_0_9_1 n_0_10_1 2276.5705831525374
R428 n_0_9_1 n_0_9_2 129.3380893429633
R429 n_0_9_2 n_1_9_2 31.37551365952332
R430 n_0_9_2 n_0_10_2 4065.3046127723887
R431 n_0_9_2 n_0_9_3 121.06045162501364
R432 n_0_9_3 n_1_9_3 439.2571912333261
R433 n_0_9_3 n_0_10_3 56914.26457881339
R434 n_0_9_3 n_0_9_4 1.6095406673791004
R435 n_0_9_4 n_1_9_4 13.310823976767457
R436 n_0_9_4 n_0_10_4 1724.6746842064663
R437 n_0_9_4 n_0_9_5 1.3303346332419095
R438 n_0_9_5 n_1_9_5 83.66803642539544
R439 n_0_9_5 n_0_10_5 10840.81230072636
R440 n_0_9_5 n_0_9_6 0.4598687621083144
R441 n_0_9_6 n_1_9_6 13.944672737565908
R442 n_0_9_6 n_0_10_6 1806.80205012106
R443 n_0_9_6 n_0_9_7 0.6241076057184259
R444 n_0_9_7 n_1_9_7 23.905153264398773
R445 n_0_9_7 n_0_10_7 3097.374943064684
R446 n_0_9_7 n_0_9_8 0.4598687621083129
R447 n_0_9_8 n_1_9_8 23.905153264398773
R448 n_0_9_8 n_0_10_8 3097.374943064684
R449 n_0_9_8 n_0_9_9 0.4598687621083129
R450 n_0_9_9 n_1_9_9 23.905153264398773
R451 n_0_9_9 n_0_10_9 3097.374943064684
R452 n_0_9_9 n_0_9_10 0.4598687621083129
R453 n_0_9_10 n_1_9_10 23.905153264398773
R454 n_0_9_10 n_0_10_10 3097.374943064684
R455 n_0_9_10 n_0_9_11 0.45986876210830996
R456 n_0_9_11 n_1_9_11 23.905153264399075
R457 n_0_9_11 n_0_10_11 3097.374943064724
R458 n_0_9_11 n_0_9_12 0.4598687621083085
R459 n_0_9_12 n_1_9_12 23.905153264398926
R460 n_0_9_12 n_0_10_12 3097.374943064704
R461 n_0_9_12 n_0_9_13 0.4598687621083129
R462 n_0_9_13 n_1_9_13 23.90515326439862
R463 n_0_9_13 n_0_10_13 3097.3749430646644
R464 n_0_9_13 n_0_9_14 2.2993438105415707
R465 n_0_9_14 n_1_9_14 2.656128140488747
R466 n_0_9_14 n_0_10_14 344.1527714516309
R467 n_0_9_14 n_0_9_15 71.04972374573518
R468 n_0_9_15 n_1_9_15 878.5143824666445
R469 n_0_9_15 n_0_10_15 113828.52915762577
R470 n_0_10_0 n_1_10_0 12.550205463809338
R471 n_0_10_0 n_0_11_0 1626.121845108955
R472 n_0_10_0 n_0_10_1 56.90875931090389
R473 n_0_10_1 n_1_10_1 17.57028764933307
R474 n_0_10_1 n_0_11_1 2276.570583152537
R475 n_0_10_1 n_0_10_2 129.33808934296337
R476 n_0_10_2 n_1_10_2 31.37551365952334
R477 n_0_10_2 n_0_11_2 4065.3046127723874
R478 n_0_10_2 n_0_10_3 121.06045162501373
R479 n_0_10_3 n_1_10_3 439.25719123332635
R480 n_0_10_3 n_0_11_3 56914.264578813374
R481 n_0_10_3 n_0_10_4 1.6095406673791013
R482 n_0_10_4 n_1_10_4 13.310823976767468
R483 n_0_10_4 n_0_11_4 1724.6746842064658
R484 n_0_10_4 n_0_10_5 1.3303346332419101
R485 n_0_10_5 n_1_10_5 83.66803642539551
R486 n_0_10_5 n_0_11_5 10840.812300726357
R487 n_0_10_5 n_0_10_6 0.4598687621083147
R488 n_0_10_6 n_1_10_6 13.944672737565918
R489 n_0_10_6 n_0_11_6 1806.8020501210594
R490 n_0_10_6 n_0_10_7 0.6241076057184264
R491 n_0_10_7 n_1_10_7 23.90515326439879
R492 n_0_10_7 n_0_11_7 3097.374943064683
R493 n_0_10_7 n_0_10_8 0.45986876210831323
R494 n_0_10_8 n_1_10_8 23.90515326439879
R495 n_0_10_8 n_0_11_8 3097.374943064683
R496 n_0_10_8 n_0_10_9 0.45986876210831323
R497 n_0_10_9 n_1_10_9 23.90515326439879
R498 n_0_10_9 n_0_11_9 3097.374943064683
R499 n_0_10_9 n_0_10_10 0.45986876210831323
R500 n_0_10_10 n_1_10_10 23.90515326439879
R501 n_0_10_10 n_0_11_10 3097.374943064683
R502 n_0_10_10 n_0_10_11 0.4598687621083103
R503 n_0_10_11 n_1_10_11 23.905153264399097
R504 n_0_10_11 n_0_11_11 3097.374943064723
R505 n_0_10_11 n_0_10_12 0.45986876210830885
R506 n_0_10_12 n_1_10_12 23.905153264398944
R507 n_0_10_12 n_0_11_12 3097.3749430647026
R508 n_0_10_12 n_0_10_13 0.45986876210831323
R509 n_0_10_13 n_1_10_13 23.905153264398635
R510 n_0_10_13 n_0_11_13 3097.3749430646635
R511 n_0_10_13 n_0_10_14 2.299343810541572
R512 n_0_10_14 n_1_10_14 2.6561281404887485
R513 n_0_10_14 n_0_11_14 344.15277145163077
R514 n_0_10_14 n_0_10_15 71.04972374573522
R515 n_0_10_15 n_1_10_15 878.514382466645
R516 n_0_10_15 n_0_11_15 113828.52915762574
R517 n_0_11_0 n_1_11_0 12.550205463809338
R518 n_0_11_0 n_0_12_0 827.2138119611458
R519 n_0_11_0 n_0_11_1 56.90875931090389
R520 n_0_11_1 n_1_11_1 17.57028764933307
R521 n_0_11_1 n_0_12_1 1158.099336745604
R522 n_0_11_1 n_0_11_2 129.33808934296337
R523 n_0_11_2 n_1_11_2 31.37551365952334
R524 n_0_11_2 n_0_12_2 2068.0345299028645
R525 n_0_11_2 n_0_11_3 121.06045162501373
R526 n_0_11_3 n_1_11_3 439.25719123332635
R527 n_0_11_3 n_0_12_3 28952.483418640077
R528 n_0_11_3 n_0_11_4 1.6095406673791013
R529 n_0_11_4 n_1_11_4 13.310823976767468
R530 n_0_11_4 n_0_12_4 877.3479823830326
R531 n_0_11_4 n_0_11_5 1.3303346332419101
R532 n_0_11_5 n_1_11_5 83.66803642539551
R533 n_0_11_5 n_0_12_5 5514.758746407633
R534 n_0_11_5 n_0_11_6 0.4598687621083147
R535 n_0_11_6 n_1_11_6 13.944672737565918
R536 n_0_11_6 n_0_12_6 919.1264577346055
R537 n_0_11_6 n_0_11_7 0.6241076057184264
R538 n_0_11_7 n_1_11_7 23.90515326439879
R539 n_0_11_7 n_0_12_7 1575.6453561164717
R540 n_0_11_7 n_0_11_8 0.45986876210831323
R541 n_0_11_8 n_1_11_8 23.90515326439879
R542 n_0_11_8 n_0_12_8 1575.6453561164717
R543 n_0_11_8 n_0_11_9 0.45986876210831323
R544 n_0_11_9 n_1_11_9 23.90515326439879
R545 n_0_11_9 n_0_12_9 1575.6453561164717
R546 n_0_11_9 n_0_11_10 0.45986876210831323
R547 n_0_11_10 n_1_11_10 23.90515326439879
R548 n_0_11_10 n_0_12_10 1575.6453561164717
R549 n_0_11_10 n_0_11_11 0.4598687621083103
R550 n_0_11_11 n_1_11_11 23.905153264399097
R551 n_0_11_11 n_0_12_11 1575.645356116492
R552 n_0_11_11 n_0_11_12 0.45986876210830885
R553 n_0_11_12 n_1_11_12 23.905153264398944
R554 n_0_11_12 n_0_12_12 1575.6453561164817
R555 n_0_11_12 n_0_11_13 0.45986876210831323
R556 n_0_11_13 n_1_11_13 23.905153264398635
R557 n_0_11_13 n_0_12_13 1575.6453561164617
R558 n_0_11_13 n_0_11_14 2.299343810541572
R559 n_0_11_14 n_1_11_14 2.6561281404887485
R560 n_0_11_14 n_0_12_14 175.07170623516316
R561 n_0_11_14 n_0_11_15 71.04972374573522
R562 n_0_11_15 n_1_11_15 878.514382466645
R563 n_0_11_15 n_0_12_15 57904.966837279644
R564 n_0_12_0 n_1_12_0 720.9892863181211
R565 n_0_12_0 n_0_13_0 28.305778813336566
R566 n_0_12_0 n_0_12_1 3269.3174529402795
R567 n_0_12_1 n_1_12_1 1009.3850008453696
R568 n_0_12_1 n_0_13_1 39.62809033867119
R569 n_0_12_1 n_0_12_2 7430.266938500637
R570 n_0_12_2 n_1_12_2 1802.473215795303
R571 n_0_12_2 n_0_13_2 70.76444703334141
R572 n_0_12_2 n_0_12_3 6954.729854436596
R573 n_0_12_3 n_1_12_3 25234.625021134216
R574 n_0_12_3 n_0_13_3 990.7022584667789
R575 n_0_12_3 n_0_12_4 92.46554412356356
R576 n_0_12_4 n_1_12_4 764.6856067010369
R577 n_0_12_4 n_0_13_4 30.02128055959936
R578 n_0_12_4 n_0_12_5 76.42560279600661
R579 n_0_12_5 n_1_12_5 4806.595242120803
R580 n_0_12_5 n_0_13_5 188.70519208891028
R581 n_0_12_5 n_0_12_6 26.418726892446728
R582 n_0_12_6 n_1_12_6 801.0992070201339
R583 n_0_12_6 n_0_13_6 31.450865348151712
R584 n_0_12_6 n_0_12_7 35.85398649689195
R585 n_0_12_7 n_1_12_7 1373.3129263202338
R586 n_0_12_7 n_0_13_7 53.91576916826025
R587 n_0_12_7 n_0_12_8 26.418726892446646
R588 n_0_12_8 n_1_12_8 1373.3129263202338
R589 n_0_12_8 n_0_13_8 53.91576916826025
R590 n_0_12_8 n_0_12_9 26.418726892446646
R591 n_0_12_9 n_1_12_9 1373.3129263202338
R592 n_0_12_9 n_0_13_9 53.91576916826025
R593 n_0_12_9 n_0_12_10 26.418726892446646
R594 n_0_12_10 n_1_12_10 1373.3129263202338
R595 n_0_12_10 n_0_13_10 53.91576916826025
R596 n_0_12_10 n_0_12_11 26.41872689244648
R597 n_0_12_11 n_1_12_11 1373.3129263202513
R598 n_0_12_11 n_0_13_11 53.915769168260944
R599 n_0_12_11 n_0_12_12 26.418726892446394
R600 n_0_12_12 n_1_12_12 1373.3129263202425
R601 n_0_12_12 n_0_13_12 53.91576916826059
R602 n_0_12_12 n_0_12_13 26.41872689244665
R603 n_0_12_13 n_1_12_13 1373.3129263202252
R604 n_0_12_13 n_0_13_13 53.91576916825991
R605 n_0_12_13 n_0_12_14 132.09363446223358
R606 n_0_12_14 n_1_12_14 152.59032514669232
R607 n_0_12_14 n_0_13_14 5.9906410186955705
R608 n_0_12_14 n_0_12_15 4081.693304883055
R609 n_0_12_15 n_1_12_15 50469.25004226799
R610 n_0_12_15 n_0_13_15 1981.4045169335404
R611 n_0_13_0 n_1_13_0 720.9892863181211
R612 n_0_13_0 n_0_14_0 28.305778813336566
R613 n_0_13_0 n_0_13_1 3269.3174529402795
R614 n_0_13_1 n_1_13_1 1009.3850008453696
R615 n_0_13_1 n_0_14_1 39.62809033867119
R616 n_0_13_1 n_0_13_2 7430.266938500637
R617 n_0_13_2 n_1_13_2 1802.473215795303
R618 n_0_13_2 n_0_14_2 70.76444703334141
R619 n_0_13_2 n_0_13_3 6954.729854436596
R620 n_0_13_3 n_1_13_3 25234.625021134216
R621 n_0_13_3 n_0_14_3 990.7022584667789
R622 n_0_13_3 n_0_13_4 92.46554412356356
R623 n_0_13_4 n_1_13_4 764.6856067010369
R624 n_0_13_4 n_0_14_4 30.02128055959936
R625 n_0_13_4 n_0_13_5 76.42560279600661
R626 n_0_13_5 n_1_13_5 4806.595242120803
R627 n_0_13_5 n_0_14_5 188.70519208891028
R628 n_0_13_5 n_0_13_6 26.418726892446728
R629 n_0_13_6 n_1_13_6 801.0992070201339
R630 n_0_13_6 n_0_14_6 31.450865348151712
R631 n_0_13_6 n_0_13_7 35.85398649689195
R632 n_0_13_7 n_1_13_7 1373.3129263202338
R633 n_0_13_7 n_0_14_7 53.91576916826025
R634 n_0_13_7 n_0_13_8 26.418726892446646
R635 n_0_13_8 n_1_13_8 1373.3129263202338
R636 n_0_13_8 n_0_14_8 53.91576916826025
R637 n_0_13_8 n_0_13_9 26.418726892446646
R638 n_0_13_9 n_1_13_9 1373.3129263202338
R639 n_0_13_9 n_0_14_9 53.91576916826025
R640 n_0_13_9 n_0_13_10 26.418726892446646
R641 n_0_13_10 n_1_13_10 1373.3129263202338
R642 n_0_13_10 n_0_14_10 53.91576916826025
R643 n_0_13_10 n_0_13_11 26.41872689244648
R644 n_0_13_11 n_1_13_11 1373.3129263202513
R645 n_0_13_11 n_0_14_11 53.915769168260944
R646 n_0_13_11 n_0_13_12 26.418726892446394
R647 n_0_13_12 n_1_13_12 1373.3129263202425
R648 n_0_13_12 n_0_14_12 53.91576916826059
R649 n_0_13_12 n_0_13_13 26.41872689244665
R650 n_0_13_13 n_1_13_13 1373.3129263202252
R651 n_0_13_13 n_0_14_13 53.91576916825991
R652 n_0_13_13 n_0_13_14 132.09363446223358
R653 n_0_13_14 n_1_13_14 152.59032514669232
R654 n_0_13_14 n_0_14_14 5.9906410186955705
R655 n_0_13_14 n_0_13_15 4081.693304883055
R656 n_0_13_15 n_1_13_15 50469.25004226799
R657 n_0_13_15 n_0_14_15 1981.4045169335404
R658 n_0_14_0 n_1_14_0 720.9892863181211
R659 n_0_14_0 n_0_15_0 28.305778813336566
R660 n_0_14_0 n_0_14_1 3269.3174529402795
R661 n_0_14_1 n_1_14_1 1009.3850008453696
R662 n_0_14_1 n_0_15_1 39.62809033867119
R663 n_0_14_1 n_0_14_2 7430.266938500637
R664 n_0_14_2 n_1_14_2 1802.473215795303
R665 n_0_14_2 n_0_15_2 70.76444703334141
R666 n_0_14_2 n_0_14_3 6954.729854436596
R667 n_0_14_3 n_1_14_3 25234.625021134216
R668 n_0_14_3 n_0_15_3 990.7022584667789
R669 n_0_14_3 n_0_14_4 92.46554412356356
R670 n_0_14_4 n_1_14_4 764.6856067010369
R671 n_0_14_4 n_0_15_4 30.02128055959936
R672 n_0_14_4 n_0_14_5 76.42560279600661
R673 n_0_14_5 n_1_14_5 4806.595242120803
R674 n_0_14_5 n_0_15_5 188.70519208891028
R675 n_0_14_5 n_0_14_6 26.418726892446728
R676 n_0_14_6 n_1_14_6 801.0992070201339
R677 n_0_14_6 n_0_15_6 31.450865348151712
R678 n_0_14_6 n_0_14_7 35.85398649689195
R679 n_0_14_7 n_1_14_7 1373.3129263202338
R680 n_0_14_7 n_0_15_7 53.91576916826025
R681 n_0_14_7 n_0_14_8 26.418726892446646
R682 n_0_14_8 n_1_14_8 1373.3129263202338
R683 n_0_14_8 n_0_15_8 53.91576916826025
R684 n_0_14_8 n_0_14_9 26.418726892446646
R685 n_0_14_9 n_1_14_9 1373.3129263202338
R686 n_0_14_9 n_0_15_9 53.91576916826025
R687 n_0_14_9 n_0_14_10 26.418726892446646
R688 n_0_14_10 n_1_14_10 1373.3129263202338
R689 n_0_14_10 n_0_15_10 53.91576916826025
R690 n_0_14_10 n_0_14_11 26.41872689244648
R691 n_0_14_11 n_1_14_11 1373.3129263202513
R692 n_0_14_11 n_0_15_11 53.915769168260944
R693 n_0_14_11 n_0_14_12 26.418726892446394
R694 n_0_14_12 n_1_14_12 1373.3129263202425
R695 n_0_14_12 n_0_15_12 53.91576916826059
R696 n_0_14_12 n_0_14_13 26.41872689244665
R697 n_0_14_13 n_1_14_13 1373.3129263202252
R698 n_0_14_13 n_0_15_13 53.91576916825991
R699 n_0_14_13 n_0_14_14 132.09363446223358
R700 n_0_14_14 n_1_14_14 152.59032514669232
R701 n_0_14_14 n_0_15_14 5.9906410186955705
R702 n_0_14_14 n_0_14_15 4081.693304883055
R703 n_0_14_15 n_1_14_15 50469.25004226799
R704 n_0_14_15 n_0_15_15 1981.4045169335404
R705 n_0_15_0 n_1_15_0 720.9892863181211
R706 n_0_15_0 n_0_16_0 827.2138119611453
R707 n_0_15_0 n_0_15_1 3269.3174529402795
R708 n_0_15_1 n_1_15_1 1009.3850008453696
R709 n_0_15_1 n_0_16_1 1158.0993367456033
R710 n_0_15_1 n_0_15_2 7430.266938500637
R711 n_0_15_2 n_1_15_2 1802.473215795303
R712 n_0_15_2 n_0_16_2 2068.034529902863
R713 n_0_15_2 n_0_15_3 6954.729854436596
R714 n_0_15_3 n_1_15_3 25234.625021134216
R715 n_0_15_3 n_0_16_3 28952.48341864006
R716 n_0_15_3 n_0_15_4 92.46554412356356
R717 n_0_15_4 n_1_15_4 764.6856067010369
R718 n_0_15_4 n_0_16_4 877.347982383032
R719 n_0_15_4 n_0_15_5 76.42560279600661
R720 n_0_15_5 n_1_15_5 4806.595242120803
R721 n_0_15_5 n_0_16_5 5514.7587464076305
R722 n_0_15_5 n_0_15_6 26.418726892446728
R723 n_0_15_6 n_1_15_6 801.0992070201339
R724 n_0_15_6 n_0_16_6 919.126457734605
R725 n_0_15_6 n_0_15_7 35.85398649689195
R726 n_0_15_7 n_1_15_7 1373.3129263202338
R727 n_0_15_7 n_0_16_7 1575.6453561164708
R728 n_0_15_7 n_0_15_8 26.418726892446646
R729 n_0_15_8 n_1_15_8 1373.3129263202338
R730 n_0_15_8 n_0_16_8 1575.6453561164708
R731 n_0_15_8 n_0_15_9 26.418726892446646
R732 n_0_15_9 n_1_15_9 1373.3129263202338
R733 n_0_15_9 n_0_16_9 1575.6453561164708
R734 n_0_15_9 n_0_15_10 26.418726892446646
R735 n_0_15_10 n_1_15_10 1373.3129263202338
R736 n_0_15_10 n_0_16_10 1575.6453561164708
R737 n_0_15_10 n_0_15_11 26.41872689244648
R738 n_0_15_11 n_1_15_11 1373.3129263202513
R739 n_0_15_11 n_0_16_11 1575.645356116491
R740 n_0_15_11 n_0_15_12 26.418726892446394
R741 n_0_15_12 n_1_15_12 1373.3129263202425
R742 n_0_15_12 n_0_16_12 1575.6453561164808
R743 n_0_15_12 n_0_15_13 26.41872689244665
R744 n_0_15_13 n_1_15_13 1373.3129263202252
R745 n_0_15_13 n_0_16_13 1575.6453561164608
R746 n_0_15_13 n_0_15_14 132.09363446223358
R747 n_0_15_14 n_1_15_14 152.59032514669232
R748 n_0_15_14 n_0_16_14 175.07170623516305
R749 n_0_15_14 n_0_15_15 4081.693304883055
R750 n_0_15_15 n_1_15_15 50469.25004226799
R751 n_0_15_15 n_0_16_15 57904.96683727961
R752 n_0_16_0 n_1_16_0 12.550205463809347
R753 n_0_16_0 n_0_17_0 1626.121845108955
R754 n_0_16_0 n_0_16_1 56.908759310903925
R755 n_0_16_1 n_1_16_1 17.57028764933308
R756 n_0_16_1 n_0_17_1 2276.570583152537
R757 n_0_16_1 n_0_16_2 129.33808934296346
R758 n_0_16_2 n_1_16_2 31.37551365952336
R759 n_0_16_2 n_0_17_2 4065.3046127723874
R760 n_0_16_2 n_0_16_3 121.0604516250138
R761 n_0_16_3 n_1_16_3 439.2571912333266
R762 n_0_16_3 n_0_17_3 56914.26457881337
R763 n_0_16_3 n_0_16_4 1.6095406673791026
R764 n_0_16_4 n_1_16_4 13.310823976767471
R765 n_0_16_4 n_0_17_4 1724.6746842064658
R766 n_0_16_4 n_0_16_5 1.3303346332419115
R767 n_0_16_5 n_1_16_5 83.66803642539556
R768 n_0_16_5 n_0_17_5 10840.812300726357
R769 n_0_16_5 n_0_16_6 0.4598687621083149
R770 n_0_16_6 n_1_16_6 13.944672737565925
R771 n_0_16_6 n_0_17_6 1806.8020501210594
R772 n_0_16_6 n_0_16_7 0.6241076057184266
R773 n_0_16_7 n_1_16_7 23.905153264398802
R774 n_0_16_7 n_0_17_7 3097.374943064683
R775 n_0_16_7 n_0_16_8 0.45986876210831346
R776 n_0_16_8 n_1_16_8 23.905153264398802
R777 n_0_16_8 n_0_17_8 3097.374943064683
R778 n_0_16_8 n_0_16_9 0.45986876210831346
R779 n_0_16_9 n_1_16_9 23.905153264398802
R780 n_0_16_9 n_0_17_9 3097.374943064683
R781 n_0_16_9 n_0_16_10 0.45986876210831346
R782 n_0_16_10 n_1_16_10 23.905153264398802
R783 n_0_16_10 n_0_17_10 3097.374943064683
R784 n_0_16_10 n_0_16_11 0.4598687621083105
R785 n_0_16_11 n_1_16_11 23.905153264399107
R786 n_0_16_11 n_0_17_11 3097.374943064723
R787 n_0_16_11 n_0_16_12 0.45986876210830907
R788 n_0_16_12 n_1_16_12 23.905153264398955
R789 n_0_16_12 n_0_17_12 3097.374943064703
R790 n_0_16_12 n_0_16_13 0.45986876210831346
R791 n_0_16_13 n_1_16_13 23.905153264398653
R792 n_0_16_13 n_0_17_13 3097.3749430646635
R793 n_0_16_13 n_0_16_14 2.299343810541573
R794 n_0_16_14 n_1_16_14 2.6561281404887502
R795 n_0_16_14 n_0_17_14 344.15277145163077
R796 n_0_16_14 n_0_16_15 71.04972374573526
R797 n_0_16_15 n_1_16_15 878.5143824666454
R798 n_0_16_15 n_0_17_15 113828.52915762574
R799 n_0_17_0 n_1_17_0 12.550205463809327
R800 n_0_17_0 n_0_18_0 1626.121845108956
R801 n_0_17_0 n_0_17_1 56.90875931090386
R802 n_0_17_1 n_1_17_1 17.57028764933306
R803 n_0_17_1 n_0_18_1 2276.5705831525383
R804 n_0_17_1 n_0_17_2 129.3380893429633
R805 n_0_17_2 n_1_17_2 31.37551365952332
R806 n_0_17_2 n_0_18_2 4065.30461277239
R807 n_0_17_2 n_0_17_3 121.06045162501364
R808 n_0_17_3 n_1_17_3 439.2571912333261
R809 n_0_17_3 n_0_18_3 56914.2645788134
R810 n_0_17_3 n_0_17_4 1.6095406673791004
R811 n_0_17_4 n_1_17_4 13.310823976767457
R812 n_0_17_4 n_0_18_4 1724.6746842064667
R813 n_0_17_4 n_0_17_5 1.3303346332419095
R814 n_0_17_5 n_1_17_5 83.66803642539544
R815 n_0_17_5 n_0_18_5 10840.812300726364
R816 n_0_17_5 n_0_17_6 0.4598687621083144
R817 n_0_17_6 n_1_17_6 13.944672737565908
R818 n_0_17_6 n_0_18_6 1806.8020501210606
R819 n_0_17_6 n_0_17_7 0.6241076057184259
R820 n_0_17_7 n_1_17_7 23.905153264398773
R821 n_0_17_7 n_0_18_7 3097.374943064685
R822 n_0_17_7 n_0_17_8 0.4598687621083129
R823 n_0_17_8 n_1_17_8 23.905153264398773
R824 n_0_17_8 n_0_18_8 3097.374943064685
R825 n_0_17_8 n_0_17_9 0.4598687621083129
R826 n_0_17_9 n_1_17_9 23.905153264398773
R827 n_0_17_9 n_0_18_9 3097.374943064685
R828 n_0_17_9 n_0_17_10 0.4598687621083129
R829 n_0_17_10 n_1_17_10 23.905153264398773
R830 n_0_17_10 n_0_18_10 3097.374943064685
R831 n_0_17_10 n_0_17_11 0.45986876210830996
R832 n_0_17_11 n_1_17_11 23.905153264399075
R833 n_0_17_11 n_0_18_11 3097.374943064725
R834 n_0_17_11 n_0_17_12 0.4598687621083085
R835 n_0_17_12 n_1_17_12 23.905153264398926
R836 n_0_17_12 n_0_18_12 3097.374943064705
R837 n_0_17_12 n_0_17_13 0.4598687621083129
R838 n_0_17_13 n_1_17_13 23.90515326439862
R839 n_0_17_13 n_0_18_13 3097.3749430646653
R840 n_0_17_13 n_0_17_14 2.2993438105415707
R841 n_0_17_14 n_1_17_14 2.656128140488747
R842 n_0_17_14 n_0_18_14 344.15277145163094
R843 n_0_17_14 n_0_17_15 71.04972374573518
R844 n_0_17_15 n_1_17_15 878.5143824666445
R845 n_0_17_15 n_0_18_15 113828.52915762582
R846 n_0_18_0 n_1_18_0 12.550205463809327
R847 n_0_18_0 n_0_19_0 1626.121845108955
R848 n_0_18_0 n_0_18_1 56.90875931090386
R849 n_0_18_1 n_1_18_1 17.57028764933306
R850 n_0_18_1 n_0_19_1 2276.570583152537
R851 n_0_18_1 n_0_18_2 129.3380893429633
R852 n_0_18_2 n_1_18_2 31.37551365952332
R853 n_0_18_2 n_0_19_2 4065.3046127723874
R854 n_0_18_2 n_0_18_3 121.06045162501364
R855 n_0_18_3 n_1_18_3 439.2571912333261
R856 n_0_18_3 n_0_19_3 56914.26457881337
R857 n_0_18_3 n_0_18_4 1.6095406673791004
R858 n_0_18_4 n_1_18_4 13.310823976767457
R859 n_0_18_4 n_0_19_4 1724.6746842064658
R860 n_0_18_4 n_0_18_5 1.3303346332419095
R861 n_0_18_5 n_1_18_5 83.66803642539544
R862 n_0_18_5 n_0_19_5 10840.812300726357
R863 n_0_18_5 n_0_18_6 0.4598687621083144
R864 n_0_18_6 n_1_18_6 13.944672737565908
R865 n_0_18_6 n_0_19_6 1806.8020501210594
R866 n_0_18_6 n_0_18_7 0.6241076057184259
R867 n_0_18_7 n_1_18_7 23.905153264398773
R868 n_0_18_7 n_0_19_7 3097.374943064683
R869 n_0_18_7 n_0_18_8 0.4598687621083129
R870 n_0_18_8 n_1_18_8 23.905153264398773
R871 n_0_18_8 n_0_19_8 3097.374943064683
R872 n_0_18_8 n_0_18_9 0.4598687621083129
R873 n_0_18_9 n_1_18_9 23.905153264398773
R874 n_0_18_9 n_0_19_9 3097.374943064683
R875 n_0_18_9 n_0_18_10 0.4598687621083129
R876 n_0_18_10 n_1_18_10 23.905153264398773
R877 n_0_18_10 n_0_19_10 3097.374943064683
R878 n_0_18_10 n_0_18_11 0.45986876210830996
R879 n_0_18_11 n_1_18_11 23.905153264399075
R880 n_0_18_11 n_0_19_11 3097.374943064723
R881 n_0_18_11 n_0_18_12 0.4598687621083085
R882 n_0_18_12 n_1_18_12 23.905153264398926
R883 n_0_18_12 n_0_19_12 3097.374943064703
R884 n_0_18_12 n_0_18_13 0.4598687621083129
R885 n_0_18_13 n_1_18_13 23.90515326439862
R886 n_0_18_13 n_0_19_13 3097.3749430646635
R887 n_0_18_13 n_0_18_14 2.2993438105415707
R888 n_0_18_14 n_1_18_14 2.656128140488747
R889 n_0_18_14 n_0_19_14 344.15277145163077
R890 n_0_18_14 n_0_18_15 71.04972374573518
R891 n_0_18_15 n_1_18_15 878.5143824666445
R892 n_0_18_15 n_0_19_15 113828.52915762574
R893 n_0_19_0 n_1_19_0 12.550205463809347
R894 n_0_19_0 n_0_20_0 827.2138145479915
R895 n_0_19_0 n_0_19_1 56.908759310903925
R896 n_0_19_1 n_1_19_1 17.57028764933308
R897 n_0_19_1 n_0_20_1 1158.099340367188
R898 n_0_19_1 n_0_19_2 129.33808934296346
R899 n_0_19_2 n_1_19_2 31.37551365952336
R900 n_0_19_2 n_0_20_2 2068.034536369979
R901 n_0_19_2 n_0_19_3 121.0604516250138
R902 n_0_19_3 n_1_19_3 439.2571912333266
R903 n_0_19_3 n_0_20_3 28952.483509179674
R904 n_0_19_3 n_0_19_4 1.6095406673791026
R905 n_0_19_4 n_1_19_4 13.310823976767471
R906 n_0_19_4 n_0_20_4 877.3479851266568
R907 n_0_19_4 n_0_19_5 1.3303346332419115
R908 n_0_19_5 n_1_19_5 83.66803642539556
R909 n_0_19_5 n_0_20_5 5514.758763653272
R910 n_0_19_5 n_0_19_6 0.4598687621083149
R911 n_0_19_6 n_1_19_6 13.944672737565925
R912 n_0_19_6 n_0_20_6 919.1264606088786
R913 n_0_19_6 n_0_19_7 0.6241076057184266
R914 n_0_19_7 n_1_19_7 23.905153264398802
R915 n_0_19_7 n_0_20_7 1575.6453610437968
R916 n_0_19_7 n_0_19_8 0.45986876210831346
R917 n_0_19_8 n_1_19_8 23.905153264398802
R918 n_0_19_8 n_0_20_8 1575.6453610437968
R919 n_0_19_8 n_0_19_9 0.45986876210831346
R920 n_0_19_9 n_1_19_9 23.905153264398802
R921 n_0_19_9 n_0_20_9 1575.6453610437968
R922 n_0_19_9 n_0_19_10 0.45986876210831346
R923 n_0_19_10 n_1_19_10 23.905153264398802
R924 n_0_19_10 n_0_20_10 1575.6453610437968
R925 n_0_19_10 n_0_19_11 0.4598687621083105
R926 n_0_19_11 n_1_19_11 23.905153264399107
R927 n_0_19_11 n_0_20_11 1575.6453610438173
R928 n_0_19_11 n_0_19_12 0.45986876210830907
R929 n_0_19_12 n_1_19_12 23.905153264398955
R930 n_0_19_12 n_0_20_12 1575.6453610438068
R931 n_0_19_12 n_0_19_13 0.45986876210831346
R932 n_0_19_13 n_1_19_13 23.905153264398653
R933 n_0_19_13 n_0_20_13 1575.6453610437868
R934 n_0_19_13 n_0_19_14 2.299343810541573
R935 n_0_19_14 n_1_19_14 2.6561281404887502
R936 n_0_19_14 n_0_20_14 175.07170678264373
R937 n_0_19_14 n_0_19_15 71.04972374573526
R938 n_0_19_15 n_1_19_15 878.5143824666454
R939 n_0_19_15 n_0_20_15 57904.96701835884
R940 n_0_20_0 n_1_20_0 720.9891545366872
R941 n_0_20_0 n_0_21_0 28.30578398702898
R942 n_0_20_0 n_0_20_1 3269.316855378915
R943 n_0_20_1 n_1_20_1 1009.384816351362
R944 n_0_20_1 n_0_21_1 39.62809758184057
R945 n_0_20_1 n_0_20_2 7430.265580406626
R946 n_0_20_2 n_1_20_2 1802.4728863417183
R947 n_0_20_2 n_0_21_2 70.76445996757245
R948 n_0_20_2 n_0_20_3 6954.728583260602
R949 n_0_20_3 n_1_20_3 25234.620408784027
R950 n_0_20_3 n_0_21_3 990.7024395460134
R951 n_0_20_3 n_0_20_4 92.4655272228381
R952 n_0_20_4 n_1_20_4 764.6854669328494
R953 n_0_20_4 n_0_21_4 30.02128604684889
R954 n_0_20_4 n_0_20_5 76.42558882703966
R955 n_0_20_5 n_1_20_5 4806.59436357791
R956 n_0_20_5 n_0_21_5 188.70522658019303
R957 n_0_20_5 n_0_20_6 26.41872206366803
R958 n_0_20_6 n_1_20_6 801.0990605963185
R959 n_0_20_6 n_0_21_6 31.450871096698837
R960 n_0_20_6 n_0_20_7 35.853979943549426
R961 n_0_20_7 n_1_20_7 1373.3126753079787
R962 n_0_20_7 n_0_21_7 53.91577902291246
R963 n_0_20_7 n_0_20_8 26.418722063667946
R964 n_0_20_8 n_1_20_8 1373.3126753079787
R965 n_0_20_8 n_0_21_8 53.91577902291246
R966 n_0_20_8 n_0_20_9 26.418722063667946
R967 n_0_20_9 n_1_20_9 1373.3126753079787
R968 n_0_20_9 n_0_21_9 53.91577902291246
R969 n_0_20_9 n_0_20_10 26.418722063667946
R970 n_0_20_10 n_1_20_10 1373.3126753079787
R971 n_0_20_10 n_0_21_10 53.91577902291246
R972 n_0_20_10 n_0_20_11 26.41872206366778
R973 n_0_20_11 n_1_20_11 1373.3126753079964
R974 n_0_20_11 n_0_21_11 53.915779022913156
R975 n_0_20_11 n_0_20_12 26.418722063667694
R976 n_0_20_12 n_1_20_12 1373.3126753079873
R977 n_0_20_12 n_0_21_12 53.91577902291281
R978 n_0_20_12 n_0_20_13 26.41872206366795
R979 n_0_20_13 n_1_20_13 1373.3126753079698
R980 n_0_20_13 n_0_21_13 53.915779022912126
R981 n_0_20_13 n_0_20_14 132.09361031834007
R982 n_0_20_14 n_1_20_14 152.59029725644177
R983 n_0_20_14 n_0_21_14 5.990642113656929
R984 n_0_20_14 n_0_20_15 4081.6925588367453
R985 n_0_20_15 n_1_20_15 50469.2408175676
R986 n_0_20_15 n_0_21_15 1981.4048790920094
R987 n_0_21_0 n_1_21_0 720.9891545366872
R988 n_0_21_0 n_0_22_0 28.305783987027976
R989 n_0_21_0 n_0_21_1 3269.316855378915
R990 n_0_21_1 n_1_21_1 1009.384816351362
R991 n_0_21_1 n_0_22_1 39.628097581839164
R992 n_0_21_1 n_0_21_2 7430.265580406626
R993 n_0_21_2 n_1_21_2 1802.4728863417183
R994 n_0_21_2 n_0_22_2 70.76445996756993
R995 n_0_21_2 n_0_21_3 6954.728583260602
R996 n_0_21_3 n_1_21_3 25234.620408784027
R997 n_0_21_3 n_0_22_3 990.7024395459782
R998 n_0_21_3 n_0_21_4 92.4655272228381
R999 n_0_21_4 n_1_21_4 764.6854669328494
R1000 n_0_21_4 n_0_22_4 30.021286046847823
R1001 n_0_21_4 n_0_21_5 76.42558882703966
R1002 n_0_21_5 n_1_21_5 4806.59436357791
R1003 n_0_21_5 n_0_22_5 188.70522658018632
R1004 n_0_21_5 n_0_21_6 26.41872206366803
R1005 n_0_21_6 n_1_21_6 801.0990605963185
R1006 n_0_21_6 n_0_22_6 31.45087109669772
R1007 n_0_21_6 n_0_21_7 35.853979943549426
R1008 n_0_21_7 n_1_21_7 1373.3126753079787
R1009 n_0_21_7 n_0_22_7 53.91577902291054
R1010 n_0_21_7 n_0_21_8 26.418722063667946
R1011 n_0_21_8 n_1_21_8 1373.3126753079787
R1012 n_0_21_8 n_0_22_8 53.91577902291054
R1013 n_0_21_8 n_0_21_9 26.418722063667946
R1014 n_0_21_9 n_1_21_9 1373.3126753079787
R1015 n_0_21_9 n_0_22_9 53.91577902291054
R1016 n_0_21_9 n_0_21_10 26.418722063667946
R1017 n_0_21_10 n_1_21_10 1373.3126753079787
R1018 n_0_21_10 n_0_22_10 53.91577902291054
R1019 n_0_21_10 n_0_21_11 26.41872206366778
R1020 n_0_21_11 n_1_21_11 1373.3126753079964
R1021 n_0_21_11 n_0_22_11 53.91577902291124
R1022 n_0_21_11 n_0_21_12 26.418722063667694
R1023 n_0_21_12 n_1_21_12 1373.3126753079873
R1024 n_0_21_12 n_0_22_12 53.9157790229109
R1025 n_0_21_12 n_0_21_13 26.41872206366795
R1026 n_0_21_13 n_1_21_13 1373.3126753079698
R1027 n_0_21_13 n_0_22_13 53.915779022910215
R1028 n_0_21_13 n_0_21_14 132.09361031834007
R1029 n_0_21_14 n_1_21_14 152.59029725644177
R1030 n_0_21_14 n_0_22_14 5.990642113656715
R1031 n_0_21_14 n_0_21_15 4081.6925588367453
R1032 n_0_21_15 n_1_21_15 50469.2408175676
R1033 n_0_21_15 n_0_22_15 1981.4048790919392
R1034 n_0_22_0 n_1_22_0 720.9891545367384
R1035 n_0_22_0 n_0_23_0 28.305783987027976
R1036 n_0_22_0 n_0_22_1 3269.3168553791475
R1037 n_0_22_1 n_1_22_1 1009.3848163514338
R1038 n_0_22_1 n_0_23_1 39.628097581839164
R1039 n_0_22_1 n_0_22_2 7430.265580407155
R1040 n_0_22_2 n_1_22_2 1802.472886341846
R1041 n_0_22_2 n_0_23_2 70.76445996756993
R1042 n_0_22_2 n_0_22_3 6954.728583261097
R1043 n_0_22_3 n_1_22_3 25234.620408785824
R1044 n_0_22_3 n_0_23_3 990.7024395459782
R1045 n_0_22_3 n_0_22_4 92.46552722284467
R1046 n_0_22_4 n_1_22_4 764.6854669329036
R1047 n_0_22_4 n_0_23_4 30.021286046847823
R1048 n_0_22_4 n_0_22_5 76.42558882704509
R1049 n_0_22_5 n_1_22_5 4806.594363578251
R1050 n_0_22_5 n_0_23_5 188.70522658018632
R1051 n_0_22_5 n_0_22_6 26.418722063669907
R1052 n_0_22_6 n_1_22_6 801.0990605963754
R1053 n_0_22_6 n_0_23_6 31.45087109669772
R1054 n_0_22_6 n_0_22_7 35.85397994355198
R1055 n_0_22_7 n_1_22_7 1373.3126753080762
R1056 n_0_22_7 n_0_23_7 53.91577902291054
R1057 n_0_22_7 n_0_22_8 26.418722063669826
R1058 n_0_22_8 n_1_22_8 1373.3126753080762
R1059 n_0_22_8 n_0_23_8 53.91577902291054
R1060 n_0_22_8 n_0_22_9 26.418722063669826
R1061 n_0_22_9 n_1_22_9 1373.3126753080762
R1062 n_0_22_9 n_0_23_9 53.91577902291054
R1063 n_0_22_9 n_0_22_10 26.418722063669826
R1064 n_0_22_10 n_1_22_10 1373.3126753080762
R1065 n_0_22_10 n_0_23_10 53.91577902291054
R1066 n_0_22_10 n_0_22_11 26.418722063669655
R1067 n_0_22_11 n_1_22_11 1373.3126753080937
R1068 n_0_22_11 n_0_23_11 53.91577902291124
R1069 n_0_22_11 n_0_22_12 26.418722063669573
R1070 n_0_22_12 n_1_22_12 1373.312675308085
R1071 n_0_22_12 n_0_23_12 53.9157790229109
R1072 n_0_22_12 n_0_22_13 26.418722063669826
R1073 n_0_22_13 n_1_22_13 1373.3126753080676
R1074 n_0_22_13 n_0_23_13 53.915779022910215
R1075 n_0_22_13 n_0_22_14 132.09361031834945
R1076 n_0_22_14 n_1_22_14 152.5902972564526
R1077 n_0_22_14 n_0_23_14 5.990642113656715
R1078 n_0_22_14 n_0_22_15 4081.692558837036
R1079 n_0_22_15 n_1_22_15 50469.2408175712
R1080 n_0_22_15 n_0_23_15 1981.4048790919392
R1081 n_0_23_0 n_1_23_0 720.9891545366872
R1082 n_0_23_0 n_0_24_0 326.27363593662324
R1083 n_0_23_0 n_0_23_1 3269.316855378915
R1084 n_0_23_1 n_1_23_1 1009.384816351362
R1085 n_0_23_1 n_0_24_1 456.7830903112725
R1086 n_0_23_1 n_0_23_2 7430.265580406626
R1087 n_0_23_2 n_1_23_2 1802.4728863417183
R1088 n_0_23_2 n_0_24_2 815.684089841558
R1089 n_0_23_2 n_0_23_3 6954.728583260602
R1090 n_0_23_3 n_1_23_3 25234.620408784027
R1091 n_0_23_3 n_0_24_3 11419.577257781802
R1092 n_0_23_3 n_0_23_4 92.4655272228381
R1093 n_0_23_4 n_1_23_4 764.6854669328494
R1094 n_0_23_4 n_0_24_4 346.0477956903576
R1095 n_0_23_4 n_0_23_5 76.42558882703966
R1096 n_0_23_5 n_1_23_5 4806.59436357791
R1097 n_0_23_5 n_0_24_5 2175.1575729108195
R1098 n_0_23_5 n_0_23_6 26.41872206366803
R1099 n_0_23_6 n_1_23_6 801.0990605963185
R1100 n_0_23_6 n_0_24_6 362.5262621518032
R1101 n_0_23_6 n_0_23_7 35.853979943549426
R1102 n_0_23_7 n_1_23_7 1373.3126753079787
R1103 n_0_23_7 n_0_24_7 621.473592260236
R1104 n_0_23_7 n_0_23_8 26.418722063667946
R1105 n_0_23_8 n_1_23_8 1373.3126753079787
R1106 n_0_23_8 n_0_24_8 621.473592260236
R1107 n_0_23_8 n_0_23_9 26.418722063667946
R1108 n_0_23_9 n_1_23_9 1373.3126753079787
R1109 n_0_23_9 n_0_24_9 621.473592260236
R1110 n_0_23_9 n_0_23_10 26.418722063667946
R1111 n_0_23_10 n_1_23_10 1373.3126753079787
R1112 n_0_23_10 n_0_24_10 621.473592260236
R1113 n_0_23_10 n_0_23_11 26.41872206366778
R1114 n_0_23_11 n_1_23_11 1373.3126753079964
R1115 n_0_23_11 n_0_24_11 621.473592260244
R1116 n_0_23_11 n_0_23_12 26.418722063667694
R1117 n_0_23_12 n_1_23_12 1373.3126753079873
R1118 n_0_23_12 n_0_24_12 621.47359226024
R1119 n_0_23_12 n_0_23_13 26.41872206366795
R1120 n_0_23_13 n_1_23_13 1373.3126753079698
R1121 n_0_23_13 n_0_24_13 621.4735922602322
R1122 n_0_23_13 n_0_23_14 132.09361031834007
R1123 n_0_23_14 n_1_23_14 152.59029725644177
R1124 n_0_23_14 n_0_24_14 69.0526213622483
R1125 n_0_23_14 n_0_23_15 4081.6925588367453
R1126 n_0_23_15 n_1_23_15 50469.2408175676
R1127 n_0_23_15 n_0_24_15 22839.1545155634
R1128 n_0_24_0 n_1_24_0 32.692737764693376
R1129 n_0_24_0 n_0_25_0 624.2414878862164
R1130 n_0_24_0 n_0_24_1 148.244835515284
R1131 n_0_24_1 n_1_24_1 45.769832870570724
R1132 n_0_24_1 n_0_25_1 873.938083040703
R1133 n_0_24_1 n_0_24_2 336.92008071655454
R1134 n_0_24_2 n_1_24_2 81.73184441173345
R1135 n_0_24_2 n_0_25_2 1560.603719715541
R1136 n_0_24_2 n_0_24_3 315.35719555069505
R1137 n_0_24_3 n_1_24_3 1144.2458217642672
R1138 n_0_24_3 n_0_25_3 21848.45207601756
R1139 n_0_24_3 n_0_24_4 4.192783226694905
R1140 n_0_24_4 n_1_24_4 34.6741158110384
R1141 n_0_24_4 n_0_25_4 662.0743053338653
R1142 n_0_24_4 n_0_24_5 3.465463687370278
R1143 n_0_24_5 n_1_24_5 217.95158509795567
R1144 n_0_24_5 n_0_25_5 4161.6099192414395
R1145 n_0_24_5 n_0_24_6 1.1979380647699727
R1146 n_0_24_6 n_1_24_6 36.325264182992605
R1147 n_0_24_6 n_0_25_6 693.6016532069066
R1148 n_0_24_6 n_0_24_7 1.625773087902104
R1149 n_0_24_7 n_1_24_7 62.27188145655895
R1150 n_0_24_7 n_0_25_7 1189.031405497558
R1151 n_0_24_7 n_0_24_8 1.197938064769969
R1152 n_0_24_8 n_1_24_8 62.27188145655895
R1153 n_0_24_8 n_0_25_8 1189.031405497558
R1154 n_0_24_8 n_0_24_9 1.197938064769969
R1155 n_0_24_9 n_1_24_9 62.27188145655895
R1156 n_0_24_9 n_0_25_9 1189.031405497558
R1157 n_0_24_9 n_0_24_10 1.197938064769969
R1158 n_0_24_10 n_1_24_10 62.27188145655895
R1159 n_0_24_10 n_0_25_10 1189.031405497558
R1160 n_0_24_10 n_0_24_11 1.1979380647699611
R1161 n_0_24_11 n_1_24_11 62.27188145655975
R1162 n_0_24_11 n_0_25_11 1189.0314054975731
R1163 n_0_24_11 n_0_24_12 1.1979380647699576
R1164 n_0_24_12 n_1_24_12 62.271881456559356
R1165 n_0_24_12 n_0_25_12 1189.0314054975654
R1166 n_0_24_12 n_0_24_13 1.1979380647699691
R1167 n_0_24_13 n_1_24_13 62.27188145655856
R1168 n_0_24_13 n_0_25_13 1189.0314054975502
R1169 n_0_24_13 n_0_24_14 5.98969032384986
R1170 n_0_24_14 n_1_24_14 6.919097939617647
R1171 n_0_24_14 n_0_25_14 132.1146006108395
R1172 n_0_24_14 n_0_24_15 185.0814310069624
R1173 n_0_24_15 n_1_24_15 2288.491643528514
R1174 n_0_24_15 n_0_25_15 43696.904152034724
R1175 n_0_25_0 n_1_25_0 32.69273776469348
R1176 n_0_25_0 n_0_26_0 624.2414878862164
R1177 n_0_25_0 n_0_25_1 148.24483551528448
R1178 n_0_25_1 n_1_25_1 45.76983287057087
R1179 n_0_25_1 n_0_26_1 873.938083040703
R1180 n_0_25_1 n_0_25_2 336.9200807165556
R1181 n_0_25_2 n_1_25_2 81.7318444117337
R1182 n_0_25_2 n_0_26_2 1560.603719715541
R1183 n_0_25_2 n_0_25_3 315.3571955506961
R1184 n_0_25_3 n_1_25_3 1144.2458217642709
R1185 n_0_25_3 n_0_26_3 21848.45207601756
R1186 n_0_25_3 n_0_25_4 4.192783226694917
R1187 n_0_25_4 n_1_25_4 34.67411581103852
R1188 n_0_25_4 n_0_26_4 662.0743053338653
R1189 n_0_25_4 n_0_25_5 3.4654636873702893
R1190 n_0_25_5 n_1_25_5 217.95158509795635
R1191 n_0_25_5 n_0_26_5 4161.6099192414395
R1192 n_0_25_5 n_0_25_6 1.1979380647699764
R1193 n_0_25_6 n_1_25_6 36.325264182992726
R1194 n_0_25_6 n_0_26_6 693.6016532069066
R1195 n_0_25_6 n_0_25_7 1.6257730879021093
R1196 n_0_25_7 n_1_25_7 62.27188145655916
R1197 n_0_25_7 n_0_26_7 1189.031405497558
R1198 n_0_25_7 n_0_25_8 1.1979380647699729
R1199 n_0_25_8 n_1_25_8 62.27188145655916
R1200 n_0_25_8 n_0_26_8 1189.031405497558
R1201 n_0_25_8 n_0_25_9 1.1979380647699729
R1202 n_0_25_9 n_1_25_9 62.27188145655916
R1203 n_0_25_9 n_0_26_9 1189.031405497558
R1204 n_0_25_9 n_0_25_10 1.1979380647699729
R1205 n_0_25_10 n_1_25_10 62.27188145655916
R1206 n_0_25_10 n_0_26_10 1189.031405497558
R1207 n_0_25_10 n_0_25_11 1.1979380647699651
R1208 n_0_25_11 n_1_25_11 62.27188145655995
R1209 n_0_25_11 n_0_26_11 1189.0314054975731
R1210 n_0_25_11 n_0_25_12 1.1979380647699613
R1211 n_0_25_12 n_1_25_12 62.271881456559534
R1212 n_0_25_12 n_0_26_12 1189.0314054975654
R1213 n_0_25_12 n_0_25_13 1.1979380647699727
R1214 n_0_25_13 n_1_25_13 62.271881456558766
R1215 n_0_25_13 n_0_26_13 1189.0314054975502
R1216 n_0_25_13 n_0_25_14 5.989690323849879
R1217 n_0_25_14 n_1_25_14 6.919097939617668
R1218 n_0_25_14 n_0_26_14 132.1146006108395
R1219 n_0_25_14 n_0_25_15 185.081431006963
R1220 n_0_25_15 n_1_25_15 2288.4916435285213
R1221 n_0_25_15 n_0_26_15 43696.904152034724
R1222 n_0_26_0 n_1_26_0 32.692737764693376
R1223 n_0_26_0 n_0_27_0 624.2414878862174
R1224 n_0_26_0 n_0_26_1 148.244835515284
R1225 n_0_26_1 n_1_26_1 45.769832870570724
R1226 n_0_26_1 n_0_27_1 873.9380830407043
R1227 n_0_26_1 n_0_26_2 336.92008071655454
R1228 n_0_26_2 n_1_26_2 81.73184441173345
R1229 n_0_26_2 n_0_27_2 1560.6037197155435
R1230 n_0_26_2 n_0_26_3 315.35719555069505
R1231 n_0_26_3 n_1_26_3 1144.2458217642672
R1232 n_0_26_3 n_0_27_3 21848.45207601759
R1233 n_0_26_3 n_0_26_4 4.192783226694905
R1234 n_0_26_4 n_1_26_4 34.6741158110384
R1235 n_0_26_4 n_0_27_4 662.0743053338663
R1236 n_0_26_4 n_0_26_5 3.465463687370278
R1237 n_0_26_5 n_1_26_5 217.95158509795567
R1238 n_0_26_5 n_0_27_5 4161.609919241446
R1239 n_0_26_5 n_0_26_6 1.1979380647699727
R1240 n_0_26_6 n_1_26_6 36.325264182992605
R1241 n_0_26_6 n_0_27_6 693.6016532069076
R1242 n_0_26_6 n_0_26_7 1.625773087902104
R1243 n_0_26_7 n_1_26_7 62.27188145655895
R1244 n_0_26_7 n_0_27_7 1189.0314054975597
R1245 n_0_26_7 n_0_26_8 1.197938064769969
R1246 n_0_26_8 n_1_26_8 62.27188145655895
R1247 n_0_26_8 n_0_27_8 1189.0314054975597
R1248 n_0_26_8 n_0_26_9 1.197938064769969
R1249 n_0_26_9 n_1_26_9 62.27188145655895
R1250 n_0_26_9 n_0_27_9 1189.0314054975597
R1251 n_0_26_9 n_0_26_10 1.197938064769969
R1252 n_0_26_10 n_1_26_10 62.27188145655895
R1253 n_0_26_10 n_0_27_10 1189.0314054975597
R1254 n_0_26_10 n_0_26_11 1.1979380647699611
R1255 n_0_26_11 n_1_26_11 62.27188145655975
R1256 n_0_26_11 n_0_27_11 1189.031405497575
R1257 n_0_26_11 n_0_26_12 1.1979380647699576
R1258 n_0_26_12 n_1_26_12 62.271881456559356
R1259 n_0_26_12 n_0_27_12 1189.0314054975672
R1260 n_0_26_12 n_0_26_13 1.1979380647699691
R1261 n_0_26_13 n_1_26_13 62.27188145655856
R1262 n_0_26_13 n_0_27_13 1189.0314054975522
R1263 n_0_26_13 n_0_26_14 5.98969032384986
R1264 n_0_26_14 n_1_26_14 6.919097939617647
R1265 n_0_26_14 n_0_27_14 132.1146006108397
R1266 n_0_26_14 n_0_26_15 185.0814310069624
R1267 n_0_26_15 n_1_26_15 2288.491643528514
R1268 n_0_26_15 n_0_27_15 43696.9041520348
R1269 n_0_27_0 n_1_27_0 32.692737764693376
R1270 n_0_27_0 n_0_27_1 148.244835515284
R1271 n_0_27_1 n_1_27_1 45.769832870570724
R1272 n_0_27_1 n_0_27_2 336.92008071655454
R1273 n_0_27_2 n_1_27_2 81.73184441173345
R1274 n_0_27_2 n_0_27_3 315.35719555069505
R1275 n_0_27_3 n_1_27_3 1144.2458217642672
R1276 n_0_27_3 n_0_27_4 4.192783226694905
R1277 n_0_27_4 n_1_27_4 34.6741158110384
R1278 n_0_27_4 n_0_27_5 3.465463687370278
R1279 n_0_27_5 n_1_27_5 217.95158509795567
R1280 n_0_27_5 n_0_27_6 1.1979380647699727
R1281 n_0_27_6 n_1_27_6 36.325264182992605
R1282 n_0_27_6 n_0_27_7 1.625773087902104
R1283 n_0_27_7 n_1_27_7 62.27188145655895
R1284 n_0_27_7 n_0_27_8 1.197938064769969
R1285 n_0_27_8 n_1_27_8 62.27188145655895
R1286 n_0_27_8 n_0_27_9 1.197938064769969
R1287 n_0_27_9 n_1_27_9 62.27188145655895
R1288 n_0_27_9 n_0_27_10 1.197938064769969
R1289 n_0_27_10 n_1_27_10 62.27188145655895
R1290 n_0_27_10 n_0_27_11 1.1979380647699611
R1291 n_0_27_11 n_1_27_11 62.27188145655975
R1292 n_0_27_11 n_0_27_12 1.1979380647699576
R1293 n_0_27_12 n_1_27_12 62.271881456559356
R1294 n_0_27_12 n_0_27_13 1.1979380647699691
R1295 n_0_27_13 n_1_27_13 62.27188145655856
R1296 n_0_27_13 n_0_27_14 5.98969032384986
R1297 n_0_27_14 n_1_27_14 6.919097939617647
R1298 n_0_27_14 n_0_27_15 185.0814310069624
R1299 n_0_27_15 n_1_27_15 2288.491643528514
R1300 n_1_0_0 n_2_0_0 32.69273494920007
R1301 n_1_0_0 n_1_1_0 624.2415416457985
R1302 n_1_0_0 n_1_0_1 148.24482274846264
R1303 n_1_0_1 n_2_0_1 45.76982892888009
R1304 n_1_0_1 n_1_1_1 873.9381583041178
R1305 n_1_0_1 n_1_0_2 336.9200517010514
R1306 n_1_0_2 n_2_0_2 81.73183737300016
R1307 n_1_0_2 n_1_1_2 1560.6038541144962
R1308 n_1_0_2 n_1_0_3 315.3571683921841
R1309 n_1_0_3 n_2_0_3 1144.245723222001
R1310 n_1_0_3 n_1_1_3 21848.453957602927
R1311 n_1_0_3 n_1_0_4 4.192782865613088
R1312 n_1_0_4 n_2_0_4 34.67411282490913
R1313 n_1_0_4 n_1_1_4 662.0743623516038
R1314 n_1_0_4 n_1_0_5 3.465463388925103
R1315 n_1_0_5 n_2_0_5 217.95156632800018
R1316 n_1_0_5 n_1_1_5 4161.610277638653
R1317 n_1_0_5 n_1_0_6 1.1979379616037393
R1318 n_1_0_6 n_2_0_6 36.32526105466671
R1319 n_1_0_6 n_1_1_6 693.6017129397754
R1320 n_1_0_6 n_1_0_7 1.6257729478907874
R1321 n_1_0_7 n_2_0_7 62.271876093714546
R1322 n_1_0_7 n_1_1_7 1189.0315078967617
R1323 n_1_0_7 n_1_0_8 1.1979379616037358
R1324 n_1_0_8 n_2_0_8 62.271876093714546
R1325 n_1_0_8 n_1_1_8 1189.0315078967617
R1326 n_1_0_8 n_1_0_9 1.1979379616037358
R1327 n_1_0_9 n_2_0_9 62.271876093714546
R1328 n_1_0_9 n_1_1_9 1189.0315078967617
R1329 n_1_0_9 n_1_0_10 1.1979379616037358
R1330 n_1_0_10 n_2_0_10 62.271876093714546
R1331 n_1_0_10 n_1_1_10 1189.0315078967617
R1332 n_1_0_10 n_1_0_11 1.1979379616037282
R1333 n_1_0_11 n_2_0_11 62.271876093715335
R1334 n_1_0_11 n_1_1_11 1189.031507896777
R1335 n_1_0_11 n_1_0_12 1.1979379616037242
R1336 n_1_0_12 n_2_0_12 62.27187609371496
R1337 n_1_0_12 n_1_1_12 1189.0315078967692
R1338 n_1_0_12 n_1_0_13 1.1979379616037358
R1339 n_1_0_13 n_2_0_13 62.271876093714155
R1340 n_1_0_13 n_1_1_13 1189.0315078967542
R1341 n_1_0_13 n_1_0_14 5.989689808018694
R1342 n_1_0_14 n_2_0_14 6.919097343746046
R1343 n_1_0_14 n_1_1_14 132.11461198852882
R1344 n_1_0_14 n_1_0_15 185.08141506777935
R1345 n_1_0_15 n_2_0_15 2288.4914464439817
R1346 n_1_0_15 n_1_1_15 43696.90791520547
R1347 n_1_1_0 n_2_1_0 32.69273494920007
R1348 n_1_1_0 n_1_2_0 624.2415416457985
R1349 n_1_1_0 n_1_1_1 148.24482274846264
R1350 n_1_1_1 n_2_1_1 45.76982892888009
R1351 n_1_1_1 n_1_2_1 873.9381583041178
R1352 n_1_1_1 n_1_1_2 336.9200517010514
R1353 n_1_1_2 n_2_1_2 81.73183737300016
R1354 n_1_1_2 n_1_2_2 1560.6038541144962
R1355 n_1_1_2 n_1_1_3 315.3571683921841
R1356 n_1_1_3 n_2_1_3 1144.245723222001
R1357 n_1_1_3 n_1_2_3 21848.453957602927
R1358 n_1_1_3 n_1_1_4 4.192782865613088
R1359 n_1_1_4 n_2_1_4 34.67411282490913
R1360 n_1_1_4 n_1_2_4 662.0743623516038
R1361 n_1_1_4 n_1_1_5 3.465463388925103
R1362 n_1_1_5 n_2_1_5 217.95156632800018
R1363 n_1_1_5 n_1_2_5 4161.610277638653
R1364 n_1_1_5 n_1_1_6 1.1979379616037393
R1365 n_1_1_6 n_2_1_6 36.32526105466671
R1366 n_1_1_6 n_1_2_6 693.6017129397754
R1367 n_1_1_6 n_1_1_7 1.6257729478907874
R1368 n_1_1_7 n_2_1_7 62.271876093714546
R1369 n_1_1_7 n_1_2_7 1189.0315078967617
R1370 n_1_1_7 n_1_1_8 1.1979379616037358
R1371 n_1_1_8 n_2_1_8 62.271876093714546
R1372 n_1_1_8 n_1_2_8 1189.0315078967617
R1373 n_1_1_8 n_1_1_9 1.1979379616037358
R1374 n_1_1_9 n_2_1_9 62.271876093714546
R1375 n_1_1_9 n_1_2_9 1189.0315078967617
R1376 n_1_1_9 n_1_1_10 1.1979379616037358
R1377 n_1_1_10 n_2_1_10 62.271876093714546
R1378 n_1_1_10 n_1_2_10 1189.0315078967617
R1379 n_1_1_10 n_1_1_11 1.1979379616037282
R1380 n_1_1_11 n_2_1_11 62.271876093715335
R1381 n_1_1_11 n_1_2_11 1189.031507896777
R1382 n_1_1_11 n_1_1_12 1.1979379616037242
R1383 n_1_1_12 n_2_1_12 62.27187609371496
R1384 n_1_1_12 n_1_2_12 1189.0315078967692
R1385 n_1_1_12 n_1_1_13 1.1979379616037358
R1386 n_1_1_13 n_2_1_13 62.271876093714155
R1387 n_1_1_13 n_1_2_13 1189.0315078967542
R1388 n_1_1_13 n_1_1_14 5.989689808018694
R1389 n_1_1_14 n_2_1_14 6.919097343746046
R1390 n_1_1_14 n_1_2_14 132.11461198852882
R1391 n_1_1_14 n_1_1_15 185.08141506777935
R1392 n_1_1_15 n_2_1_15 2288.4914464439817
R1393 n_1_1_15 n_1_2_15 43696.90791520547
R1394 n_1_2_0 n_2_2_0 32.69273494920007
R1395 n_1_2_0 n_1_3_0 624.2415416457985
R1396 n_1_2_0 n_1_2_1 148.24482274846264
R1397 n_1_2_1 n_2_2_1 45.76982892888009
R1398 n_1_2_1 n_1_3_1 873.9381583041178
R1399 n_1_2_1 n_1_2_2 336.9200517010514
R1400 n_1_2_2 n_2_2_2 81.73183737300016
R1401 n_1_2_2 n_1_3_2 1560.6038541144962
R1402 n_1_2_2 n_1_2_3 315.3571683921841
R1403 n_1_2_3 n_2_2_3 1144.245723222001
R1404 n_1_2_3 n_1_3_3 21848.453957602927
R1405 n_1_2_3 n_1_2_4 4.192782865613088
R1406 n_1_2_4 n_2_2_4 34.67411282490913
R1407 n_1_2_4 n_1_3_4 662.0743623516038
R1408 n_1_2_4 n_1_2_5 3.465463388925103
R1409 n_1_2_5 n_2_2_5 217.95156632800018
R1410 n_1_2_5 n_1_3_5 4161.610277638653
R1411 n_1_2_5 n_1_2_6 1.1979379616037393
R1412 n_1_2_6 n_2_2_6 36.32526105466671
R1413 n_1_2_6 n_1_3_6 693.6017129397754
R1414 n_1_2_6 n_1_2_7 1.6257729478907874
R1415 n_1_2_7 n_2_2_7 62.271876093714546
R1416 n_1_2_7 n_1_3_7 1189.0315078967617
R1417 n_1_2_7 n_1_2_8 1.1979379616037358
R1418 n_1_2_8 n_2_2_8 62.271876093714546
R1419 n_1_2_8 n_1_3_8 1189.0315078967617
R1420 n_1_2_8 n_1_2_9 1.1979379616037358
R1421 n_1_2_9 n_2_2_9 62.271876093714546
R1422 n_1_2_9 n_1_3_9 1189.0315078967617
R1423 n_1_2_9 n_1_2_10 1.1979379616037358
R1424 n_1_2_10 n_2_2_10 62.271876093714546
R1425 n_1_2_10 n_1_3_10 1189.0315078967617
R1426 n_1_2_10 n_1_2_11 1.1979379616037282
R1427 n_1_2_11 n_2_2_11 62.271876093715335
R1428 n_1_2_11 n_1_3_11 1189.031507896777
R1429 n_1_2_11 n_1_2_12 1.1979379616037242
R1430 n_1_2_12 n_2_2_12 62.27187609371496
R1431 n_1_2_12 n_1_3_12 1189.0315078967692
R1432 n_1_2_12 n_1_2_13 1.1979379616037358
R1433 n_1_2_13 n_2_2_13 62.271876093714155
R1434 n_1_2_13 n_1_3_13 1189.0315078967542
R1435 n_1_2_13 n_1_2_14 5.989689808018694
R1436 n_1_2_14 n_2_2_14 6.919097343746046
R1437 n_1_2_14 n_1_3_14 132.11461198852882
R1438 n_1_2_14 n_1_2_15 185.08141506777935
R1439 n_1_2_15 n_2_2_15 2288.4914464439817
R1440 n_1_2_15 n_1_3_15 43696.90791520547
R1441 n_1_3_0 n_2_3_0 32.69273494920007
R1442 n_1_3_0 n_1_4_0 326.2736359366225
R1443 n_1_3_0 n_1_3_1 148.24482274846264
R1444 n_1_3_1 n_2_3_1 45.76982892888009
R1445 n_1_3_1 n_1_4_1 456.7830903112714
R1446 n_1_3_1 n_1_3_2 336.9200517010514
R1447 n_1_3_2 n_2_3_2 81.73183737300016
R1448 n_1_3_2 n_1_4_2 815.6840898415562
R1449 n_1_3_2 n_1_3_3 315.3571683921841
R1450 n_1_3_3 n_2_3_3 1144.245723222001
R1451 n_1_3_3 n_1_4_3 11419.577257781777
R1452 n_1_3_3 n_1_3_4 4.192782865613088
R1453 n_1_3_4 n_2_3_4 34.67411282490913
R1454 n_1_3_4 n_1_4_4 346.0477956903568
R1455 n_1_3_4 n_1_3_5 3.465463388925103
R1456 n_1_3_5 n_2_3_5 217.95156632800018
R1457 n_1_3_5 n_1_4_5 2175.157572910815
R1458 n_1_3_5 n_1_3_6 1.1979379616037393
R1459 n_1_3_6 n_2_3_6 36.32526105466671
R1460 n_1_3_6 n_1_4_6 362.5262621518024
R1461 n_1_3_6 n_1_3_7 1.6257729478907874
R1462 n_1_3_7 n_2_3_7 62.271876093714546
R1463 n_1_3_7 n_1_4_7 621.4735922602347
R1464 n_1_3_7 n_1_3_8 1.1979379616037358
R1465 n_1_3_8 n_2_3_8 62.271876093714546
R1466 n_1_3_8 n_1_4_8 621.4735922602347
R1467 n_1_3_8 n_1_3_9 1.1979379616037358
R1468 n_1_3_9 n_2_3_9 62.271876093714546
R1469 n_1_3_9 n_1_4_9 621.4735922602347
R1470 n_1_3_9 n_1_3_10 1.1979379616037358
R1471 n_1_3_10 n_2_3_10 62.271876093714546
R1472 n_1_3_10 n_1_4_10 621.4735922602347
R1473 n_1_3_10 n_1_3_11 1.1979379616037282
R1474 n_1_3_11 n_2_3_11 62.271876093715335
R1475 n_1_3_11 n_1_4_11 621.4735922602426
R1476 n_1_3_11 n_1_3_12 1.1979379616037242
R1477 n_1_3_12 n_2_3_12 62.27187609371496
R1478 n_1_3_12 n_1_4_12 621.4735922602385
R1479 n_1_3_12 n_1_3_13 1.1979379616037358
R1480 n_1_3_13 n_2_3_13 62.271876093714155
R1481 n_1_3_13 n_1_4_13 621.4735922602308
R1482 n_1_3_13 n_1_3_14 5.989689808018694
R1483 n_1_3_14 n_2_3_14 6.919097343746046
R1484 n_1_3_14 n_1_4_14 69.05262136224816
R1485 n_1_3_14 n_1_3_15 185.08141506777935
R1486 n_1_3_15 n_2_3_15 2288.4914464439817
R1487 n_1_3_15 n_1_4_15 22839.15451556335
R1488 n_1_4_0 n_2_4_0 720.9905238734129
R1489 n_1_4_0 n_1_5_0 28.305730227446713
R1490 n_1_4_0 n_1_4_1 3269.323064620219
R1491 n_1_4_1 n_2_4_1 1009.386733422778
R1492 n_1_4_1 n_1_5_1 39.628022318425394
R1493 n_1_4_1 n_1_4_2 7430.279692318681
R1494 n_1_4_2 n_2_4_2 1802.4763096835322
R1495 n_1_4_2 n_1_5_2 70.76432556861678
R1496 n_1_4_2 n_1_4_3 6954.741792010285
R1497 n_1_4_3 n_2_4_3 25234.668335569433
R1498 n_1_4_3 n_1_5_3 990.700557960634
R1499 n_1_4_3 n_1_4_4 92.46570283774366
R1500 n_1_4_4 n_2_4_4 764.6869192596797
R1501 n_1_4_4 n_1_5_4 30.02122902911012
R1502 n_1_4_4 n_1_4_5 76.42573397813507
R1503 n_1_4_5 n_2_4_5 4806.603492489416
R1504 n_1_4_5 n_1_5_5 188.70486818297792
R1505 n_1_4_5 n_1_4_6 26.418772239355334
R1506 n_1_4_6 n_2_4_6 801.1005820815692
R1507 n_1_4_6 n_1_5_6 31.45081136382965
R1508 n_1_4_6 n_1_4_7 35.854048039125054
R1509 n_1_4_7 n_2_4_7 1373.3152835684086
R1510 n_1_4_7 n_1_5_7 53.91567662370814
R1511 n_1_4_7 n_1_4_8 26.418772239355253
R1512 n_1_4_8 n_2_4_8 1373.3152835684086
R1513 n_1_4_8 n_1_5_8 53.91567662370814
R1514 n_1_4_8 n_1_4_9 26.418772239355253
R1515 n_1_4_9 n_2_4_9 1373.3152835684086
R1516 n_1_4_9 n_1_5_9 53.91567662370814
R1517 n_1_4_9 n_1_4_10 26.418772239355253
R1518 n_1_4_10 n_2_4_10 1373.3152835684086
R1519 n_1_4_10 n_1_5_10 53.91567662370814
R1520 n_1_4_10 n_1_4_11 26.418772239355086
R1521 n_1_4_11 n_2_4_11 1373.315283568426
R1522 n_1_4_11 n_1_5_11 53.91567662370883
R1523 n_1_4_11 n_1_4_12 26.418772239355
R1524 n_1_4_12 n_2_4_12 1373.3152835684173
R1525 n_1_4_12 n_1_5_12 53.915676623708485
R1526 n_1_4_12 n_1_4_13 26.41877223935525
R1527 n_1_4_13 n_2_4_13 1373.3152835684
R1528 n_1_4_13 n_1_5_13 53.9156766237078
R1529 n_1_4_13 n_1_4_14 132.0938611967766
R1530 n_1_4_14 n_2_4_14 152.5905870631562
R1531 n_1_4_14 n_1_5_14 5.990630735967559
R1532 n_1_4_14 n_1_4_15 4081.700310980434
R1533 n_1_4_15 n_2_4_15 50469.336671138415
R1534 n_1_4_15 n_1_5_15 1981.4011159212505
R1535 n_1_5_0 n_2_5_0 720.9905238734002
R1536 n_1_5_0 n_1_6_0 28.305730227446965
R1537 n_1_5_0 n_1_5_1 3269.323064620161
R1538 n_1_5_1 n_2_5_1 1009.38673342276
R1539 n_1_5_1 n_1_6_1 39.62802231842574
R1540 n_1_5_1 n_1_5_2 7430.279692318548
R1541 n_1_5_2 n_2_5_2 1802.4763096835004
R1542 n_1_5_2 n_1_6_2 70.76432556861741
R1543 n_1_5_2 n_1_5_3 6954.741792010161
R1544 n_1_5_3 n_2_5_3 25234.668335568982
R1545 n_1_5_3 n_1_6_3 990.7005579606428
R1546 n_1_5_3 n_1_5_4 92.46570283774201
R1547 n_1_5_4 n_2_5_4 764.6869192596661
R1548 n_1_5_4 n_1_6_4 30.021229029110387
R1549 n_1_5_4 n_1_5_5 76.4257339781337
R1550 n_1_5_5 n_2_5_5 4806.60349248933
R1551 n_1_5_5 n_1_6_5 188.7048681829796
R1552 n_1_5_5 n_1_5_6 26.418772239354865
R1553 n_1_5_6 n_2_5_6 801.1005820815549
R1554 n_1_5_6 n_1_6_6 31.45081136382993
R1555 n_1_5_6 n_1_5_7 35.85404803912442
R1556 n_1_5_7 n_2_5_7 1373.3152835683843
R1557 n_1_5_7 n_1_6_7 53.91567662370862
R1558 n_1_5_7 n_1_5_8 26.418772239354784
R1559 n_1_5_8 n_2_5_8 1373.3152835683843
R1560 n_1_5_8 n_1_6_8 53.91567662370862
R1561 n_1_5_8 n_1_5_9 26.418772239354784
R1562 n_1_5_9 n_2_5_9 1373.3152835683843
R1563 n_1_5_9 n_1_6_9 53.91567662370862
R1564 n_1_5_9 n_1_5_10 26.418772239354784
R1565 n_1_5_10 n_2_5_10 1373.3152835683843
R1566 n_1_5_10 n_1_6_10 53.91567662370862
R1567 n_1_5_10 n_1_5_11 26.418772239354617
R1568 n_1_5_11 n_2_5_11 1373.3152835684014
R1569 n_1_5_11 n_1_6_11 53.91567662370932
R1570 n_1_5_11 n_1_5_12 26.41877223935453
R1571 n_1_5_12 n_2_5_12 1373.3152835683927
R1572 n_1_5_12 n_1_6_12 53.91567662370896
R1573 n_1_5_12 n_1_5_13 26.41877223935478
R1574 n_1_5_13 n_2_5_13 1373.3152835683754
R1575 n_1_5_13 n_1_6_13 53.91567662370828
R1576 n_1_5_13 n_1_5_14 132.09386119677424
R1577 n_1_5_14 n_2_5_14 152.59058706315346
R1578 n_1_5_14 n_1_6_14 5.9906307359676125
R1579 n_1_5_14 n_1_5_15 4081.7003109803613
R1580 n_1_5_15 n_2_5_15 50469.33667113751
R1581 n_1_5_15 n_1_6_15 1981.4011159212682
R1582 n_1_6_0 n_2_6_0 720.9905238734002
R1583 n_1_6_0 n_1_7_0 28.305730227446713
R1584 n_1_6_0 n_1_6_1 3269.323064620161
R1585 n_1_6_1 n_2_6_1 1009.38673342276
R1586 n_1_6_1 n_1_7_1 39.628022318425394
R1587 n_1_6_1 n_1_6_2 7430.279692318548
R1588 n_1_6_2 n_2_6_2 1802.4763096835004
R1589 n_1_6_2 n_1_7_2 70.76432556861678
R1590 n_1_6_2 n_1_6_3 6954.741792010161
R1591 n_1_6_3 n_2_6_3 25234.668335568982
R1592 n_1_6_3 n_1_7_3 990.700557960634
R1593 n_1_6_3 n_1_6_4 92.46570283774201
R1594 n_1_6_4 n_2_6_4 764.6869192596661
R1595 n_1_6_4 n_1_7_4 30.02122902911012
R1596 n_1_6_4 n_1_6_5 76.4257339781337
R1597 n_1_6_5 n_2_6_5 4806.60349248933
R1598 n_1_6_5 n_1_7_5 188.70486818297792
R1599 n_1_6_5 n_1_6_6 26.418772239354865
R1600 n_1_6_6 n_2_6_6 801.1005820815549
R1601 n_1_6_6 n_1_7_6 31.45081136382965
R1602 n_1_6_6 n_1_6_7 35.85404803912442
R1603 n_1_6_7 n_2_6_7 1373.3152835683843
R1604 n_1_6_7 n_1_7_7 53.91567662370814
R1605 n_1_6_7 n_1_6_8 26.418772239354784
R1606 n_1_6_8 n_2_6_8 1373.3152835683843
R1607 n_1_6_8 n_1_7_8 53.91567662370814
R1608 n_1_6_8 n_1_6_9 26.418772239354784
R1609 n_1_6_9 n_2_6_9 1373.3152835683843
R1610 n_1_6_9 n_1_7_9 53.91567662370814
R1611 n_1_6_9 n_1_6_10 26.418772239354784
R1612 n_1_6_10 n_2_6_10 1373.3152835683843
R1613 n_1_6_10 n_1_7_10 53.91567662370814
R1614 n_1_6_10 n_1_6_11 26.418772239354617
R1615 n_1_6_11 n_2_6_11 1373.3152835684014
R1616 n_1_6_11 n_1_7_11 53.91567662370883
R1617 n_1_6_11 n_1_6_12 26.41877223935453
R1618 n_1_6_12 n_2_6_12 1373.3152835683927
R1619 n_1_6_12 n_1_7_12 53.915676623708485
R1620 n_1_6_12 n_1_6_13 26.41877223935478
R1621 n_1_6_13 n_2_6_13 1373.3152835683754
R1622 n_1_6_13 n_1_7_13 53.9156766237078
R1623 n_1_6_13 n_1_6_14 132.09386119677424
R1624 n_1_6_14 n_2_6_14 152.59058706315346
R1625 n_1_6_14 n_1_7_14 5.990630735967559
R1626 n_1_6_14 n_1_6_15 4081.7003109803613
R1627 n_1_6_15 n_2_6_15 50469.33667113751
R1628 n_1_6_15 n_1_7_15 1981.4011159212505
R1629 n_1_7_0 n_2_7_0 720.9905238734129
R1630 n_1_7_0 n_1_8_0 827.2137876682008
R1631 n_1_7_0 n_1_7_1 3269.323064620219
R1632 n_1_7_1 n_2_7_1 1009.386733422778
R1633 n_1_7_1 n_1_8_1 1158.099302735481
R1634 n_1_7_1 n_1_7_2 7430.279692318681
R1635 n_1_7_2 n_2_7_2 1802.4763096835322
R1636 n_1_7_2 n_1_8_2 2068.034469170502
R1637 n_1_7_2 n_1_7_3 6954.741792010285
R1638 n_1_7_3 n_2_7_3 25234.668335569433
R1639 n_1_7_3 n_1_8_3 28952.482568387
R1640 n_1_7_3 n_1_7_4 92.46570283774366
R1641 n_1_7_4 n_2_7_4 764.6869192596797
R1642 n_1_7_4 n_1_8_4 877.3479566177879
R1643 n_1_7_4 n_1_7_5 76.42573397813507
R1644 n_1_7_5 n_2_7_5 4806.603492489416
R1645 n_1_7_5 n_1_8_5 5514.758584454667
R1646 n_1_7_5 n_1_7_6 26.418772239355334
R1647 n_1_7_6 n_2_7_6 801.1005820815692
R1648 n_1_7_6 n_1_8_6 919.1264307424444
R1649 n_1_7_6 n_1_7_7 35.854048039125054
R1650 n_1_7_7 n_2_7_7 1373.3152835684086
R1651 n_1_7_7 n_1_8_7 1575.6453098441953
R1652 n_1_7_7 n_1_7_8 26.418772239355253
R1653 n_1_7_8 n_2_7_8 1373.3152835684086
R1654 n_1_7_8 n_1_8_8 1575.6453098441953
R1655 n_1_7_8 n_1_7_9 26.418772239355253
R1656 n_1_7_9 n_2_7_9 1373.3152835684086
R1657 n_1_7_9 n_1_8_9 1575.6453098441953
R1658 n_1_7_9 n_1_7_10 26.418772239355253
R1659 n_1_7_10 n_2_7_10 1373.3152835684086
R1660 n_1_7_10 n_1_8_10 1575.6453098441953
R1661 n_1_7_10 n_1_7_11 26.418772239355086
R1662 n_1_7_11 n_2_7_11 1373.315283568426
R1663 n_1_7_11 n_1_8_11 1575.6453098442157
R1664 n_1_7_11 n_1_7_12 26.418772239355
R1665 n_1_7_12 n_2_7_12 1373.3152835684173
R1666 n_1_7_12 n_1_8_12 1575.6453098442053
R1667 n_1_7_12 n_1_7_13 26.41877223935525
R1668 n_1_7_13 n_2_7_13 1373.3152835684
R1669 n_1_7_13 n_1_8_13 1575.6453098441855
R1670 n_1_7_13 n_1_7_14 132.0938611967766
R1671 n_1_7_14 n_2_7_14 152.5905870631562
R1672 n_1_7_14 n_1_8_14 175.07170109379913
R1673 n_1_7_14 n_1_7_15 4081.700310980434
R1674 n_1_7_15 n_2_7_15 50469.336671138415
R1675 n_1_7_15 n_1_8_15 57904.96513677349
R1676 n_1_8_0 n_2_8_0 12.550205463809336
R1677 n_1_8_0 n_1_9_0 1626.1218451089555
R1678 n_1_8_0 n_1_8_1 56.90875931090389
R1679 n_1_8_1 n_2_8_1 17.570287649333068
R1680 n_1_8_1 n_1_9_1 2276.5705831525374
R1681 n_1_8_1 n_1_8_2 129.33808934296337
R1682 n_1_8_2 n_2_8_2 31.375513659523335
R1683 n_1_8_2 n_1_9_2 4065.3046127723887
R1684 n_1_8_2 n_1_8_3 121.06045162501373
R1685 n_1_8_3 n_2_8_3 439.25719123332635
R1686 n_1_8_3 n_1_9_3 56914.26457881339
R1687 n_1_8_3 n_1_8_4 1.6095406673791013
R1688 n_1_8_4 n_2_8_4 13.310823976767466
R1689 n_1_8_4 n_1_9_4 1724.6746842064663
R1690 n_1_8_4 n_1_8_5 1.3303346332419101
R1691 n_1_8_5 n_2_8_5 83.6680364253955
R1692 n_1_8_5 n_1_9_5 10840.81230072636
R1693 n_1_8_5 n_1_8_6 0.4598687621083147
R1694 n_1_8_6 n_2_8_6 13.944672737565917
R1695 n_1_8_6 n_1_9_6 1806.80205012106
R1696 n_1_8_6 n_1_8_7 0.6241076057184264
R1697 n_1_8_7 n_2_8_7 23.905153264398788
R1698 n_1_8_7 n_1_9_7 3097.374943064684
R1699 n_1_8_7 n_1_8_8 0.45986876210831323
R1700 n_1_8_8 n_2_8_8 23.905153264398788
R1701 n_1_8_8 n_1_9_8 3097.374943064684
R1702 n_1_8_8 n_1_8_9 0.45986876210831323
R1703 n_1_8_9 n_2_8_9 23.905153264398788
R1704 n_1_8_9 n_1_9_9 3097.374943064684
R1705 n_1_8_9 n_1_8_10 0.45986876210831323
R1706 n_1_8_10 n_2_8_10 23.905153264398788
R1707 n_1_8_10 n_1_9_10 3097.374943064684
R1708 n_1_8_10 n_1_8_11 0.4598687621083103
R1709 n_1_8_11 n_2_8_11 23.905153264399093
R1710 n_1_8_11 n_1_9_11 3097.374943064724
R1711 n_1_8_11 n_1_8_12 0.45986876210830885
R1712 n_1_8_12 n_2_8_12 23.90515326439894
R1713 n_1_8_12 n_1_9_12 3097.374943064704
R1714 n_1_8_12 n_1_8_13 0.45986876210831323
R1715 n_1_8_13 n_2_8_13 23.905153264398635
R1716 n_1_8_13 n_1_9_13 3097.3749430646644
R1717 n_1_8_13 n_1_8_14 2.299343810541572
R1718 n_1_8_14 n_2_8_14 2.6561281404887485
R1719 n_1_8_14 n_1_9_14 344.1527714516309
R1720 n_1_8_14 n_1_8_15 71.04972374573522
R1721 n_1_8_15 n_2_8_15 878.5143824666449
R1722 n_1_8_15 n_1_9_15 113828.52915762577
R1723 n_1_9_0 n_2_9_0 12.550205463809325
R1724 n_1_9_0 n_1_10_0 1626.1218451089555
R1725 n_1_9_0 n_1_9_1 56.90875931090386
R1726 n_1_9_1 n_2_9_1 17.57028764933306
R1727 n_1_9_1 n_1_10_1 2276.5705831525374
R1728 n_1_9_1 n_1_9_2 129.3380893429633
R1729 n_1_9_2 n_2_9_2 31.375513659523318
R1730 n_1_9_2 n_1_10_2 4065.3046127723887
R1731 n_1_9_2 n_1_9_3 121.06045162501364
R1732 n_1_9_3 n_2_9_3 439.25719123332607
R1733 n_1_9_3 n_1_10_3 56914.26457881339
R1734 n_1_9_3 n_1_9_4 1.6095406673791004
R1735 n_1_9_4 n_2_9_4 13.310823976767455
R1736 n_1_9_4 n_1_10_4 1724.6746842064663
R1737 n_1_9_4 n_1_9_5 1.3303346332419095
R1738 n_1_9_5 n_2_9_5 83.66803642539543
R1739 n_1_9_5 n_1_10_5 10840.81230072636
R1740 n_1_9_5 n_1_9_6 0.4598687621083144
R1741 n_1_9_6 n_2_9_6 13.944672737565906
R1742 n_1_9_6 n_1_10_6 1806.80205012106
R1743 n_1_9_6 n_1_9_7 0.6241076057184259
R1744 n_1_9_7 n_2_9_7 23.90515326439877
R1745 n_1_9_7 n_1_10_7 3097.374943064684
R1746 n_1_9_7 n_1_9_8 0.4598687621083129
R1747 n_1_9_8 n_2_9_8 23.90515326439877
R1748 n_1_9_8 n_1_10_8 3097.374943064684
R1749 n_1_9_8 n_1_9_9 0.4598687621083129
R1750 n_1_9_9 n_2_9_9 23.90515326439877
R1751 n_1_9_9 n_1_10_9 3097.374943064684
R1752 n_1_9_9 n_1_9_10 0.4598687621083129
R1753 n_1_9_10 n_2_9_10 23.90515326439877
R1754 n_1_9_10 n_1_10_10 3097.374943064684
R1755 n_1_9_10 n_1_9_11 0.45986876210830996
R1756 n_1_9_11 n_2_9_11 23.905153264399075
R1757 n_1_9_11 n_1_10_11 3097.374943064724
R1758 n_1_9_11 n_1_9_12 0.4598687621083085
R1759 n_1_9_12 n_2_9_12 23.905153264398926
R1760 n_1_9_12 n_1_10_12 3097.374943064704
R1761 n_1_9_12 n_1_9_13 0.4598687621083129
R1762 n_1_9_13 n_2_9_13 23.90515326439862
R1763 n_1_9_13 n_1_10_13 3097.3749430646644
R1764 n_1_9_13 n_1_9_14 2.2993438105415707
R1765 n_1_9_14 n_2_9_14 2.6561281404887467
R1766 n_1_9_14 n_1_10_14 344.1527714516309
R1767 n_1_9_14 n_1_9_15 71.04972374573518
R1768 n_1_9_15 n_2_9_15 878.5143824666444
R1769 n_1_9_15 n_1_10_15 113828.52915762577
R1770 n_1_10_0 n_2_10_0 12.550205463809336
R1771 n_1_10_0 n_1_11_0 1626.121845108955
R1772 n_1_10_0 n_1_10_1 56.90875931090389
R1773 n_1_10_1 n_2_10_1 17.570287649333068
R1774 n_1_10_1 n_1_11_1 2276.570583152537
R1775 n_1_10_1 n_1_10_2 129.33808934296337
R1776 n_1_10_2 n_2_10_2 31.375513659523335
R1777 n_1_10_2 n_1_11_2 4065.3046127723874
R1778 n_1_10_2 n_1_10_3 121.06045162501373
R1779 n_1_10_3 n_2_10_3 439.25719123332635
R1780 n_1_10_3 n_1_11_3 56914.264578813374
R1781 n_1_10_3 n_1_10_4 1.6095406673791013
R1782 n_1_10_4 n_2_10_4 13.310823976767466
R1783 n_1_10_4 n_1_11_4 1724.6746842064658
R1784 n_1_10_4 n_1_10_5 1.3303346332419101
R1785 n_1_10_5 n_2_10_5 83.6680364253955
R1786 n_1_10_5 n_1_11_5 10840.812300726357
R1787 n_1_10_5 n_1_10_6 0.4598687621083147
R1788 n_1_10_6 n_2_10_6 13.944672737565917
R1789 n_1_10_6 n_1_11_6 1806.8020501210594
R1790 n_1_10_6 n_1_10_7 0.6241076057184264
R1791 n_1_10_7 n_2_10_7 23.905153264398788
R1792 n_1_10_7 n_1_11_7 3097.374943064683
R1793 n_1_10_7 n_1_10_8 0.45986876210831323
R1794 n_1_10_8 n_2_10_8 23.905153264398788
R1795 n_1_10_8 n_1_11_8 3097.374943064683
R1796 n_1_10_8 n_1_10_9 0.45986876210831323
R1797 n_1_10_9 n_2_10_9 23.905153264398788
R1798 n_1_10_9 n_1_11_9 3097.374943064683
R1799 n_1_10_9 n_1_10_10 0.45986876210831323
R1800 n_1_10_10 n_2_10_10 23.905153264398788
R1801 n_1_10_10 n_1_11_10 3097.374943064683
R1802 n_1_10_10 n_1_10_11 0.4598687621083103
R1803 n_1_10_11 n_2_10_11 23.905153264399093
R1804 n_1_10_11 n_1_11_11 3097.374943064723
R1805 n_1_10_11 n_1_10_12 0.45986876210830885
R1806 n_1_10_12 n_2_10_12 23.90515326439894
R1807 n_1_10_12 n_1_11_12 3097.3749430647026
R1808 n_1_10_12 n_1_10_13 0.45986876210831323
R1809 n_1_10_13 n_2_10_13 23.905153264398635
R1810 n_1_10_13 n_1_11_13 3097.3749430646635
R1811 n_1_10_13 n_1_10_14 2.299343810541572
R1812 n_1_10_14 n_2_10_14 2.6561281404887485
R1813 n_1_10_14 n_1_11_14 344.15277145163077
R1814 n_1_10_14 n_1_10_15 71.04972374573522
R1815 n_1_10_15 n_2_10_15 878.5143824666449
R1816 n_1_10_15 n_1_11_15 113828.52915762574
R1817 n_1_11_0 n_2_11_0 12.550205463809336
R1818 n_1_11_0 n_1_12_0 827.2138119611458
R1819 n_1_11_0 n_1_11_1 56.90875931090389
R1820 n_1_11_1 n_2_11_1 17.570287649333068
R1821 n_1_11_1 n_1_12_1 1158.099336745604
R1822 n_1_11_1 n_1_11_2 129.33808934296337
R1823 n_1_11_2 n_2_11_2 31.375513659523335
R1824 n_1_11_2 n_1_12_2 2068.0345299028645
R1825 n_1_11_2 n_1_11_3 121.06045162501373
R1826 n_1_11_3 n_2_11_3 439.25719123332635
R1827 n_1_11_3 n_1_12_3 28952.483418640077
R1828 n_1_11_3 n_1_11_4 1.6095406673791013
R1829 n_1_11_4 n_2_11_4 13.310823976767466
R1830 n_1_11_4 n_1_12_4 877.3479823830326
R1831 n_1_11_4 n_1_11_5 1.3303346332419101
R1832 n_1_11_5 n_2_11_5 83.6680364253955
R1833 n_1_11_5 n_1_12_5 5514.758746407633
R1834 n_1_11_5 n_1_11_6 0.4598687621083147
R1835 n_1_11_6 n_2_11_6 13.944672737565917
R1836 n_1_11_6 n_1_12_6 919.1264577346055
R1837 n_1_11_6 n_1_11_7 0.6241076057184264
R1838 n_1_11_7 n_2_11_7 23.905153264398788
R1839 n_1_11_7 n_1_12_7 1575.6453561164717
R1840 n_1_11_7 n_1_11_8 0.45986876210831323
R1841 n_1_11_8 n_2_11_8 23.905153264398788
R1842 n_1_11_8 n_1_12_8 1575.6453561164717
R1843 n_1_11_8 n_1_11_9 0.45986876210831323
R1844 n_1_11_9 n_2_11_9 23.905153264398788
R1845 n_1_11_9 n_1_12_9 1575.6453561164717
R1846 n_1_11_9 n_1_11_10 0.45986876210831323
R1847 n_1_11_10 n_2_11_10 23.905153264398788
R1848 n_1_11_10 n_1_12_10 1575.6453561164717
R1849 n_1_11_10 n_1_11_11 0.4598687621083103
R1850 n_1_11_11 n_2_11_11 23.905153264399093
R1851 n_1_11_11 n_1_12_11 1575.645356116492
R1852 n_1_11_11 n_1_11_12 0.45986876210830885
R1853 n_1_11_12 n_2_11_12 23.90515326439894
R1854 n_1_11_12 n_1_12_12 1575.6453561164817
R1855 n_1_11_12 n_1_11_13 0.45986876210831323
R1856 n_1_11_13 n_2_11_13 23.905153264398635
R1857 n_1_11_13 n_1_12_13 1575.6453561164617
R1858 n_1_11_13 n_1_11_14 2.299343810541572
R1859 n_1_11_14 n_2_11_14 2.6561281404887485
R1860 n_1_11_14 n_1_12_14 175.07170623516316
R1861 n_1_11_14 n_1_11_15 71.04972374573522
R1862 n_1_11_15 n_2_11_15 878.5143824666449
R1863 n_1_11_15 n_1_12_15 57904.966837279644
R1864 n_1_12_0 n_2_12_0 720.989286318121
R1865 n_1_12_0 n_1_13_0 28.305778813336566
R1866 n_1_12_0 n_1_12_1 3269.3174529402795
R1867 n_1_12_1 n_2_12_1 1009.3850008453695
R1868 n_1_12_1 n_1_13_1 39.62809033867119
R1869 n_1_12_1 n_1_12_2 7430.266938500637
R1870 n_1_12_2 n_2_12_2 1802.4732157953028
R1871 n_1_12_2 n_1_13_2 70.76444703334141
R1872 n_1_12_2 n_1_12_3 6954.729854436596
R1873 n_1_12_3 n_2_12_3 25234.625021134212
R1874 n_1_12_3 n_1_13_3 990.7022584667789
R1875 n_1_12_3 n_1_12_4 92.46554412356356
R1876 n_1_12_4 n_2_12_4 764.6856067010369
R1877 n_1_12_4 n_1_13_4 30.02128055959936
R1878 n_1_12_4 n_1_12_5 76.42560279600661
R1879 n_1_12_5 n_2_12_5 4806.595242120802
R1880 n_1_12_5 n_1_13_5 188.70519208891028
R1881 n_1_12_5 n_1_12_6 26.418726892446728
R1882 n_1_12_6 n_2_12_6 801.0992070201339
R1883 n_1_12_6 n_1_13_6 31.450865348151712
R1884 n_1_12_6 n_1_12_7 35.85398649689195
R1885 n_1_12_7 n_2_12_7 1373.3129263202336
R1886 n_1_12_7 n_1_13_7 53.91576916826025
R1887 n_1_12_7 n_1_12_8 26.418726892446646
R1888 n_1_12_8 n_2_12_8 1373.3129263202336
R1889 n_1_12_8 n_1_13_8 53.91576916826025
R1890 n_1_12_8 n_1_12_9 26.418726892446646
R1891 n_1_12_9 n_2_12_9 1373.3129263202336
R1892 n_1_12_9 n_1_13_9 53.91576916826025
R1893 n_1_12_9 n_1_12_10 26.418726892446646
R1894 n_1_12_10 n_2_12_10 1373.3129263202336
R1895 n_1_12_10 n_1_13_10 53.91576916826025
R1896 n_1_12_10 n_1_12_11 26.41872689244648
R1897 n_1_12_11 n_2_12_11 1373.312926320251
R1898 n_1_12_11 n_1_13_11 53.915769168260944
R1899 n_1_12_11 n_1_12_12 26.418726892446394
R1900 n_1_12_12 n_2_12_12 1373.3129263202422
R1901 n_1_12_12 n_1_13_12 53.91576916826059
R1902 n_1_12_12 n_1_12_13 26.41872689244665
R1903 n_1_12_13 n_2_12_13 1373.312926320225
R1904 n_1_12_13 n_1_13_13 53.91576916825991
R1905 n_1_12_13 n_1_12_14 132.09363446223358
R1906 n_1_12_14 n_2_12_14 152.5903251466923
R1907 n_1_12_14 n_1_13_14 5.9906410186955705
R1908 n_1_12_14 n_1_12_15 4081.693304883055
R1909 n_1_12_15 n_2_12_15 50469.25004226799
R1910 n_1_12_15 n_1_13_15 1981.4045169335404
R1911 n_1_13_0 n_2_13_0 720.989286318121
R1912 n_1_13_0 n_1_14_0 28.305778813336566
R1913 n_1_13_0 n_1_13_1 3269.3174529402795
R1914 n_1_13_1 n_2_13_1 1009.3850008453695
R1915 n_1_13_1 n_1_14_1 39.62809033867119
R1916 n_1_13_1 n_1_13_2 7430.266938500637
R1917 n_1_13_2 n_2_13_2 1802.4732157953028
R1918 n_1_13_2 n_1_14_2 70.76444703334141
R1919 n_1_13_2 n_1_13_3 6954.729854436596
R1920 n_1_13_3 n_2_13_3 25234.625021134212
R1921 n_1_13_3 n_1_14_3 990.7022584667789
R1922 n_1_13_3 n_1_13_4 92.46554412356356
R1923 n_1_13_4 n_2_13_4 764.6856067010369
R1924 n_1_13_4 n_1_14_4 30.02128055959936
R1925 n_1_13_4 n_1_13_5 76.42560279600661
R1926 n_1_13_5 n_2_13_5 4806.595242120802
R1927 n_1_13_5 n_1_14_5 188.70519208891028
R1928 n_1_13_5 n_1_13_6 26.418726892446728
R1929 n_1_13_6 n_2_13_6 801.0992070201339
R1930 n_1_13_6 n_1_14_6 31.450865348151712
R1931 n_1_13_6 n_1_13_7 35.85398649689195
R1932 n_1_13_7 n_2_13_7 1373.3129263202336
R1933 n_1_13_7 n_1_14_7 53.91576916826025
R1934 n_1_13_7 n_1_13_8 26.418726892446646
R1935 n_1_13_8 n_2_13_8 1373.3129263202336
R1936 n_1_13_8 n_1_14_8 53.91576916826025
R1937 n_1_13_8 n_1_13_9 26.418726892446646
R1938 n_1_13_9 n_2_13_9 1373.3129263202336
R1939 n_1_13_9 n_1_14_9 53.91576916826025
R1940 n_1_13_9 n_1_13_10 26.418726892446646
R1941 n_1_13_10 n_2_13_10 1373.3129263202336
R1942 n_1_13_10 n_1_14_10 53.91576916826025
R1943 n_1_13_10 n_1_13_11 26.41872689244648
R1944 n_1_13_11 n_2_13_11 1373.312926320251
R1945 n_1_13_11 n_1_14_11 53.915769168260944
R1946 n_1_13_11 n_1_13_12 26.418726892446394
R1947 n_1_13_12 n_2_13_12 1373.3129263202422
R1948 n_1_13_12 n_1_14_12 53.91576916826059
R1949 n_1_13_12 n_1_13_13 26.41872689244665
R1950 n_1_13_13 n_2_13_13 1373.312926320225
R1951 n_1_13_13 n_1_14_13 53.91576916825991
R1952 n_1_13_13 n_1_13_14 132.09363446223358
R1953 n_1_13_14 n_2_13_14 152.5903251466923
R1954 n_1_13_14 n_1_14_14 5.9906410186955705
R1955 n_1_13_14 n_1_13_15 4081.693304883055
R1956 n_1_13_15 n_2_13_15 50469.25004226799
R1957 n_1_13_15 n_1_14_15 1981.4045169335404
R1958 n_1_14_0 n_2_14_0 720.989286318121
R1959 n_1_14_0 n_1_15_0 28.305778813336566
R1960 n_1_14_0 n_1_14_1 3269.3174529402795
R1961 n_1_14_1 n_2_14_1 1009.3850008453695
R1962 n_1_14_1 n_1_15_1 39.62809033867119
R1963 n_1_14_1 n_1_14_2 7430.266938500637
R1964 n_1_14_2 n_2_14_2 1802.4732157953028
R1965 n_1_14_2 n_1_15_2 70.76444703334141
R1966 n_1_14_2 n_1_14_3 6954.729854436596
R1967 n_1_14_3 n_2_14_3 25234.625021134212
R1968 n_1_14_3 n_1_15_3 990.7022584667789
R1969 n_1_14_3 n_1_14_4 92.46554412356356
R1970 n_1_14_4 n_2_14_4 764.6856067010369
R1971 n_1_14_4 n_1_15_4 30.02128055959936
R1972 n_1_14_4 n_1_14_5 76.42560279600661
R1973 n_1_14_5 n_2_14_5 4806.595242120802
R1974 n_1_14_5 n_1_15_5 188.70519208891028
R1975 n_1_14_5 n_1_14_6 26.418726892446728
R1976 n_1_14_6 n_2_14_6 801.0992070201339
R1977 n_1_14_6 n_1_15_6 31.450865348151712
R1978 n_1_14_6 n_1_14_7 35.85398649689195
R1979 n_1_14_7 n_2_14_7 1373.3129263202336
R1980 n_1_14_7 n_1_15_7 53.91576916826025
R1981 n_1_14_7 n_1_14_8 26.418726892446646
R1982 n_1_14_8 n_2_14_8 1373.3129263202336
R1983 n_1_14_8 n_1_15_8 53.91576916826025
R1984 n_1_14_8 n_1_14_9 26.418726892446646
R1985 n_1_14_9 n_2_14_9 1373.3129263202336
R1986 n_1_14_9 n_1_15_9 53.91576916826025
R1987 n_1_14_9 n_1_14_10 26.418726892446646
R1988 n_1_14_10 n_2_14_10 1373.3129263202336
R1989 n_1_14_10 n_1_15_10 53.91576916826025
R1990 n_1_14_10 n_1_14_11 26.41872689244648
R1991 n_1_14_11 n_2_14_11 1373.312926320251
R1992 n_1_14_11 n_1_15_11 53.915769168260944
R1993 n_1_14_11 n_1_14_12 26.418726892446394
R1994 n_1_14_12 n_2_14_12 1373.3129263202422
R1995 n_1_14_12 n_1_15_12 53.91576916826059
R1996 n_1_14_12 n_1_14_13 26.41872689244665
R1997 n_1_14_13 n_2_14_13 1373.312926320225
R1998 n_1_14_13 n_1_15_13 53.91576916825991
R1999 n_1_14_13 n_1_14_14 132.09363446223358
R2000 n_1_14_14 n_2_14_14 152.5903251466923
R2001 n_1_14_14 n_1_15_14 5.9906410186955705
R2002 n_1_14_14 n_1_14_15 4081.693304883055
R2003 n_1_14_15 n_2_14_15 50469.25004226799
R2004 n_1_14_15 n_1_15_15 1981.4045169335404
R2005 n_1_15_0 n_2_15_0 720.989286318121
R2006 n_1_15_0 n_1_16_0 827.2138119611453
R2007 n_1_15_0 n_1_15_1 3269.3174529402795
R2008 n_1_15_1 n_2_15_1 1009.3850008453695
R2009 n_1_15_1 n_1_16_1 1158.0993367456033
R2010 n_1_15_1 n_1_15_2 7430.266938500637
R2011 n_1_15_2 n_2_15_2 1802.4732157953028
R2012 n_1_15_2 n_1_16_2 2068.034529902863
R2013 n_1_15_2 n_1_15_3 6954.729854436596
R2014 n_1_15_3 n_2_15_3 25234.625021134212
R2015 n_1_15_3 n_1_16_3 28952.48341864006
R2016 n_1_15_3 n_1_15_4 92.46554412356356
R2017 n_1_15_4 n_2_15_4 764.6856067010369
R2018 n_1_15_4 n_1_16_4 877.347982383032
R2019 n_1_15_4 n_1_15_5 76.42560279600661
R2020 n_1_15_5 n_2_15_5 4806.595242120802
R2021 n_1_15_5 n_1_16_5 5514.7587464076305
R2022 n_1_15_5 n_1_15_6 26.418726892446728
R2023 n_1_15_6 n_2_15_6 801.0992070201339
R2024 n_1_15_6 n_1_16_6 919.126457734605
R2025 n_1_15_6 n_1_15_7 35.85398649689195
R2026 n_1_15_7 n_2_15_7 1373.3129263202336
R2027 n_1_15_7 n_1_16_7 1575.6453561164708
R2028 n_1_15_7 n_1_15_8 26.418726892446646
R2029 n_1_15_8 n_2_15_8 1373.3129263202336
R2030 n_1_15_8 n_1_16_8 1575.6453561164708
R2031 n_1_15_8 n_1_15_9 26.418726892446646
R2032 n_1_15_9 n_2_15_9 1373.3129263202336
R2033 n_1_15_9 n_1_16_9 1575.6453561164708
R2034 n_1_15_9 n_1_15_10 26.418726892446646
R2035 n_1_15_10 n_2_15_10 1373.3129263202336
R2036 n_1_15_10 n_1_16_10 1575.6453561164708
R2037 n_1_15_10 n_1_15_11 26.41872689244648
R2038 n_1_15_11 n_2_15_11 1373.312926320251
R2039 n_1_15_11 n_1_16_11 1575.645356116491
R2040 n_1_15_11 n_1_15_12 26.418726892446394
R2041 n_1_15_12 n_2_15_12 1373.3129263202422
R2042 n_1_15_12 n_1_16_12 1575.6453561164808
R2043 n_1_15_12 n_1_15_13 26.41872689244665
R2044 n_1_15_13 n_2_15_13 1373.312926320225
R2045 n_1_15_13 n_1_16_13 1575.6453561164608
R2046 n_1_15_13 n_1_15_14 132.09363446223358
R2047 n_1_15_14 n_2_15_14 152.5903251466923
R2048 n_1_15_14 n_1_16_14 175.07170623516305
R2049 n_1_15_14 n_1_15_15 4081.693304883055
R2050 n_1_15_15 n_2_15_15 50469.25004226799
R2051 n_1_15_15 n_1_16_15 57904.96683727961
R2052 n_1_16_0 n_2_16_0 12.550205463809345
R2053 n_1_16_0 n_1_17_0 1626.121845108955
R2054 n_1_16_0 n_1_16_1 56.908759310903925
R2055 n_1_16_1 n_2_16_1 17.570287649333075
R2056 n_1_16_1 n_1_17_1 2276.570583152537
R2057 n_1_16_1 n_1_16_2 129.33808934296346
R2058 n_1_16_2 n_2_16_2 31.375513659523357
R2059 n_1_16_2 n_1_17_2 4065.3046127723874
R2060 n_1_16_2 n_1_16_3 121.0604516250138
R2061 n_1_16_3 n_2_16_3 439.2571912333266
R2062 n_1_16_3 n_1_17_3 56914.26457881337
R2063 n_1_16_3 n_1_16_4 1.6095406673791026
R2064 n_1_16_4 n_2_16_4 13.31082397676747
R2065 n_1_16_4 n_1_17_4 1724.6746842064658
R2066 n_1_16_4 n_1_16_5 1.3303346332419115
R2067 n_1_16_5 n_2_16_5 83.66803642539554
R2068 n_1_16_5 n_1_17_5 10840.812300726357
R2069 n_1_16_5 n_1_16_6 0.4598687621083149
R2070 n_1_16_6 n_2_16_6 13.944672737565924
R2071 n_1_16_6 n_1_17_6 1806.8020501210594
R2072 n_1_16_6 n_1_16_7 0.6241076057184266
R2073 n_1_16_7 n_2_16_7 23.9051532643988
R2074 n_1_16_7 n_1_17_7 3097.374943064683
R2075 n_1_16_7 n_1_16_8 0.45986876210831346
R2076 n_1_16_8 n_2_16_8 23.9051532643988
R2077 n_1_16_8 n_1_17_8 3097.374943064683
R2078 n_1_16_8 n_1_16_9 0.45986876210831346
R2079 n_1_16_9 n_2_16_9 23.9051532643988
R2080 n_1_16_9 n_1_17_9 3097.374943064683
R2081 n_1_16_9 n_1_16_10 0.45986876210831346
R2082 n_1_16_10 n_2_16_10 23.9051532643988
R2083 n_1_16_10 n_1_17_10 3097.374943064683
R2084 n_1_16_10 n_1_16_11 0.4598687621083105
R2085 n_1_16_11 n_2_16_11 23.905153264399104
R2086 n_1_16_11 n_1_17_11 3097.374943064723
R2087 n_1_16_11 n_1_16_12 0.45986876210830907
R2088 n_1_16_12 n_2_16_12 23.90515326439895
R2089 n_1_16_12 n_1_17_12 3097.374943064703
R2090 n_1_16_12 n_1_16_13 0.45986876210831346
R2091 n_1_16_13 n_2_16_13 23.90515326439865
R2092 n_1_16_13 n_1_17_13 3097.3749430646635
R2093 n_1_16_13 n_1_16_14 2.299343810541573
R2094 n_1_16_14 n_2_16_14 2.6561281404887502
R2095 n_1_16_14 n_1_17_14 344.15277145163077
R2096 n_1_16_14 n_1_16_15 71.04972374573526
R2097 n_1_16_15 n_2_16_15 878.5143824666453
R2098 n_1_16_15 n_1_17_15 113828.52915762574
R2099 n_1_17_0 n_2_17_0 12.550205463809325
R2100 n_1_17_0 n_1_18_0 1626.121845108956
R2101 n_1_17_0 n_1_17_1 56.90875931090386
R2102 n_1_17_1 n_2_17_1 17.57028764933306
R2103 n_1_17_1 n_1_18_1 2276.5705831525383
R2104 n_1_17_1 n_1_17_2 129.3380893429633
R2105 n_1_17_2 n_2_17_2 31.375513659523318
R2106 n_1_17_2 n_1_18_2 4065.30461277239
R2107 n_1_17_2 n_1_17_3 121.06045162501364
R2108 n_1_17_3 n_2_17_3 439.25719123332607
R2109 n_1_17_3 n_1_18_3 56914.2645788134
R2110 n_1_17_3 n_1_17_4 1.6095406673791004
R2111 n_1_17_4 n_2_17_4 13.310823976767455
R2112 n_1_17_4 n_1_18_4 1724.6746842064667
R2113 n_1_17_4 n_1_17_5 1.3303346332419095
R2114 n_1_17_5 n_2_17_5 83.66803642539543
R2115 n_1_17_5 n_1_18_5 10840.812300726364
R2116 n_1_17_5 n_1_17_6 0.4598687621083144
R2117 n_1_17_6 n_2_17_6 13.944672737565906
R2118 n_1_17_6 n_1_18_6 1806.8020501210606
R2119 n_1_17_6 n_1_17_7 0.6241076057184259
R2120 n_1_17_7 n_2_17_7 23.90515326439877
R2121 n_1_17_7 n_1_18_7 3097.374943064685
R2122 n_1_17_7 n_1_17_8 0.4598687621083129
R2123 n_1_17_8 n_2_17_8 23.90515326439877
R2124 n_1_17_8 n_1_18_8 3097.374943064685
R2125 n_1_17_8 n_1_17_9 0.4598687621083129
R2126 n_1_17_9 n_2_17_9 23.90515326439877
R2127 n_1_17_9 n_1_18_9 3097.374943064685
R2128 n_1_17_9 n_1_17_10 0.4598687621083129
R2129 n_1_17_10 n_2_17_10 23.90515326439877
R2130 n_1_17_10 n_1_18_10 3097.374943064685
R2131 n_1_17_10 n_1_17_11 0.45986876210830996
R2132 n_1_17_11 n_2_17_11 23.905153264399075
R2133 n_1_17_11 n_1_18_11 3097.374943064725
R2134 n_1_17_11 n_1_17_12 0.4598687621083085
R2135 n_1_17_12 n_2_17_12 23.905153264398926
R2136 n_1_17_12 n_1_18_12 3097.374943064705
R2137 n_1_17_12 n_1_17_13 0.4598687621083129
R2138 n_1_17_13 n_2_17_13 23.90515326439862
R2139 n_1_17_13 n_1_18_13 3097.3749430646653
R2140 n_1_17_13 n_1_17_14 2.2993438105415707
R2141 n_1_17_14 n_2_17_14 2.6561281404887467
R2142 n_1_17_14 n_1_18_14 344.15277145163094
R2143 n_1_17_14 n_1_17_15 71.04972374573518
R2144 n_1_17_15 n_2_17_15 878.5143824666444
R2145 n_1_17_15 n_1_18_15 113828.52915762582
R2146 n_1_18_0 n_2_18_0 12.550205463809325
R2147 n_1_18_0 n_1_19_0 1626.121845108955
R2148 n_1_18_0 n_1_18_1 56.90875931090386
R2149 n_1_18_1 n_2_18_1 17.57028764933306
R2150 n_1_18_1 n_1_19_1 2276.570583152537
R2151 n_1_18_1 n_1_18_2 129.3380893429633
R2152 n_1_18_2 n_2_18_2 31.375513659523318
R2153 n_1_18_2 n_1_19_2 4065.3046127723874
R2154 n_1_18_2 n_1_18_3 121.06045162501364
R2155 n_1_18_3 n_2_18_3 439.25719123332607
R2156 n_1_18_3 n_1_19_3 56914.26457881337
R2157 n_1_18_3 n_1_18_4 1.6095406673791004
R2158 n_1_18_4 n_2_18_4 13.310823976767455
R2159 n_1_18_4 n_1_19_4 1724.6746842064658
R2160 n_1_18_4 n_1_18_5 1.3303346332419095
R2161 n_1_18_5 n_2_18_5 83.66803642539543
R2162 n_1_18_5 n_1_19_5 10840.812300726357
R2163 n_1_18_5 n_1_18_6 0.4598687621083144
R2164 n_1_18_6 n_2_18_6 13.944672737565906
R2165 n_1_18_6 n_1_19_6 1806.8020501210594
R2166 n_1_18_6 n_1_18_7 0.6241076057184259
R2167 n_1_18_7 n_2_18_7 23.90515326439877
R2168 n_1_18_7 n_1_19_7 3097.374943064683
R2169 n_1_18_7 n_1_18_8 0.4598687621083129
R2170 n_1_18_8 n_2_18_8 23.90515326439877
R2171 n_1_18_8 n_1_19_8 3097.374943064683
R2172 n_1_18_8 n_1_18_9 0.4598687621083129
R2173 n_1_18_9 n_2_18_9 23.90515326439877
R2174 n_1_18_9 n_1_19_9 3097.374943064683
R2175 n_1_18_9 n_1_18_10 0.4598687621083129
R2176 n_1_18_10 n_2_18_10 23.90515326439877
R2177 n_1_18_10 n_1_19_10 3097.374943064683
R2178 n_1_18_10 n_1_18_11 0.45986876210830996
R2179 n_1_18_11 n_2_18_11 23.905153264399075
R2180 n_1_18_11 n_1_19_11 3097.374943064723
R2181 n_1_18_11 n_1_18_12 0.4598687621083085
R2182 n_1_18_12 n_2_18_12 23.905153264398926
R2183 n_1_18_12 n_1_19_12 3097.374943064703
R2184 n_1_18_12 n_1_18_13 0.4598687621083129
R2185 n_1_18_13 n_2_18_13 23.90515326439862
R2186 n_1_18_13 n_1_19_13 3097.3749430646635
R2187 n_1_18_13 n_1_18_14 2.2993438105415707
R2188 n_1_18_14 n_2_18_14 2.6561281404887467
R2189 n_1_18_14 n_1_19_14 344.15277145163077
R2190 n_1_18_14 n_1_18_15 71.04972374573518
R2191 n_1_18_15 n_2_18_15 878.5143824666444
R2192 n_1_18_15 n_1_19_15 113828.52915762574
R2193 n_1_19_0 n_2_19_0 12.550205463809345
R2194 n_1_19_0 n_1_20_0 827.2138145479915
R2195 n_1_19_0 n_1_19_1 56.908759310903925
R2196 n_1_19_1 n_2_19_1 17.570287649333075
R2197 n_1_19_1 n_1_20_1 1158.099340367188
R2198 n_1_19_1 n_1_19_2 129.33808934296346
R2199 n_1_19_2 n_2_19_2 31.375513659523357
R2200 n_1_19_2 n_1_20_2 2068.034536369979
R2201 n_1_19_2 n_1_19_3 121.0604516250138
R2202 n_1_19_3 n_2_19_3 439.2571912333266
R2203 n_1_19_3 n_1_20_3 28952.483509179674
R2204 n_1_19_3 n_1_19_4 1.6095406673791026
R2205 n_1_19_4 n_2_19_4 13.31082397676747
R2206 n_1_19_4 n_1_20_4 877.3479851266568
R2207 n_1_19_4 n_1_19_5 1.3303346332419115
R2208 n_1_19_5 n_2_19_5 83.66803642539554
R2209 n_1_19_5 n_1_20_5 5514.758763653272
R2210 n_1_19_5 n_1_19_6 0.4598687621083149
R2211 n_1_19_6 n_2_19_6 13.944672737565924
R2212 n_1_19_6 n_1_20_6 919.1264606088786
R2213 n_1_19_6 n_1_19_7 0.6241076057184266
R2214 n_1_19_7 n_2_19_7 23.9051532643988
R2215 n_1_19_7 n_1_20_7 1575.6453610437968
R2216 n_1_19_7 n_1_19_8 0.45986876210831346
R2217 n_1_19_8 n_2_19_8 23.9051532643988
R2218 n_1_19_8 n_1_20_8 1575.6453610437968
R2219 n_1_19_8 n_1_19_9 0.45986876210831346
R2220 n_1_19_9 n_2_19_9 23.9051532643988
R2221 n_1_19_9 n_1_20_9 1575.6453610437968
R2222 n_1_19_9 n_1_19_10 0.45986876210831346
R2223 n_1_19_10 n_2_19_10 23.9051532643988
R2224 n_1_19_10 n_1_20_10 1575.6453610437968
R2225 n_1_19_10 n_1_19_11 0.4598687621083105
R2226 n_1_19_11 n_2_19_11 23.905153264399104
R2227 n_1_19_11 n_1_20_11 1575.6453610438173
R2228 n_1_19_11 n_1_19_12 0.45986876210830907
R2229 n_1_19_12 n_2_19_12 23.90515326439895
R2230 n_1_19_12 n_1_20_12 1575.6453610438068
R2231 n_1_19_12 n_1_19_13 0.45986876210831346
R2232 n_1_19_13 n_2_19_13 23.90515326439865
R2233 n_1_19_13 n_1_20_13 1575.6453610437868
R2234 n_1_19_13 n_1_19_14 2.299343810541573
R2235 n_1_19_14 n_2_19_14 2.6561281404887502
R2236 n_1_19_14 n_1_20_14 175.07170678264373
R2237 n_1_19_14 n_1_19_15 71.04972374573526
R2238 n_1_19_15 n_2_19_15 878.5143824666453
R2239 n_1_19_15 n_1_20_15 57904.96701835884
R2240 n_1_20_0 n_2_20_0 720.9891545366872
R2241 n_1_20_0 n_1_21_0 28.30578398702898
R2242 n_1_20_0 n_1_20_1 3269.316855378915
R2243 n_1_20_1 n_2_20_1 1009.3848163513619
R2244 n_1_20_1 n_1_21_1 39.62809758184057
R2245 n_1_20_1 n_1_20_2 7430.265580406626
R2246 n_1_20_2 n_2_20_2 1802.472886341718
R2247 n_1_20_2 n_1_21_2 70.76445996757245
R2248 n_1_20_2 n_1_20_3 6954.728583260602
R2249 n_1_20_3 n_2_20_3 25234.620408784023
R2250 n_1_20_3 n_1_21_3 990.7024395460134
R2251 n_1_20_3 n_1_20_4 92.4655272228381
R2252 n_1_20_4 n_2_20_4 764.6854669328493
R2253 n_1_20_4 n_1_21_4 30.02128604684889
R2254 n_1_20_4 n_1_20_5 76.42558882703966
R2255 n_1_20_5 n_2_20_5 4806.5943635779095
R2256 n_1_20_5 n_1_21_5 188.70522658019303
R2257 n_1_20_5 n_1_20_6 26.41872206366803
R2258 n_1_20_6 n_2_20_6 801.0990605963184
R2259 n_1_20_6 n_1_21_6 31.450871096698837
R2260 n_1_20_6 n_1_20_7 35.853979943549426
R2261 n_1_20_7 n_2_20_7 1373.3126753079785
R2262 n_1_20_7 n_1_21_7 53.91577902291246
R2263 n_1_20_7 n_1_20_8 26.418722063667946
R2264 n_1_20_8 n_2_20_8 1373.3126753079785
R2265 n_1_20_8 n_1_21_8 53.91577902291246
R2266 n_1_20_8 n_1_20_9 26.418722063667946
R2267 n_1_20_9 n_2_20_9 1373.3126753079785
R2268 n_1_20_9 n_1_21_9 53.91577902291246
R2269 n_1_20_9 n_1_20_10 26.418722063667946
R2270 n_1_20_10 n_2_20_10 1373.3126753079785
R2271 n_1_20_10 n_1_21_10 53.91577902291246
R2272 n_1_20_10 n_1_20_11 26.41872206366778
R2273 n_1_20_11 n_2_20_11 1373.3126753079964
R2274 n_1_20_11 n_1_21_11 53.915779022913156
R2275 n_1_20_11 n_1_20_12 26.418722063667694
R2276 n_1_20_12 n_2_20_12 1373.3126753079873
R2277 n_1_20_12 n_1_21_12 53.91577902291281
R2278 n_1_20_12 n_1_20_13 26.41872206366795
R2279 n_1_20_13 n_2_20_13 1373.3126753079696
R2280 n_1_20_13 n_1_21_13 53.915779022912126
R2281 n_1_20_13 n_1_20_14 132.09361031834007
R2282 n_1_20_14 n_2_20_14 152.59029725644177
R2283 n_1_20_14 n_1_21_14 5.990642113656929
R2284 n_1_20_14 n_1_20_15 4081.6925588367453
R2285 n_1_20_15 n_2_20_15 50469.240817567596
R2286 n_1_20_15 n_1_21_15 1981.4048790920094
R2287 n_1_21_0 n_2_21_0 720.9891545366872
R2288 n_1_21_0 n_1_22_0 28.305783987027976
R2289 n_1_21_0 n_1_21_1 3269.316855378915
R2290 n_1_21_1 n_2_21_1 1009.3848163513619
R2291 n_1_21_1 n_1_22_1 39.628097581839164
R2292 n_1_21_1 n_1_21_2 7430.265580406626
R2293 n_1_21_2 n_2_21_2 1802.472886341718
R2294 n_1_21_2 n_1_22_2 70.76445996756993
R2295 n_1_21_2 n_1_21_3 6954.728583260602
R2296 n_1_21_3 n_2_21_3 25234.620408784023
R2297 n_1_21_3 n_1_22_3 990.7024395459782
R2298 n_1_21_3 n_1_21_4 92.4655272228381
R2299 n_1_21_4 n_2_21_4 764.6854669328493
R2300 n_1_21_4 n_1_22_4 30.021286046847823
R2301 n_1_21_4 n_1_21_5 76.42558882703966
R2302 n_1_21_5 n_2_21_5 4806.5943635779095
R2303 n_1_21_5 n_1_22_5 188.70522658018632
R2304 n_1_21_5 n_1_21_6 26.41872206366803
R2305 n_1_21_6 n_2_21_6 801.0990605963184
R2306 n_1_21_6 n_1_22_6 31.45087109669772
R2307 n_1_21_6 n_1_21_7 35.853979943549426
R2308 n_1_21_7 n_2_21_7 1373.3126753079785
R2309 n_1_21_7 n_1_22_7 53.91577902291054
R2310 n_1_21_7 n_1_21_8 26.418722063667946
R2311 n_1_21_8 n_2_21_8 1373.3126753079785
R2312 n_1_21_8 n_1_22_8 53.91577902291054
R2313 n_1_21_8 n_1_21_9 26.418722063667946
R2314 n_1_21_9 n_2_21_9 1373.3126753079785
R2315 n_1_21_9 n_1_22_9 53.91577902291054
R2316 n_1_21_9 n_1_21_10 26.418722063667946
R2317 n_1_21_10 n_2_21_10 1373.3126753079785
R2318 n_1_21_10 n_1_22_10 53.91577902291054
R2319 n_1_21_10 n_1_21_11 26.41872206366778
R2320 n_1_21_11 n_2_21_11 1373.3126753079964
R2321 n_1_21_11 n_1_22_11 53.91577902291124
R2322 n_1_21_11 n_1_21_12 26.418722063667694
R2323 n_1_21_12 n_2_21_12 1373.3126753079873
R2324 n_1_21_12 n_1_22_12 53.9157790229109
R2325 n_1_21_12 n_1_21_13 26.41872206366795
R2326 n_1_21_13 n_2_21_13 1373.3126753079696
R2327 n_1_21_13 n_1_22_13 53.915779022910215
R2328 n_1_21_13 n_1_21_14 132.09361031834007
R2329 n_1_21_14 n_2_21_14 152.59029725644177
R2330 n_1_21_14 n_1_22_14 5.990642113656715
R2331 n_1_21_14 n_1_21_15 4081.6925588367453
R2332 n_1_21_15 n_2_21_15 50469.240817567596
R2333 n_1_21_15 n_1_22_15 1981.4048790919392
R2334 n_1_22_0 n_2_22_0 720.9891545367384
R2335 n_1_22_0 n_1_23_0 28.305783987027976
R2336 n_1_22_0 n_1_22_1 3269.3168553791475
R2337 n_1_22_1 n_2_22_1 1009.3848163514338
R2338 n_1_22_1 n_1_23_1 39.628097581839164
R2339 n_1_22_1 n_1_22_2 7430.265580407155
R2340 n_1_22_2 n_2_22_2 1802.4728863418459
R2341 n_1_22_2 n_1_23_2 70.76445996756993
R2342 n_1_22_2 n_1_22_3 6954.728583261097
R2343 n_1_22_3 n_2_22_3 25234.62040878582
R2344 n_1_22_3 n_1_23_3 990.7024395459782
R2345 n_1_22_3 n_1_22_4 92.46552722284467
R2346 n_1_22_4 n_2_22_4 764.6854669329036
R2347 n_1_22_4 n_1_23_4 30.021286046847823
R2348 n_1_22_4 n_1_22_5 76.42558882704509
R2349 n_1_22_5 n_2_22_5 4806.594363578251
R2350 n_1_22_5 n_1_23_5 188.70522658018632
R2351 n_1_22_5 n_1_22_6 26.418722063669907
R2352 n_1_22_6 n_2_22_6 801.0990605963752
R2353 n_1_22_6 n_1_23_6 31.45087109669772
R2354 n_1_22_6 n_1_22_7 35.85397994355198
R2355 n_1_22_7 n_2_22_7 1373.312675308076
R2356 n_1_22_7 n_1_23_7 53.91577902291054
R2357 n_1_22_7 n_1_22_8 26.418722063669826
R2358 n_1_22_8 n_2_22_8 1373.312675308076
R2359 n_1_22_8 n_1_23_8 53.91577902291054
R2360 n_1_22_8 n_1_22_9 26.418722063669826
R2361 n_1_22_9 n_2_22_9 1373.312675308076
R2362 n_1_22_9 n_1_23_9 53.91577902291054
R2363 n_1_22_9 n_1_22_10 26.418722063669826
R2364 n_1_22_10 n_2_22_10 1373.312675308076
R2365 n_1_22_10 n_1_23_10 53.91577902291054
R2366 n_1_22_10 n_1_22_11 26.418722063669655
R2367 n_1_22_11 n_2_22_11 1373.3126753080937
R2368 n_1_22_11 n_1_23_11 53.91577902291124
R2369 n_1_22_11 n_1_22_12 26.418722063669573
R2370 n_1_22_12 n_2_22_12 1373.3126753080849
R2371 n_1_22_12 n_1_23_12 53.9157790229109
R2372 n_1_22_12 n_1_22_13 26.418722063669826
R2373 n_1_22_13 n_2_22_13 1373.3126753080674
R2374 n_1_22_13 n_1_23_13 53.915779022910215
R2375 n_1_22_13 n_1_22_14 132.09361031834945
R2376 n_1_22_14 n_2_22_14 152.59029725645257
R2377 n_1_22_14 n_1_23_14 5.990642113656715
R2378 n_1_22_14 n_1_22_15 4081.692558837036
R2379 n_1_22_15 n_2_22_15 50469.24081757119
R2380 n_1_22_15 n_1_23_15 1981.4048790919392
R2381 n_1_23_0 n_2_23_0 720.9891545366872
R2382 n_1_23_0 n_1_24_0 326.27363593662324
R2383 n_1_23_0 n_1_23_1 3269.316855378915
R2384 n_1_23_1 n_2_23_1 1009.3848163513619
R2385 n_1_23_1 n_1_24_1 456.7830903112725
R2386 n_1_23_1 n_1_23_2 7430.265580406626
R2387 n_1_23_2 n_2_23_2 1802.472886341718
R2388 n_1_23_2 n_1_24_2 815.684089841558
R2389 n_1_23_2 n_1_23_3 6954.728583260602
R2390 n_1_23_3 n_2_23_3 25234.620408784023
R2391 n_1_23_3 n_1_24_3 11419.577257781802
R2392 n_1_23_3 n_1_23_4 92.4655272228381
R2393 n_1_23_4 n_2_23_4 764.6854669328493
R2394 n_1_23_4 n_1_24_4 346.0477956903576
R2395 n_1_23_4 n_1_23_5 76.42558882703966
R2396 n_1_23_5 n_2_23_5 4806.5943635779095
R2397 n_1_23_5 n_1_24_5 2175.1575729108195
R2398 n_1_23_5 n_1_23_6 26.41872206366803
R2399 n_1_23_6 n_2_23_6 801.0990605963184
R2400 n_1_23_6 n_1_24_6 362.5262621518032
R2401 n_1_23_6 n_1_23_7 35.853979943549426
R2402 n_1_23_7 n_2_23_7 1373.3126753079785
R2403 n_1_23_7 n_1_24_7 621.473592260236
R2404 n_1_23_7 n_1_23_8 26.418722063667946
R2405 n_1_23_8 n_2_23_8 1373.3126753079785
R2406 n_1_23_8 n_1_24_8 621.473592260236
R2407 n_1_23_8 n_1_23_9 26.418722063667946
R2408 n_1_23_9 n_2_23_9 1373.3126753079785
R2409 n_1_23_9 n_1_24_9 621.473592260236
R2410 n_1_23_9 n_1_23_10 26.418722063667946
R2411 n_1_23_10 n_2_23_10 1373.3126753079785
R2412 n_1_23_10 n_1_24_10 621.473592260236
R2413 n_1_23_10 n_1_23_11 26.41872206366778
R2414 n_1_23_11 n_2_23_11 1373.3126753079964
R2415 n_1_23_11 n_1_24_11 621.473592260244
R2416 n_1_23_11 n_1_23_12 26.418722063667694
R2417 n_1_23_12 n_2_23_12 1373.3126753079873
R2418 n_1_23_12 n_1_24_12 621.47359226024
R2419 n_1_23_12 n_1_23_13 26.41872206366795
R2420 n_1_23_13 n_2_23_13 1373.3126753079696
R2421 n_1_23_13 n_1_24_13 621.4735922602322
R2422 n_1_23_13 n_1_23_14 132.09361031834007
R2423 n_1_23_14 n_2_23_14 152.59029725644177
R2424 n_1_23_14 n_1_24_14 69.0526213622483
R2425 n_1_23_14 n_1_23_15 4081.6925588367453
R2426 n_1_23_15 n_2_23_15 50469.240817567596
R2427 n_1_23_15 n_1_24_15 22839.1545155634
R2428 n_1_24_0 n_2_24_0 32.692737764693376
R2429 n_1_24_0 n_1_25_0 624.2414878862164
R2430 n_1_24_0 n_1_24_1 148.244835515284
R2431 n_1_24_1 n_2_24_1 45.769832870570724
R2432 n_1_24_1 n_1_25_1 873.938083040703
R2433 n_1_24_1 n_1_24_2 336.92008071655454
R2434 n_1_24_2 n_2_24_2 81.73184441173345
R2435 n_1_24_2 n_1_25_2 1560.603719715541
R2436 n_1_24_2 n_1_24_3 315.35719555069505
R2437 n_1_24_3 n_2_24_3 1144.245821764267
R2438 n_1_24_3 n_1_25_3 21848.45207601756
R2439 n_1_24_3 n_1_24_4 4.192783226694905
R2440 n_1_24_4 n_2_24_4 34.67411581103839
R2441 n_1_24_4 n_1_25_4 662.0743053338653
R2442 n_1_24_4 n_1_24_5 3.465463687370278
R2443 n_1_24_5 n_2_24_5 217.95158509795564
R2444 n_1_24_5 n_1_25_5 4161.6099192414395
R2445 n_1_24_5 n_1_24_6 1.1979380647699727
R2446 n_1_24_6 n_2_24_6 36.3252641829926
R2447 n_1_24_6 n_1_25_6 693.6016532069066
R2448 n_1_24_6 n_1_24_7 1.625773087902104
R2449 n_1_24_7 n_2_24_7 62.271881456558944
R2450 n_1_24_7 n_1_25_7 1189.031405497558
R2451 n_1_24_7 n_1_24_8 1.197938064769969
R2452 n_1_24_8 n_2_24_8 62.271881456558944
R2453 n_1_24_8 n_1_25_8 1189.031405497558
R2454 n_1_24_8 n_1_24_9 1.197938064769969
R2455 n_1_24_9 n_2_24_9 62.271881456558944
R2456 n_1_24_9 n_1_25_9 1189.031405497558
R2457 n_1_24_9 n_1_24_10 1.197938064769969
R2458 n_1_24_10 n_2_24_10 62.271881456558944
R2459 n_1_24_10 n_1_25_10 1189.031405497558
R2460 n_1_24_10 n_1_24_11 1.1979380647699611
R2461 n_1_24_11 n_2_24_11 62.27188145655974
R2462 n_1_24_11 n_1_25_11 1189.0314054975731
R2463 n_1_24_11 n_1_24_12 1.1979380647699576
R2464 n_1_24_12 n_2_24_12 62.27188145655935
R2465 n_1_24_12 n_1_25_12 1189.0314054975654
R2466 n_1_24_12 n_1_24_13 1.1979380647699691
R2467 n_1_24_13 n_2_24_13 62.27188145655855
R2468 n_1_24_13 n_1_25_13 1189.0314054975502
R2469 n_1_24_13 n_1_24_14 5.98969032384986
R2470 n_1_24_14 n_2_24_14 6.919097939617646
R2471 n_1_24_14 n_1_25_14 132.1146006108395
R2472 n_1_24_14 n_1_24_15 185.0814310069624
R2473 n_1_24_15 n_2_24_15 2288.491643528514
R2474 n_1_24_15 n_1_25_15 43696.904152034724
R2475 n_1_25_0 n_2_25_0 32.692737764693476
R2476 n_1_25_0 n_1_26_0 624.2414878862164
R2477 n_1_25_0 n_1_25_1 148.24483551528448
R2478 n_1_25_1 n_2_25_1 45.769832870570866
R2479 n_1_25_1 n_1_26_1 873.938083040703
R2480 n_1_25_1 n_1_25_2 336.9200807165556
R2481 n_1_25_2 n_2_25_2 81.7318444117337
R2482 n_1_25_2 n_1_26_2 1560.603719715541
R2483 n_1_25_2 n_1_25_3 315.3571955506961
R2484 n_1_25_3 n_2_25_3 1144.2458217642707
R2485 n_1_25_3 n_1_26_3 21848.45207601756
R2486 n_1_25_3 n_1_25_4 4.192783226694917
R2487 n_1_25_4 n_2_25_4 34.67411581103851
R2488 n_1_25_4 n_1_26_4 662.0743053338653
R2489 n_1_25_4 n_1_25_5 3.4654636873702893
R2490 n_1_25_5 n_2_25_5 217.95158509795633
R2491 n_1_25_5 n_1_26_5 4161.6099192414395
R2492 n_1_25_5 n_1_25_6 1.1979380647699764
R2493 n_1_25_6 n_2_25_6 36.325264182992726
R2494 n_1_25_6 n_1_26_6 693.6016532069066
R2495 n_1_25_6 n_1_25_7 1.6257730879021093
R2496 n_1_25_7 n_2_25_7 62.27188145655915
R2497 n_1_25_7 n_1_26_7 1189.031405497558
R2498 n_1_25_7 n_1_25_8 1.1979380647699729
R2499 n_1_25_8 n_2_25_8 62.27188145655915
R2500 n_1_25_8 n_1_26_8 1189.031405497558
R2501 n_1_25_8 n_1_25_9 1.1979380647699729
R2502 n_1_25_9 n_2_25_9 62.27188145655915
R2503 n_1_25_9 n_1_26_9 1189.031405497558
R2504 n_1_25_9 n_1_25_10 1.1979380647699729
R2505 n_1_25_10 n_2_25_10 62.27188145655915
R2506 n_1_25_10 n_1_26_10 1189.031405497558
R2507 n_1_25_10 n_1_25_11 1.1979380647699651
R2508 n_1_25_11 n_2_25_11 62.271881456559946
R2509 n_1_25_11 n_1_26_11 1189.0314054975731
R2510 n_1_25_11 n_1_25_12 1.1979380647699613
R2511 n_1_25_12 n_2_25_12 62.27188145655953
R2512 n_1_25_12 n_1_26_12 1189.0314054975654
R2513 n_1_25_12 n_1_25_13 1.1979380647699727
R2514 n_1_25_13 n_2_25_13 62.27188145655876
R2515 n_1_25_13 n_1_26_13 1189.0314054975502
R2516 n_1_25_13 n_1_25_14 5.989690323849879
R2517 n_1_25_14 n_2_25_14 6.919097939617668
R2518 n_1_25_14 n_1_26_14 132.1146006108395
R2519 n_1_25_14 n_1_25_15 185.081431006963
R2520 n_1_25_15 n_2_25_15 2288.4916435285213
R2521 n_1_25_15 n_1_26_15 43696.904152034724
R2522 n_1_26_0 n_2_26_0 32.692737764693376
R2523 n_1_26_0 n_1_27_0 624.2414878862174
R2524 n_1_26_0 n_1_26_1 148.244835515284
R2525 n_1_26_1 n_2_26_1 45.769832870570724
R2526 n_1_26_1 n_1_27_1 873.9380830407043
R2527 n_1_26_1 n_1_26_2 336.92008071655454
R2528 n_1_26_2 n_2_26_2 81.73184441173345
R2529 n_1_26_2 n_1_27_2 1560.6037197155435
R2530 n_1_26_2 n_1_26_3 315.35719555069505
R2531 n_1_26_3 n_2_26_3 1144.245821764267
R2532 n_1_26_3 n_1_27_3 21848.45207601759
R2533 n_1_26_3 n_1_26_4 4.192783226694905
R2534 n_1_26_4 n_2_26_4 34.67411581103839
R2535 n_1_26_4 n_1_27_4 662.0743053338663
R2536 n_1_26_4 n_1_26_5 3.465463687370278
R2537 n_1_26_5 n_2_26_5 217.95158509795564
R2538 n_1_26_5 n_1_27_5 4161.609919241446
R2539 n_1_26_5 n_1_26_6 1.1979380647699727
R2540 n_1_26_6 n_2_26_6 36.3252641829926
R2541 n_1_26_6 n_1_27_6 693.6016532069076
R2542 n_1_26_6 n_1_26_7 1.625773087902104
R2543 n_1_26_7 n_2_26_7 62.271881456558944
R2544 n_1_26_7 n_1_27_7 1189.0314054975597
R2545 n_1_26_7 n_1_26_8 1.197938064769969
R2546 n_1_26_8 n_2_26_8 62.271881456558944
R2547 n_1_26_8 n_1_27_8 1189.0314054975597
R2548 n_1_26_8 n_1_26_9 1.197938064769969
R2549 n_1_26_9 n_2_26_9 62.271881456558944
R2550 n_1_26_9 n_1_27_9 1189.0314054975597
R2551 n_1_26_9 n_1_26_10 1.197938064769969
R2552 n_1_26_10 n_2_26_10 62.271881456558944
R2553 n_1_26_10 n_1_27_10 1189.0314054975597
R2554 n_1_26_10 n_1_26_11 1.1979380647699611
R2555 n_1_26_11 n_2_26_11 62.27188145655974
R2556 n_1_26_11 n_1_27_11 1189.031405497575
R2557 n_1_26_11 n_1_26_12 1.1979380647699576
R2558 n_1_26_12 n_2_26_12 62.27188145655935
R2559 n_1_26_12 n_1_27_12 1189.0314054975672
R2560 n_1_26_12 n_1_26_13 1.1979380647699691
R2561 n_1_26_13 n_2_26_13 62.27188145655855
R2562 n_1_26_13 n_1_27_13 1189.0314054975522
R2563 n_1_26_13 n_1_26_14 5.98969032384986
R2564 n_1_26_14 n_2_26_14 6.919097939617646
R2565 n_1_26_14 n_1_27_14 132.1146006108397
R2566 n_1_26_14 n_1_26_15 185.0814310069624
R2567 n_1_26_15 n_2_26_15 2288.491643528514
R2568 n_1_26_15 n_1_27_15 43696.9041520348
R2569 n_1_27_0 n_2_27_0 32.692737764693376
R2570 n_1_27_0 n_1_27_1 148.244835515284
R2571 n_1_27_1 n_2_27_1 45.769832870570724
R2572 n_1_27_1 n_1_27_2 336.92008071655454
R2573 n_1_27_2 n_2_27_2 81.73184441173345
R2574 n_1_27_2 n_1_27_3 315.35719555069505
R2575 n_1_27_3 n_2_27_3 1144.245821764267
R2576 n_1_27_3 n_1_27_4 4.192783226694905
R2577 n_1_27_4 n_2_27_4 34.67411581103839
R2578 n_1_27_4 n_1_27_5 3.465463687370278
R2579 n_1_27_5 n_2_27_5 217.95158509795564
R2580 n_1_27_5 n_1_27_6 1.1979380647699727
R2581 n_1_27_6 n_2_27_6 36.3252641829926
R2582 n_1_27_6 n_1_27_7 1.625773087902104
R2583 n_1_27_7 n_2_27_7 62.271881456558944
R2584 n_1_27_7 n_1_27_8 1.197938064769969
R2585 n_1_27_8 n_2_27_8 62.271881456558944
R2586 n_1_27_8 n_1_27_9 1.197938064769969
R2587 n_1_27_9 n_2_27_9 62.271881456558944
R2588 n_1_27_9 n_1_27_10 1.197938064769969
R2589 n_1_27_10 n_2_27_10 62.271881456558944
R2590 n_1_27_10 n_1_27_11 1.1979380647699611
R2591 n_1_27_11 n_2_27_11 62.27188145655974
R2592 n_1_27_11 n_1_27_12 1.1979380647699576
R2593 n_1_27_12 n_2_27_12 62.27188145655935
R2594 n_1_27_12 n_1_27_13 1.1979380647699691
R2595 n_1_27_13 n_2_27_13 62.27188145655855
R2596 n_1_27_13 n_1_27_14 5.98969032384986
R2597 n_1_27_14 n_2_27_14 6.919097939617646
R2598 n_1_27_14 n_1_27_15 185.0814310069624
R2599 n_1_27_15 n_2_27_15 2288.491643528514
R2600 n_2_0_0 n_3_0_0 32.69273494920007
R2601 n_2_0_0 n_2_1_0 624.2415416457986
R2602 n_2_0_0 n_2_0_1 148.24482274846264
R2603 n_2_0_1 n_3_0_1 45.76982892888009
R2604 n_2_0_1 n_2_1_1 873.938158304118
R2605 n_2_0_1 n_2_0_2 336.9200517010515
R2606 n_2_0_2 n_3_0_2 81.73183737300018
R2607 n_2_0_2 n_2_1_2 1560.6038541144965
R2608 n_2_0_2 n_2_0_3 315.3571683921842
R2609 n_2_0_3 n_3_0_3 1144.2457232220013
R2610 n_2_0_3 n_2_1_3 21848.45395760293
R2611 n_2_0_3 n_2_0_4 4.192782865613089
R2612 n_2_0_4 n_3_0_4 34.67411282490913
R2613 n_2_0_4 n_2_1_4 662.074362351604
R2614 n_2_0_4 n_2_0_5 3.465463388925104
R2615 n_2_0_5 n_3_0_5 217.95156632800024
R2616 n_2_0_5 n_2_1_5 4161.610277638654
R2617 n_2_0_5 n_2_0_6 1.1979379616037398
R2618 n_2_0_6 n_3_0_6 36.32526105466671
R2619 n_2_0_6 n_2_1_6 693.6017129397757
R2620 n_2_0_6 n_2_0_7 1.6257729478907876
R2621 n_2_0_7 n_3_0_7 62.27187609371455
R2622 n_2_0_7 n_2_1_7 1189.031507896762
R2623 n_2_0_7 n_2_0_8 1.197937961603736
R2624 n_2_0_8 n_3_0_8 62.27187609371455
R2625 n_2_0_8 n_2_1_8 1189.031507896762
R2626 n_2_0_8 n_2_0_9 1.197937961603736
R2627 n_2_0_9 n_3_0_9 62.27187609371455
R2628 n_2_0_9 n_2_1_9 1189.031507896762
R2629 n_2_0_9 n_2_0_10 1.197937961603736
R2630 n_2_0_10 n_3_0_10 62.27187609371455
R2631 n_2_0_10 n_2_1_10 1189.031507896762
R2632 n_2_0_10 n_2_0_11 1.1979379616037282
R2633 n_2_0_11 n_3_0_11 62.27187609371534
R2634 n_2_0_11 n_2_1_11 1189.0315078967772
R2635 n_2_0_11 n_2_0_12 1.1979379616037247
R2636 n_2_0_12 n_3_0_12 62.271876093714965
R2637 n_2_0_12 n_2_1_12 1189.0315078967694
R2638 n_2_0_12 n_2_0_13 1.1979379616037362
R2639 n_2_0_13 n_3_0_13 62.271876093714155
R2640 n_2_0_13 n_2_1_13 1189.0315078967544
R2641 n_2_0_13 n_2_0_14 5.989689808018695
R2642 n_2_0_14 n_3_0_14 6.9190973437460475
R2643 n_2_0_14 n_2_1_14 132.11461198852882
R2644 n_2_0_14 n_2_0_15 185.08141506777937
R2645 n_2_0_15 n_3_0_15 2288.491446443982
R2646 n_2_0_15 n_2_1_15 43696.90791520548
R2647 n_2_1_0 n_3_1_0 32.69273494920007
R2648 n_2_1_0 n_2_2_0 624.2415416457986
R2649 n_2_1_0 n_2_1_1 148.24482274846264
R2650 n_2_1_1 n_3_1_1 45.76982892888009
R2651 n_2_1_1 n_2_2_1 873.938158304118
R2652 n_2_1_1 n_2_1_2 336.9200517010515
R2653 n_2_1_2 n_3_1_2 81.73183737300018
R2654 n_2_1_2 n_2_2_2 1560.6038541144965
R2655 n_2_1_2 n_2_1_3 315.3571683921842
R2656 n_2_1_3 n_3_1_3 1144.2457232220013
R2657 n_2_1_3 n_2_2_3 21848.45395760293
R2658 n_2_1_3 n_2_1_4 4.192782865613089
R2659 n_2_1_4 n_3_1_4 34.67411282490913
R2660 n_2_1_4 n_2_2_4 662.074362351604
R2661 n_2_1_4 n_2_1_5 3.465463388925104
R2662 n_2_1_5 n_3_1_5 217.95156632800024
R2663 n_2_1_5 n_2_2_5 4161.610277638654
R2664 n_2_1_5 n_2_1_6 1.1979379616037398
R2665 n_2_1_6 n_3_1_6 36.32526105466671
R2666 n_2_1_6 n_2_2_6 693.6017129397757
R2667 n_2_1_6 n_2_1_7 1.6257729478907876
R2668 n_2_1_7 n_3_1_7 62.27187609371455
R2669 n_2_1_7 n_2_2_7 1189.031507896762
R2670 n_2_1_7 n_2_1_8 1.197937961603736
R2671 n_2_1_8 n_3_1_8 62.27187609371455
R2672 n_2_1_8 n_2_2_8 1189.031507896762
R2673 n_2_1_8 n_2_1_9 1.197937961603736
R2674 n_2_1_9 n_3_1_9 62.27187609371455
R2675 n_2_1_9 n_2_2_9 1189.031507896762
R2676 n_2_1_9 n_2_1_10 1.197937961603736
R2677 n_2_1_10 n_3_1_10 62.27187609371455
R2678 n_2_1_10 n_2_2_10 1189.031507896762
R2679 n_2_1_10 n_2_1_11 1.1979379616037282
R2680 n_2_1_11 n_3_1_11 62.27187609371534
R2681 n_2_1_11 n_2_2_11 1189.0315078967772
R2682 n_2_1_11 n_2_1_12 1.1979379616037247
R2683 n_2_1_12 n_3_1_12 62.271876093714965
R2684 n_2_1_12 n_2_2_12 1189.0315078967694
R2685 n_2_1_12 n_2_1_13 1.1979379616037362
R2686 n_2_1_13 n_3_1_13 62.271876093714155
R2687 n_2_1_13 n_2_2_13 1189.0315078967544
R2688 n_2_1_13 n_2_1_14 5.989689808018695
R2689 n_2_1_14 n_3_1_14 6.9190973437460475
R2690 n_2_1_14 n_2_2_14 132.11461198852882
R2691 n_2_1_14 n_2_1_15 185.08141506777937
R2692 n_2_1_15 n_3_1_15 2288.491446443982
R2693 n_2_1_15 n_2_2_15 43696.90791520548
R2694 n_2_2_0 n_3_2_0 32.69273494920007
R2695 n_2_2_0 n_2_3_0 624.2415416457986
R2696 n_2_2_0 n_2_2_1 148.24482274846264
R2697 n_2_2_1 n_3_2_1 45.76982892888009
R2698 n_2_2_1 n_2_3_1 873.938158304118
R2699 n_2_2_1 n_2_2_2 336.9200517010515
R2700 n_2_2_2 n_3_2_2 81.73183737300018
R2701 n_2_2_2 n_2_3_2 1560.6038541144965
R2702 n_2_2_2 n_2_2_3 315.3571683921842
R2703 n_2_2_3 n_3_2_3 1144.2457232220013
R2704 n_2_2_3 n_2_3_3 21848.45395760293
R2705 n_2_2_3 n_2_2_4 4.192782865613089
R2706 n_2_2_4 n_3_2_4 34.67411282490913
R2707 n_2_2_4 n_2_3_4 662.074362351604
R2708 n_2_2_4 n_2_2_5 3.465463388925104
R2709 n_2_2_5 n_3_2_5 217.95156632800024
R2710 n_2_2_5 n_2_3_5 4161.610277638654
R2711 n_2_2_5 n_2_2_6 1.1979379616037398
R2712 n_2_2_6 n_3_2_6 36.32526105466671
R2713 n_2_2_6 n_2_3_6 693.6017129397757
R2714 n_2_2_6 n_2_2_7 1.6257729478907876
R2715 n_2_2_7 n_3_2_7 62.27187609371455
R2716 n_2_2_7 n_2_3_7 1189.031507896762
R2717 n_2_2_7 n_2_2_8 1.197937961603736
R2718 n_2_2_8 n_3_2_8 62.27187609371455
R2719 n_2_2_8 n_2_3_8 1189.031507896762
R2720 n_2_2_8 n_2_2_9 1.197937961603736
R2721 n_2_2_9 n_3_2_9 62.27187609371455
R2722 n_2_2_9 n_2_3_9 1189.031507896762
R2723 n_2_2_9 n_2_2_10 1.197937961603736
R2724 n_2_2_10 n_3_2_10 62.27187609371455
R2725 n_2_2_10 n_2_3_10 1189.031507896762
R2726 n_2_2_10 n_2_2_11 1.1979379616037282
R2727 n_2_2_11 n_3_2_11 62.27187609371534
R2728 n_2_2_11 n_2_3_11 1189.0315078967772
R2729 n_2_2_11 n_2_2_12 1.1979379616037247
R2730 n_2_2_12 n_3_2_12 62.271876093714965
R2731 n_2_2_12 n_2_3_12 1189.0315078967694
R2732 n_2_2_12 n_2_2_13 1.1979379616037362
R2733 n_2_2_13 n_3_2_13 62.271876093714155
R2734 n_2_2_13 n_2_3_13 1189.0315078967544
R2735 n_2_2_13 n_2_2_14 5.989689808018695
R2736 n_2_2_14 n_3_2_14 6.9190973437460475
R2737 n_2_2_14 n_2_3_14 132.11461198852882
R2738 n_2_2_14 n_2_2_15 185.08141506777937
R2739 n_2_2_15 n_3_2_15 2288.491446443982
R2740 n_2_2_15 n_2_3_15 43696.90791520548
R2741 n_2_3_0 n_3_3_0 32.69273494920007
R2742 n_2_3_0 n_2_4_0 326.27363593662255
R2743 n_2_3_0 n_2_3_1 148.24482274846264
R2744 n_2_3_1 n_3_3_1 45.76982892888009
R2745 n_2_3_1 n_2_4_1 456.7830903112715
R2746 n_2_3_1 n_2_3_2 336.9200517010515
R2747 n_2_3_2 n_3_3_2 81.73183737300018
R2748 n_2_3_2 n_2_4_2 815.6840898415563
R2749 n_2_3_2 n_2_3_3 315.3571683921842
R2750 n_2_3_3 n_3_3_3 1144.2457232220013
R2751 n_2_3_3 n_2_4_3 11419.577257781779
R2752 n_2_3_3 n_2_3_4 4.192782865613089
R2753 n_2_3_4 n_3_3_4 34.67411282490913
R2754 n_2_3_4 n_2_4_4 346.0477956903569
R2755 n_2_3_4 n_2_3_5 3.465463388925104
R2756 n_2_3_5 n_3_3_5 217.95156632800024
R2757 n_2_3_5 n_2_4_5 2175.1575729108154
R2758 n_2_3_5 n_2_3_6 1.1979379616037398
R2759 n_2_3_6 n_3_3_6 36.32526105466671
R2760 n_2_3_6 n_2_4_6 362.52626215180254
R2761 n_2_3_6 n_2_3_7 1.6257729478907876
R2762 n_2_3_7 n_3_3_7 62.27187609371455
R2763 n_2_3_7 n_2_4_7 621.4735922602348
R2764 n_2_3_7 n_2_3_8 1.197937961603736
R2765 n_2_3_8 n_3_3_8 62.27187609371455
R2766 n_2_3_8 n_2_4_8 621.4735922602348
R2767 n_2_3_8 n_2_3_9 1.197937961603736
R2768 n_2_3_9 n_3_3_9 62.27187609371455
R2769 n_2_3_9 n_2_4_9 621.4735922602348
R2770 n_2_3_9 n_2_3_10 1.197937961603736
R2771 n_2_3_10 n_3_3_10 62.27187609371455
R2772 n_2_3_10 n_2_4_10 621.4735922602348
R2773 n_2_3_10 n_2_3_11 1.1979379616037282
R2774 n_2_3_11 n_3_3_11 62.27187609371534
R2775 n_2_3_11 n_2_4_11 621.4735922602428
R2776 n_2_3_11 n_2_3_12 1.1979379616037247
R2777 n_2_3_12 n_3_3_12 62.271876093714965
R2778 n_2_3_12 n_2_4_12 621.4735922602388
R2779 n_2_3_12 n_2_3_13 1.1979379616037362
R2780 n_2_3_13 n_3_3_13 62.271876093714155
R2781 n_2_3_13 n_2_4_13 621.4735922602309
R2782 n_2_3_13 n_2_3_14 5.989689808018695
R2783 n_2_3_14 n_3_3_14 6.9190973437460475
R2784 n_2_3_14 n_2_4_14 69.05262136224816
R2785 n_2_3_14 n_2_3_15 185.08141506777937
R2786 n_2_3_15 n_3_3_15 2288.491446443982
R2787 n_2_3_15 n_2_4_15 22839.154515563354
R2788 n_2_4_0 n_3_4_0 720.9905238734129
R2789 n_2_4_0 n_2_5_0 28.30573022744672
R2790 n_2_4_0 n_2_4_1 3269.32306462022
R2791 n_2_4_1 n_3_4_1 1009.3867334227781
R2792 n_2_4_1 n_2_5_1 39.628022318425394
R2793 n_2_4_1 n_2_4_2 7430.2796923186825
R2794 n_2_4_2 n_3_4_2 1802.4763096835327
R2795 n_2_4_2 n_2_5_2 70.76432556861678
R2796 n_2_4_2 n_2_4_3 6954.741792010287
R2797 n_2_4_3 n_3_4_3 25234.668335569433
R2798 n_2_4_3 n_2_5_3 990.7005579606341
R2799 n_2_4_3 n_2_4_4 92.46570283774369
R2800 n_2_4_4 n_3_4_4 764.6869192596798
R2801 n_2_4_4 n_2_5_4 30.021229029110128
R2802 n_2_4_4 n_2_4_5 76.42573397813509
R2803 n_2_4_5 n_3_4_5 4806.603492489416
R2804 n_2_4_5 n_2_5_5 188.70486818297795
R2805 n_2_4_5 n_2_4_6 26.418772239355338
R2806 n_2_4_6 n_3_4_6 801.1005820815692
R2807 n_2_4_6 n_2_5_6 31.450811363829658
R2808 n_2_4_6 n_2_4_7 35.85404803912506
R2809 n_2_4_7 n_3_4_7 1373.3152835684086
R2810 n_2_4_7 n_2_5_7 53.91567662370815
R2811 n_2_4_7 n_2_4_8 26.418772239355256
R2812 n_2_4_8 n_3_4_8 1373.3152835684086
R2813 n_2_4_8 n_2_5_8 53.91567662370815
R2814 n_2_4_8 n_2_4_9 26.418772239355256
R2815 n_2_4_9 n_3_4_9 1373.3152835684086
R2816 n_2_4_9 n_2_5_9 53.91567662370815
R2817 n_2_4_9 n_2_4_10 26.418772239355256
R2818 n_2_4_10 n_3_4_10 1373.3152835684086
R2819 n_2_4_10 n_2_5_10 53.91567662370815
R2820 n_2_4_10 n_2_4_11 26.418772239355086
R2821 n_2_4_11 n_3_4_11 1373.3152835684261
R2822 n_2_4_11 n_2_5_11 53.91567662370885
R2823 n_2_4_11 n_2_4_12 26.418772239355
R2824 n_2_4_12 n_3_4_12 1373.3152835684175
R2825 n_2_4_12 n_2_5_12 53.91567662370849
R2826 n_2_4_12 n_2_4_13 26.418772239355256
R2827 n_2_4_13 n_3_4_13 1373.3152835684
R2828 n_2_4_13 n_2_5_13 53.91567662370781
R2829 n_2_4_13 n_2_4_14 132.0938611967766
R2830 n_2_4_14 n_3_4_14 152.5905870631562
R2831 n_2_4_14 n_2_5_14 5.99063073596756
R2832 n_2_4_14 n_2_4_15 4081.7003109804355
R2833 n_2_4_15 n_3_4_15 50469.336671138415
R2834 n_2_4_15 n_2_5_15 1981.401115921251
R2835 n_2_5_0 n_3_5_0 720.9905238734002
R2836 n_2_5_0 n_2_6_0 28.305730227446972
R2837 n_2_5_0 n_2_5_1 3269.323064620162
R2838 n_2_5_1 n_3_5_1 1009.3867334227601
R2839 n_2_5_1 n_2_6_1 39.62802231842575
R2840 n_2_5_1 n_2_5_2 7430.279692318551
R2841 n_2_5_2 n_3_5_2 1802.4763096835004
R2842 n_2_5_2 n_2_6_2 70.76432556861742
R2843 n_2_5_2 n_2_5_3 6954.741792010163
R2844 n_2_5_3 n_3_5_3 25234.668335568982
R2845 n_2_5_3 n_2_6_3 990.7005579606429
R2846 n_2_5_3 n_2_5_4 92.46570283774204
R2847 n_2_5_4 n_3_5_4 764.6869192596662
R2848 n_2_5_4 n_2_6_4 30.021229029110394
R2849 n_2_5_4 n_2_5_5 76.42573397813372
R2850 n_2_5_5 n_3_5_5 4806.603492489331
R2851 n_2_5_5 n_2_6_5 188.70486818297962
R2852 n_2_5_5 n_2_5_6 26.41877223935487
R2853 n_2_5_6 n_3_5_6 801.1005820815551
R2854 n_2_5_6 n_2_6_6 31.45081136382994
R2855 n_2_5_6 n_2_5_7 35.85404803912442
R2856 n_2_5_7 n_3_5_7 1373.3152835683845
R2857 n_2_5_7 n_2_6_7 53.915676623708634
R2858 n_2_5_7 n_2_5_8 26.418772239354787
R2859 n_2_5_8 n_3_5_8 1373.3152835683845
R2860 n_2_5_8 n_2_6_8 53.915676623708634
R2861 n_2_5_8 n_2_5_9 26.418772239354787
R2862 n_2_5_9 n_3_5_9 1373.3152835683845
R2863 n_2_5_9 n_2_6_9 53.915676623708634
R2864 n_2_5_9 n_2_5_10 26.418772239354787
R2865 n_2_5_10 n_3_5_10 1373.3152835683845
R2866 n_2_5_10 n_2_6_10 53.915676623708634
R2867 n_2_5_10 n_2_5_11 26.418772239354617
R2868 n_2_5_11 n_3_5_11 1373.3152835684018
R2869 n_2_5_11 n_2_6_11 53.915676623709324
R2870 n_2_5_11 n_2_5_12 26.41877223935453
R2871 n_2_5_12 n_3_5_12 1373.315283568393
R2872 n_2_5_12 n_2_6_12 53.91567662370897
R2873 n_2_5_12 n_2_5_13 26.418772239354787
R2874 n_2_5_13 n_3_5_13 1373.315283568376
R2875 n_2_5_13 n_2_6_13 53.91567662370829
R2876 n_2_5_13 n_2_5_14 132.09386119677427
R2877 n_2_5_14 n_3_5_14 152.59058706315346
R2878 n_2_5_14 n_2_6_14 5.990630735967613
R2879 n_2_5_14 n_2_5_15 4081.7003109803627
R2880 n_2_5_15 n_3_5_15 50469.33667113751
R2881 n_2_5_15 n_2_6_15 1981.4011159212685
R2882 n_2_6_0 n_3_6_0 720.9905238734002
R2883 n_2_6_0 n_2_7_0 28.30573022744672
R2884 n_2_6_0 n_2_6_1 3269.323064620162
R2885 n_2_6_1 n_3_6_1 1009.3867334227601
R2886 n_2_6_1 n_2_7_1 39.628022318425394
R2887 n_2_6_1 n_2_6_2 7430.279692318551
R2888 n_2_6_2 n_3_6_2 1802.4763096835004
R2889 n_2_6_2 n_2_7_2 70.76432556861678
R2890 n_2_6_2 n_2_6_3 6954.741792010163
R2891 n_2_6_3 n_3_6_3 25234.668335568982
R2892 n_2_6_3 n_2_7_3 990.7005579606341
R2893 n_2_6_3 n_2_6_4 92.46570283774204
R2894 n_2_6_4 n_3_6_4 764.6869192596662
R2895 n_2_6_4 n_2_7_4 30.021229029110128
R2896 n_2_6_4 n_2_6_5 76.42573397813372
R2897 n_2_6_5 n_3_6_5 4806.603492489331
R2898 n_2_6_5 n_2_7_5 188.70486818297795
R2899 n_2_6_5 n_2_6_6 26.41877223935487
R2900 n_2_6_6 n_3_6_6 801.1005820815551
R2901 n_2_6_6 n_2_7_6 31.450811363829658
R2902 n_2_6_6 n_2_6_7 35.85404803912442
R2903 n_2_6_7 n_3_6_7 1373.3152835683845
R2904 n_2_6_7 n_2_7_7 53.91567662370815
R2905 n_2_6_7 n_2_6_8 26.418772239354787
R2906 n_2_6_8 n_3_6_8 1373.3152835683845
R2907 n_2_6_8 n_2_7_8 53.91567662370815
R2908 n_2_6_8 n_2_6_9 26.418772239354787
R2909 n_2_6_9 n_3_6_9 1373.3152835683845
R2910 n_2_6_9 n_2_7_9 53.91567662370815
R2911 n_2_6_9 n_2_6_10 26.418772239354787
R2912 n_2_6_10 n_3_6_10 1373.3152835683845
R2913 n_2_6_10 n_2_7_10 53.91567662370815
R2914 n_2_6_10 n_2_6_11 26.418772239354617
R2915 n_2_6_11 n_3_6_11 1373.3152835684018
R2916 n_2_6_11 n_2_7_11 53.91567662370885
R2917 n_2_6_11 n_2_6_12 26.41877223935453
R2918 n_2_6_12 n_3_6_12 1373.315283568393
R2919 n_2_6_12 n_2_7_12 53.91567662370849
R2920 n_2_6_12 n_2_6_13 26.418772239354787
R2921 n_2_6_13 n_3_6_13 1373.315283568376
R2922 n_2_6_13 n_2_7_13 53.91567662370781
R2923 n_2_6_13 n_2_6_14 132.09386119677427
R2924 n_2_6_14 n_3_6_14 152.59058706315346
R2925 n_2_6_14 n_2_7_14 5.99063073596756
R2926 n_2_6_14 n_2_6_15 4081.7003109803627
R2927 n_2_6_15 n_3_6_15 50469.33667113751
R2928 n_2_6_15 n_2_7_15 1981.401115921251
R2929 n_2_7_0 n_3_7_0 720.9905238734129
R2930 n_2_7_0 n_2_8_0 827.213787668201
R2931 n_2_7_0 n_2_7_1 3269.32306462022
R2932 n_2_7_1 n_3_7_1 1009.3867334227781
R2933 n_2_7_1 n_2_8_1 1158.0993027354812
R2934 n_2_7_1 n_2_7_2 7430.2796923186825
R2935 n_2_7_2 n_3_7_2 1802.4763096835327
R2936 n_2_7_2 n_2_8_2 2068.0344691705022
R2937 n_2_7_2 n_2_7_3 6954.741792010287
R2938 n_2_7_3 n_3_7_3 25234.668335569433
R2939 n_2_7_3 n_2_8_3 28952.482568387004
R2940 n_2_7_3 n_2_7_4 92.46570283774369
R2941 n_2_7_4 n_3_7_4 764.6869192596798
R2942 n_2_7_4 n_2_8_4 877.3479566177881
R2943 n_2_7_4 n_2_7_5 76.42573397813509
R2944 n_2_7_5 n_3_7_5 4806.603492489416
R2945 n_2_7_5 n_2_8_5 5514.758584454668
R2946 n_2_7_5 n_2_7_6 26.418772239355338
R2947 n_2_7_6 n_3_7_6 801.1005820815692
R2948 n_2_7_6 n_2_8_6 919.1264307424447
R2949 n_2_7_6 n_2_7_7 35.85404803912506
R2950 n_2_7_7 n_3_7_7 1373.3152835684086
R2951 n_2_7_7 n_2_8_7 1575.6453098441957
R2952 n_2_7_7 n_2_7_8 26.418772239355256
R2953 n_2_7_8 n_3_7_8 1373.3152835684086
R2954 n_2_7_8 n_2_8_8 1575.6453098441957
R2955 n_2_7_8 n_2_7_9 26.418772239355256
R2956 n_2_7_9 n_3_7_9 1373.3152835684086
R2957 n_2_7_9 n_2_8_9 1575.6453098441957
R2958 n_2_7_9 n_2_7_10 26.418772239355256
R2959 n_2_7_10 n_3_7_10 1373.3152835684086
R2960 n_2_7_10 n_2_8_10 1575.6453098441957
R2961 n_2_7_10 n_2_7_11 26.418772239355086
R2962 n_2_7_11 n_3_7_11 1373.3152835684261
R2963 n_2_7_11 n_2_8_11 1575.645309844216
R2964 n_2_7_11 n_2_7_12 26.418772239355
R2965 n_2_7_12 n_3_7_12 1373.3152835684175
R2966 n_2_7_12 n_2_8_12 1575.6453098442055
R2967 n_2_7_12 n_2_7_13 26.418772239355256
R2968 n_2_7_13 n_3_7_13 1373.3152835684
R2969 n_2_7_13 n_2_8_13 1575.645309844186
R2970 n_2_7_13 n_2_7_14 132.0938611967766
R2971 n_2_7_14 n_3_7_14 152.5905870631562
R2972 n_2_7_14 n_2_8_14 175.07170109379916
R2973 n_2_7_14 n_2_7_15 4081.7003109804355
R2974 n_2_7_15 n_3_7_15 50469.336671138415
R2975 n_2_7_15 n_2_8_15 57904.9651367735
R2976 n_2_8_0 n_3_8_0 12.550205463809338
R2977 n_2_8_0 n_2_9_0 1626.121845108956
R2978 n_2_8_0 n_2_8_1 56.90875931090389
R2979 n_2_8_1 n_3_8_1 17.57028764933307
R2980 n_2_8_1 n_2_9_1 2276.5705831525383
R2981 n_2_8_1 n_2_8_2 129.33808934296343
R2982 n_2_8_2 n_3_8_2 31.37551365952334
R2983 n_2_8_2 n_2_9_2 4065.304612772389
R2984 n_2_8_2 n_2_8_3 121.06045162501376
R2985 n_2_8_3 n_3_8_3 439.25719123332635
R2986 n_2_8_3 n_2_9_3 56914.264578813396
R2987 n_2_8_3 n_2_8_4 1.6095406673791015
R2988 n_2_8_4 n_3_8_4 13.310823976767466
R2989 n_2_8_4 n_2_9_4 1724.6746842064667
R2990 n_2_8_4 n_2_8_5 1.3303346332419104
R2991 n_2_8_5 n_3_8_5 83.66803642539551
R2992 n_2_8_5 n_2_9_5 10840.812300726364
R2993 n_2_8_5 n_2_8_6 0.45986876210831473
R2994 n_2_8_6 n_3_8_6 13.944672737565918
R2995 n_2_8_6 n_2_9_6 1806.8020501210603
R2996 n_2_8_6 n_2_8_7 0.6241076057184265
R2997 n_2_8_7 n_3_8_7 23.90515326439879
R2998 n_2_8_7 n_2_9_7 3097.374943064685
R2999 n_2_8_7 n_2_8_8 0.4598687621083133
R3000 n_2_8_8 n_3_8_8 23.90515326439879
R3001 n_2_8_8 n_2_9_8 3097.374943064685
R3002 n_2_8_8 n_2_8_9 0.4598687621083133
R3003 n_2_8_9 n_3_8_9 23.90515326439879
R3004 n_2_8_9 n_2_9_9 3097.374943064685
R3005 n_2_8_9 n_2_8_10 0.4598687621083133
R3006 n_2_8_10 n_3_8_10 23.90515326439879
R3007 n_2_8_10 n_2_9_10 3097.374943064685
R3008 n_2_8_10 n_2_8_11 0.45986876210831035
R3009 n_2_8_11 n_3_8_11 23.905153264399097
R3010 n_2_8_11 n_2_9_11 3097.3749430647244
R3011 n_2_8_11 n_2_8_12 0.45986876210830885
R3012 n_2_8_12 n_3_8_12 23.90515326439894
R3013 n_2_8_12 n_2_9_12 3097.374943064704
R3014 n_2_8_12 n_2_8_13 0.4598687621083133
R3015 n_2_8_13 n_3_8_13 23.905153264398635
R3016 n_2_8_13 n_2_9_13 3097.3749430646653
R3017 n_2_8_13 n_2_8_14 2.2993438105415724
R3018 n_2_8_14 n_3_8_14 2.6561281404887485
R3019 n_2_8_14 n_2_9_14 344.15277145163094
R3020 n_2_8_14 n_2_8_15 71.04972374573524
R3021 n_2_8_15 n_3_8_15 878.514382466645
R3022 n_2_8_15 n_2_9_15 113828.5291576258
R3023 n_2_9_0 n_3_9_0 12.550205463809327
R3024 n_2_9_0 n_2_10_0 1626.121845108956
R3025 n_2_9_0 n_2_9_1 56.90875931090386
R3026 n_2_9_1 n_3_9_1 17.57028764933306
R3027 n_2_9_1 n_2_10_1 2276.5705831525383
R3028 n_2_9_1 n_2_9_2 129.33808934296331
R3029 n_2_9_2 n_3_9_2 31.37551365952332
R3030 n_2_9_2 n_2_10_2 4065.304612772389
R3031 n_2_9_2 n_2_9_3 121.06045162501366
R3032 n_2_9_3 n_3_9_3 439.2571912333261
R3033 n_2_9_3 n_2_10_3 56914.264578813396
R3034 n_2_9_3 n_2_9_4 1.6095406673791006
R3035 n_2_9_4 n_3_9_4 13.310823976767459
R3036 n_2_9_4 n_2_10_4 1724.6746842064667
R3037 n_2_9_4 n_2_9_5 1.3303346332419097
R3038 n_2_9_5 n_3_9_5 83.66803642539546
R3039 n_2_9_5 n_2_10_5 10840.812300726364
R3040 n_2_9_5 n_2_9_6 0.45986876210831445
R3041 n_2_9_6 n_3_9_6 13.944672737565908
R3042 n_2_9_6 n_2_10_6 1806.8020501210603
R3043 n_2_9_6 n_2_9_7 0.624107605718426
R3044 n_2_9_7 n_3_9_7 23.905153264398777
R3045 n_2_9_7 n_2_10_7 3097.374943064685
R3046 n_2_9_7 n_2_9_8 0.45986876210831296
R3047 n_2_9_8 n_3_9_8 23.905153264398777
R3048 n_2_9_8 n_2_10_8 3097.374943064685
R3049 n_2_9_8 n_2_9_9 0.45986876210831296
R3050 n_2_9_9 n_3_9_9 23.905153264398777
R3051 n_2_9_9 n_2_10_9 3097.374943064685
R3052 n_2_9_9 n_2_9_10 0.45986876210831296
R3053 n_2_9_10 n_3_9_10 23.905153264398777
R3054 n_2_9_10 n_2_10_10 3097.374943064685
R3055 n_2_9_10 n_2_9_11 0.45986876210831007
R3056 n_2_9_11 n_3_9_11 23.905153264399075
R3057 n_2_9_11 n_2_10_11 3097.3749430647244
R3058 n_2_9_11 n_2_9_12 0.45986876210830857
R3059 n_2_9_12 n_3_9_12 23.905153264398926
R3060 n_2_9_12 n_2_10_12 3097.374943064704
R3061 n_2_9_12 n_2_9_13 0.45986876210831296
R3062 n_2_9_13 n_3_9_13 23.90515326439862
R3063 n_2_9_13 n_2_10_13 3097.3749430646653
R3064 n_2_9_13 n_2_9_14 2.2993438105415707
R3065 n_2_9_14 n_3_9_14 2.656128140488747
R3066 n_2_9_14 n_2_10_14 344.15277145163094
R3067 n_2_9_14 n_2_9_15 71.04972374573519
R3068 n_2_9_15 n_3_9_15 878.5143824666445
R3069 n_2_9_15 n_2_10_15 113828.5291576258
R3070 n_2_10_0 n_3_10_0 12.550205463809338
R3071 n_2_10_0 n_2_11_0 1626.1218451089555
R3072 n_2_10_0 n_2_10_1 56.90875931090389
R3073 n_2_10_1 n_3_10_1 17.57028764933307
R3074 n_2_10_1 n_2_11_1 2276.5705831525374
R3075 n_2_10_1 n_2_10_2 129.33808934296343
R3076 n_2_10_2 n_3_10_2 31.37551365952334
R3077 n_2_10_2 n_2_11_2 4065.3046127723883
R3078 n_2_10_2 n_2_10_3 121.06045162501376
R3079 n_2_10_3 n_3_10_3 439.25719123332635
R3080 n_2_10_3 n_2_11_3 56914.26457881338
R3081 n_2_10_3 n_2_10_4 1.6095406673791015
R3082 n_2_10_4 n_3_10_4 13.310823976767466
R3083 n_2_10_4 n_2_11_4 1724.6746842064663
R3084 n_2_10_4 n_2_10_5 1.3303346332419104
R3085 n_2_10_5 n_3_10_5 83.66803642539551
R3086 n_2_10_5 n_2_11_5 10840.81230072636
R3087 n_2_10_5 n_2_10_6 0.45986876210831473
R3088 n_2_10_6 n_3_10_6 13.944672737565918
R3089 n_2_10_6 n_2_11_6 1806.80205012106
R3090 n_2_10_6 n_2_10_7 0.6241076057184265
R3091 n_2_10_7 n_3_10_7 23.90515326439879
R3092 n_2_10_7 n_2_11_7 3097.3749430646835
R3093 n_2_10_7 n_2_10_8 0.4598687621083133
R3094 n_2_10_8 n_3_10_8 23.90515326439879
R3095 n_2_10_8 n_2_11_8 3097.3749430646835
R3096 n_2_10_8 n_2_10_9 0.4598687621083133
R3097 n_2_10_9 n_3_10_9 23.90515326439879
R3098 n_2_10_9 n_2_11_9 3097.3749430646835
R3099 n_2_10_9 n_2_10_10 0.4598687621083133
R3100 n_2_10_10 n_3_10_10 23.90515326439879
R3101 n_2_10_10 n_2_11_10 3097.3749430646835
R3102 n_2_10_10 n_2_10_11 0.45986876210831035
R3103 n_2_10_11 n_3_10_11 23.905153264399097
R3104 n_2_10_11 n_2_11_11 3097.3749430647235
R3105 n_2_10_11 n_2_10_12 0.45986876210830885
R3106 n_2_10_12 n_3_10_12 23.90515326439894
R3107 n_2_10_12 n_2_11_12 3097.374943064703
R3108 n_2_10_12 n_2_10_13 0.4598687621083133
R3109 n_2_10_13 n_3_10_13 23.905153264398635
R3110 n_2_10_13 n_2_11_13 3097.3749430646644
R3111 n_2_10_13 n_2_10_14 2.2993438105415724
R3112 n_2_10_14 n_3_10_14 2.6561281404887485
R3113 n_2_10_14 n_2_11_14 344.1527714516308
R3114 n_2_10_14 n_2_10_15 71.04972374573524
R3115 n_2_10_15 n_3_10_15 878.514382466645
R3116 n_2_10_15 n_2_11_15 113828.52915762576
R3117 n_2_11_0 n_3_11_0 12.550205463809338
R3118 n_2_11_0 n_2_12_0 827.213811961146
R3119 n_2_11_0 n_2_11_1 56.90875931090389
R3120 n_2_11_1 n_3_11_1 17.57028764933307
R3121 n_2_11_1 n_2_12_1 1158.0993367456044
R3122 n_2_11_1 n_2_11_2 129.33808934296343
R3123 n_2_11_2 n_3_11_2 31.37551365952334
R3124 n_2_11_2 n_2_12_2 2068.034529902865
R3125 n_2_11_2 n_2_11_3 121.06045162501376
R3126 n_2_11_3 n_3_11_3 439.25719123332635
R3127 n_2_11_3 n_2_12_3 28952.48341864008
R3128 n_2_11_3 n_2_11_4 1.6095406673791015
R3129 n_2_11_4 n_3_11_4 13.310823976767466
R3130 n_2_11_4 n_2_12_4 877.3479823830328
R3131 n_2_11_4 n_2_11_5 1.3303346332419104
R3132 n_2_11_5 n_3_11_5 83.66803642539551
R3133 n_2_11_5 n_2_12_5 5514.758746407635
R3134 n_2_11_5 n_2_11_6 0.45986876210831473
R3135 n_2_11_6 n_3_11_6 13.944672737565918
R3136 n_2_11_6 n_2_12_6 919.1264577346058
R3137 n_2_11_6 n_2_11_7 0.6241076057184265
R3138 n_2_11_7 n_3_11_7 23.90515326439879
R3139 n_2_11_7 n_2_12_7 1575.645356116472
R3140 n_2_11_7 n_2_11_8 0.4598687621083133
R3141 n_2_11_8 n_3_11_8 23.90515326439879
R3142 n_2_11_8 n_2_12_8 1575.645356116472
R3143 n_2_11_8 n_2_11_9 0.4598687621083133
R3144 n_2_11_9 n_3_11_9 23.90515326439879
R3145 n_2_11_9 n_2_12_9 1575.645356116472
R3146 n_2_11_9 n_2_11_10 0.4598687621083133
R3147 n_2_11_10 n_3_11_10 23.90515326439879
R3148 n_2_11_10 n_2_12_10 1575.645356116472
R3149 n_2_11_10 n_2_11_11 0.45986876210831035
R3150 n_2_11_11 n_3_11_11 23.905153264399097
R3151 n_2_11_11 n_2_12_11 1575.6453561164922
R3152 n_2_11_11 n_2_11_12 0.45986876210830885
R3153 n_2_11_12 n_3_11_12 23.90515326439894
R3154 n_2_11_12 n_2_12_12 1575.645356116482
R3155 n_2_11_12 n_2_11_13 0.4598687621083133
R3156 n_2_11_13 n_3_11_13 23.905153264398635
R3157 n_2_11_13 n_2_12_13 1575.6453561164622
R3158 n_2_11_13 n_2_11_14 2.2993438105415724
R3159 n_2_11_14 n_3_11_14 2.6561281404887485
R3160 n_2_11_14 n_2_12_14 175.0717062351632
R3161 n_2_11_14 n_2_11_15 71.04972374573524
R3162 n_2_11_15 n_3_11_15 878.514382466645
R3163 n_2_11_15 n_2_12_15 57904.96683727965
R3164 n_2_12_0 n_3_12_0 720.9892863181211
R3165 n_2_12_0 n_2_13_0 28.305778813336573
R3166 n_2_12_0 n_2_12_1 3269.3174529402813
R3167 n_2_12_1 n_3_12_1 1009.3850008453696
R3168 n_2_12_1 n_2_13_1 39.6280903386712
R3169 n_2_12_1 n_2_12_2 7430.266938500638
R3170 n_2_12_2 n_3_12_2 1802.473215795303
R3171 n_2_12_2 n_2_13_2 70.76444703334143
R3172 n_2_12_2 n_2_12_3 6954.729854436598
R3173 n_2_12_3 n_3_12_3 25234.62502113422
R3174 n_2_12_3 n_2_13_3 990.7022584667791
R3175 n_2_12_3 n_2_12_4 92.46554412356359
R3176 n_2_12_4 n_3_12_4 764.6856067010369
R3177 n_2_12_4 n_2_13_4 30.02128055959937
R3178 n_2_12_4 n_2_12_5 76.42560279600663
R3179 n_2_12_5 n_3_12_5 4806.595242120803
R3180 n_2_12_5 n_2_13_5 188.70519208891034
R3181 n_2_12_5 n_2_12_6 26.418726892446735
R3182 n_2_12_6 n_3_12_6 801.0992070201339
R3183 n_2_12_6 n_2_13_6 31.45086534815172
R3184 n_2_12_6 n_2_12_7 35.85398649689196
R3185 n_2_12_7 n_3_12_7 1373.3129263202338
R3186 n_2_12_7 n_2_13_7 53.91576916826026
R3187 n_2_12_7 n_2_12_8 26.418726892446657
R3188 n_2_12_8 n_3_12_8 1373.3129263202338
R3189 n_2_12_8 n_2_13_8 53.91576916826026
R3190 n_2_12_8 n_2_12_9 26.418726892446657
R3191 n_2_12_9 n_3_12_9 1373.3129263202338
R3192 n_2_12_9 n_2_13_9 53.91576916826026
R3193 n_2_12_9 n_2_12_10 26.418726892446657
R3194 n_2_12_10 n_3_12_10 1373.3129263202338
R3195 n_2_12_10 n_2_13_10 53.91576916826026
R3196 n_2_12_10 n_2_12_11 26.418726892446486
R3197 n_2_12_11 n_3_12_11 1373.3129263202513
R3198 n_2_12_11 n_2_13_11 53.91576916826095
R3199 n_2_12_11 n_2_12_12 26.4187268924464
R3200 n_2_12_12 n_3_12_12 1373.3129263202427
R3201 n_2_12_12 n_2_13_12 53.915769168260596
R3202 n_2_12_12 n_2_12_13 26.418726892446657
R3203 n_2_12_13 n_3_12_13 1373.3129263202252
R3204 n_2_12_13 n_2_13_13 53.91576916825992
R3205 n_2_12_13 n_2_12_14 132.0936344622336
R3206 n_2_12_14 n_3_12_14 152.5903251466923
R3207 n_2_12_14 n_2_13_14 5.990641018695572
R3208 n_2_12_14 n_2_12_15 4081.693304883056
R3209 n_2_12_15 n_3_12_15 50469.25004226799
R3210 n_2_12_15 n_2_13_15 1981.4045169335407
R3211 n_2_13_0 n_3_13_0 720.9892863181211
R3212 n_2_13_0 n_2_14_0 28.305778813336573
R3213 n_2_13_0 n_2_13_1 3269.3174529402813
R3214 n_2_13_1 n_3_13_1 1009.3850008453696
R3215 n_2_13_1 n_2_14_1 39.6280903386712
R3216 n_2_13_1 n_2_13_2 7430.266938500638
R3217 n_2_13_2 n_3_13_2 1802.473215795303
R3218 n_2_13_2 n_2_14_2 70.76444703334143
R3219 n_2_13_2 n_2_13_3 6954.729854436598
R3220 n_2_13_3 n_3_13_3 25234.62502113422
R3221 n_2_13_3 n_2_14_3 990.7022584667791
R3222 n_2_13_3 n_2_13_4 92.46554412356359
R3223 n_2_13_4 n_3_13_4 764.6856067010369
R3224 n_2_13_4 n_2_14_4 30.02128055959937
R3225 n_2_13_4 n_2_13_5 76.42560279600663
R3226 n_2_13_5 n_3_13_5 4806.595242120803
R3227 n_2_13_5 n_2_14_5 188.70519208891034
R3228 n_2_13_5 n_2_13_6 26.418726892446735
R3229 n_2_13_6 n_3_13_6 801.0992070201339
R3230 n_2_13_6 n_2_14_6 31.45086534815172
R3231 n_2_13_6 n_2_13_7 35.85398649689196
R3232 n_2_13_7 n_3_13_7 1373.3129263202338
R3233 n_2_13_7 n_2_14_7 53.91576916826026
R3234 n_2_13_7 n_2_13_8 26.418726892446657
R3235 n_2_13_8 n_3_13_8 1373.3129263202338
R3236 n_2_13_8 n_2_14_8 53.91576916826026
R3237 n_2_13_8 n_2_13_9 26.418726892446657
R3238 n_2_13_9 n_3_13_9 1373.3129263202338
R3239 n_2_13_9 n_2_14_9 53.91576916826026
R3240 n_2_13_9 n_2_13_10 26.418726892446657
R3241 n_2_13_10 n_3_13_10 1373.3129263202338
R3242 n_2_13_10 n_2_14_10 53.91576916826026
R3243 n_2_13_10 n_2_13_11 26.418726892446486
R3244 n_2_13_11 n_3_13_11 1373.3129263202513
R3245 n_2_13_11 n_2_14_11 53.91576916826095
R3246 n_2_13_11 n_2_13_12 26.4187268924464
R3247 n_2_13_12 n_3_13_12 1373.3129263202427
R3248 n_2_13_12 n_2_14_12 53.915769168260596
R3249 n_2_13_12 n_2_13_13 26.418726892446657
R3250 n_2_13_13 n_3_13_13 1373.3129263202252
R3251 n_2_13_13 n_2_14_13 53.91576916825992
R3252 n_2_13_13 n_2_13_14 132.0936344622336
R3253 n_2_13_14 n_3_13_14 152.5903251466923
R3254 n_2_13_14 n_2_14_14 5.990641018695572
R3255 n_2_13_14 n_2_13_15 4081.693304883056
R3256 n_2_13_15 n_3_13_15 50469.25004226799
R3257 n_2_13_15 n_2_14_15 1981.4045169335407
R3258 n_2_14_0 n_3_14_0 720.9892863181211
R3259 n_2_14_0 n_2_15_0 28.305778813336573
R3260 n_2_14_0 n_2_14_1 3269.3174529402813
R3261 n_2_14_1 n_3_14_1 1009.3850008453696
R3262 n_2_14_1 n_2_15_1 39.6280903386712
R3263 n_2_14_1 n_2_14_2 7430.266938500638
R3264 n_2_14_2 n_3_14_2 1802.473215795303
R3265 n_2_14_2 n_2_15_2 70.76444703334143
R3266 n_2_14_2 n_2_14_3 6954.729854436598
R3267 n_2_14_3 n_3_14_3 25234.62502113422
R3268 n_2_14_3 n_2_15_3 990.7022584667791
R3269 n_2_14_3 n_2_14_4 92.46554412356359
R3270 n_2_14_4 n_3_14_4 764.6856067010369
R3271 n_2_14_4 n_2_15_4 30.02128055959937
R3272 n_2_14_4 n_2_14_5 76.42560279600663
R3273 n_2_14_5 n_3_14_5 4806.595242120803
R3274 n_2_14_5 n_2_15_5 188.70519208891034
R3275 n_2_14_5 n_2_14_6 26.418726892446735
R3276 n_2_14_6 n_3_14_6 801.0992070201339
R3277 n_2_14_6 n_2_15_6 31.45086534815172
R3278 n_2_14_6 n_2_14_7 35.85398649689196
R3279 n_2_14_7 n_3_14_7 1373.3129263202338
R3280 n_2_14_7 n_2_15_7 53.91576916826026
R3281 n_2_14_7 n_2_14_8 26.418726892446657
R3282 n_2_14_8 n_3_14_8 1373.3129263202338
R3283 n_2_14_8 n_2_15_8 53.91576916826026
R3284 n_2_14_8 n_2_14_9 26.418726892446657
R3285 n_2_14_9 n_3_14_9 1373.3129263202338
R3286 n_2_14_9 n_2_15_9 53.91576916826026
R3287 n_2_14_9 n_2_14_10 26.418726892446657
R3288 n_2_14_10 n_3_14_10 1373.3129263202338
R3289 n_2_14_10 n_2_15_10 53.91576916826026
R3290 n_2_14_10 n_2_14_11 26.418726892446486
R3291 n_2_14_11 n_3_14_11 1373.3129263202513
R3292 n_2_14_11 n_2_15_11 53.91576916826095
R3293 n_2_14_11 n_2_14_12 26.4187268924464
R3294 n_2_14_12 n_3_14_12 1373.3129263202427
R3295 n_2_14_12 n_2_15_12 53.915769168260596
R3296 n_2_14_12 n_2_14_13 26.418726892446657
R3297 n_2_14_13 n_3_14_13 1373.3129263202252
R3298 n_2_14_13 n_2_15_13 53.91576916825992
R3299 n_2_14_13 n_2_14_14 132.0936344622336
R3300 n_2_14_14 n_3_14_14 152.5903251466923
R3301 n_2_14_14 n_2_15_14 5.990641018695572
R3302 n_2_14_14 n_2_14_15 4081.693304883056
R3303 n_2_14_15 n_3_14_15 50469.25004226799
R3304 n_2_14_15 n_2_15_15 1981.4045169335407
R3305 n_2_15_0 n_3_15_0 720.9892863181211
R3306 n_2_15_0 n_2_16_0 827.2138119611454
R3307 n_2_15_0 n_2_15_1 3269.3174529402813
R3308 n_2_15_1 n_3_15_1 1009.3850008453696
R3309 n_2_15_1 n_2_16_1 1158.0993367456035
R3310 n_2_15_1 n_2_15_2 7430.266938500638
R3311 n_2_15_2 n_3_15_2 1802.473215795303
R3312 n_2_15_2 n_2_16_2 2068.0345299028636
R3313 n_2_15_2 n_2_15_3 6954.729854436598
R3314 n_2_15_3 n_3_15_3 25234.62502113422
R3315 n_2_15_3 n_2_16_3 28952.483418640062
R3316 n_2_15_3 n_2_15_4 92.46554412356359
R3317 n_2_15_4 n_3_15_4 764.6856067010369
R3318 n_2_15_4 n_2_16_4 877.3479823830322
R3319 n_2_15_4 n_2_15_5 76.42560279600663
R3320 n_2_15_5 n_3_15_5 4806.595242120803
R3321 n_2_15_5 n_2_16_5 5514.758746407631
R3322 n_2_15_5 n_2_15_6 26.418726892446735
R3323 n_2_15_6 n_3_15_6 801.0992070201339
R3324 n_2_15_6 n_2_16_6 919.1264577346052
R3325 n_2_15_6 n_2_15_7 35.85398649689196
R3326 n_2_15_7 n_3_15_7 1373.3129263202338
R3327 n_2_15_7 n_2_16_7 1575.645356116471
R3328 n_2_15_7 n_2_15_8 26.418726892446657
R3329 n_2_15_8 n_3_15_8 1373.3129263202338
R3330 n_2_15_8 n_2_16_8 1575.645356116471
R3331 n_2_15_8 n_2_15_9 26.418726892446657
R3332 n_2_15_9 n_3_15_9 1373.3129263202338
R3333 n_2_15_9 n_2_16_9 1575.645356116471
R3334 n_2_15_9 n_2_15_10 26.418726892446657
R3335 n_2_15_10 n_3_15_10 1373.3129263202338
R3336 n_2_15_10 n_2_16_10 1575.645356116471
R3337 n_2_15_10 n_2_15_11 26.418726892446486
R3338 n_2_15_11 n_3_15_11 1373.3129263202513
R3339 n_2_15_11 n_2_16_11 1575.645356116491
R3340 n_2_15_11 n_2_15_12 26.4187268924464
R3341 n_2_15_12 n_3_15_12 1373.3129263202427
R3342 n_2_15_12 n_2_16_12 1575.645356116481
R3343 n_2_15_12 n_2_15_13 26.418726892446657
R3344 n_2_15_13 n_3_15_13 1373.3129263202252
R3345 n_2_15_13 n_2_16_13 1575.6453561164612
R3346 n_2_15_13 n_2_15_14 132.0936344622336
R3347 n_2_15_14 n_3_15_14 152.5903251466923
R3348 n_2_15_14 n_2_16_14 175.07170623516308
R3349 n_2_15_14 n_2_15_15 4081.693304883056
R3350 n_2_15_15 n_3_15_15 50469.25004226799
R3351 n_2_15_15 n_2_16_15 57904.966837279615
R3352 n_2_16_0 n_3_16_0 12.550205463809345
R3353 n_2_16_0 n_2_17_0 1626.1218451089553
R3354 n_2_16_0 n_2_16_1 56.908759310903925
R3355 n_2_16_1 n_3_16_1 17.570287649333082
R3356 n_2_16_1 n_2_17_1 2276.5705831525374
R3357 n_2_16_1 n_2_16_2 129.33808934296349
R3358 n_2_16_2 n_3_16_2 31.37551365952336
R3359 n_2_16_2 n_2_17_2 4065.3046127723883
R3360 n_2_16_2 n_2_16_3 121.06045162501383
R3361 n_2_16_3 n_3_16_3 439.2571912333266
R3362 n_2_16_3 n_2_17_3 56914.26457881338
R3363 n_2_16_3 n_2_16_4 1.6095406673791026
R3364 n_2_16_4 n_3_16_4 13.310823976767473
R3365 n_2_16_4 n_2_17_4 1724.6746842064663
R3366 n_2_16_4 n_2_16_5 1.3303346332419115
R3367 n_2_16_5 n_3_16_5 83.66803642539556
R3368 n_2_16_5 n_2_17_5 10840.81230072636
R3369 n_2_16_5 n_2_16_6 0.45986876210831507
R3370 n_2_16_6 n_3_16_6 13.944672737565927
R3371 n_2_16_6 n_2_17_6 1806.80205012106
R3372 n_2_16_6 n_2_16_7 0.6241076057184269
R3373 n_2_16_7 n_3_16_7 23.9051532643988
R3374 n_2_16_7 n_2_17_7 3097.374943064684
R3375 n_2_16_7 n_2_16_8 0.4598687621083136
R3376 n_2_16_8 n_3_16_8 23.9051532643988
R3377 n_2_16_8 n_2_17_8 3097.374943064684
R3378 n_2_16_8 n_2_16_9 0.4598687621083136
R3379 n_2_16_9 n_3_16_9 23.9051532643988
R3380 n_2_16_9 n_2_17_9 3097.374943064684
R3381 n_2_16_9 n_2_16_10 0.4598687621083136
R3382 n_2_16_10 n_3_16_10 23.9051532643988
R3383 n_2_16_10 n_2_17_10 3097.374943064684
R3384 n_2_16_10 n_2_16_11 0.4598687621083107
R3385 n_2_16_11 n_3_16_11 23.90515326439911
R3386 n_2_16_11 n_2_17_11 3097.374943064723
R3387 n_2_16_11 n_2_16_12 0.4598687621083092
R3388 n_2_16_12 n_3_16_12 23.905153264398955
R3389 n_2_16_12 n_2_17_12 3097.374943064703
R3390 n_2_16_12 n_2_16_13 0.4598687621083136
R3391 n_2_16_13 n_3_16_13 23.90515326439865
R3392 n_2_16_13 n_2_17_13 3097.3749430646644
R3393 n_2_16_13 n_2_16_14 2.2993438105415738
R3394 n_2_16_14 n_3_16_14 2.6561281404887502
R3395 n_2_16_14 n_2_17_14 344.1527714516308
R3396 n_2_16_14 n_2_16_15 71.04972374573529
R3397 n_2_16_15 n_3_16_15 878.5143824666454
R3398 n_2_16_15 n_2_17_15 113828.52915762576
R3399 n_2_17_0 n_3_17_0 12.550205463809327
R3400 n_2_17_0 n_2_18_0 1626.1218451089564
R3401 n_2_17_0 n_2_17_1 56.90875931090386
R3402 n_2_17_1 n_3_17_1 17.57028764933306
R3403 n_2_17_1 n_2_18_1 2276.570583152539
R3404 n_2_17_1 n_2_17_2 129.33808934296331
R3405 n_2_17_2 n_3_17_2 31.37551365952332
R3406 n_2_17_2 n_2_18_2 4065.3046127723906
R3407 n_2_17_2 n_2_17_3 121.06045162501366
R3408 n_2_17_3 n_3_17_3 439.2571912333261
R3409 n_2_17_3 n_2_18_3 56914.26457881341
R3410 n_2_17_3 n_2_17_4 1.6095406673791006
R3411 n_2_17_4 n_3_17_4 13.310823976767459
R3412 n_2_17_4 n_2_18_4 1724.6746842064672
R3413 n_2_17_4 n_2_17_5 1.3303346332419097
R3414 n_2_17_5 n_3_17_5 83.66803642539546
R3415 n_2_17_5 n_2_18_5 10840.812300726366
R3416 n_2_17_5 n_2_17_6 0.45986876210831445
R3417 n_2_17_6 n_3_17_6 13.944672737565908
R3418 n_2_17_6 n_2_18_6 1806.802050121061
R3419 n_2_17_6 n_2_17_7 0.624107605718426
R3420 n_2_17_7 n_3_17_7 23.905153264398777
R3421 n_2_17_7 n_2_18_7 3097.374943064686
R3422 n_2_17_7 n_2_17_8 0.45986876210831296
R3423 n_2_17_8 n_3_17_8 23.905153264398777
R3424 n_2_17_8 n_2_18_8 3097.374943064686
R3425 n_2_17_8 n_2_17_9 0.45986876210831296
R3426 n_2_17_9 n_3_17_9 23.905153264398777
R3427 n_2_17_9 n_2_18_9 3097.374943064686
R3428 n_2_17_9 n_2_17_10 0.45986876210831296
R3429 n_2_17_10 n_3_17_10 23.905153264398777
R3430 n_2_17_10 n_2_18_10 3097.374943064686
R3431 n_2_17_10 n_2_17_11 0.45986876210831007
R3432 n_2_17_11 n_3_17_11 23.905153264399075
R3433 n_2_17_11 n_2_18_11 3097.3749430647254
R3434 n_2_17_11 n_2_17_12 0.45986876210830857
R3435 n_2_17_12 n_3_17_12 23.905153264398926
R3436 n_2_17_12 n_2_18_12 3097.374943064705
R3437 n_2_17_12 n_2_17_13 0.45986876210831296
R3438 n_2_17_13 n_3_17_13 23.90515326439862
R3439 n_2_17_13 n_2_18_13 3097.3749430646662
R3440 n_2_17_13 n_2_17_14 2.2993438105415707
R3441 n_2_17_14 n_3_17_14 2.656128140488747
R3442 n_2_17_14 n_2_18_14 344.15277145163105
R3443 n_2_17_14 n_2_17_15 71.04972374573519
R3444 n_2_17_15 n_3_17_15 878.5143824666445
R3445 n_2_17_15 n_2_18_15 113828.52915762583
R3446 n_2_18_0 n_3_18_0 12.550205463809327
R3447 n_2_18_0 n_2_19_0 1626.1218451089553
R3448 n_2_18_0 n_2_18_1 56.90875931090386
R3449 n_2_18_1 n_3_18_1 17.57028764933306
R3450 n_2_18_1 n_2_19_1 2276.5705831525374
R3451 n_2_18_1 n_2_18_2 129.33808934296331
R3452 n_2_18_2 n_3_18_2 31.37551365952332
R3453 n_2_18_2 n_2_19_2 4065.3046127723883
R3454 n_2_18_2 n_2_18_3 121.06045162501366
R3455 n_2_18_3 n_3_18_3 439.2571912333261
R3456 n_2_18_3 n_2_19_3 56914.26457881338
R3457 n_2_18_3 n_2_18_4 1.6095406673791006
R3458 n_2_18_4 n_3_18_4 13.310823976767459
R3459 n_2_18_4 n_2_19_4 1724.6746842064663
R3460 n_2_18_4 n_2_18_5 1.3303346332419097
R3461 n_2_18_5 n_3_18_5 83.66803642539546
R3462 n_2_18_5 n_2_19_5 10840.81230072636
R3463 n_2_18_5 n_2_18_6 0.45986876210831445
R3464 n_2_18_6 n_3_18_6 13.944672737565908
R3465 n_2_18_6 n_2_19_6 1806.80205012106
R3466 n_2_18_6 n_2_18_7 0.624107605718426
R3467 n_2_18_7 n_3_18_7 23.905153264398777
R3468 n_2_18_7 n_2_19_7 3097.374943064684
R3469 n_2_18_7 n_2_18_8 0.45986876210831296
R3470 n_2_18_8 n_3_18_8 23.905153264398777
R3471 n_2_18_8 n_2_19_8 3097.374943064684
R3472 n_2_18_8 n_2_18_9 0.45986876210831296
R3473 n_2_18_9 n_3_18_9 23.905153264398777
R3474 n_2_18_9 n_2_19_9 3097.374943064684
R3475 n_2_18_9 n_2_18_10 0.45986876210831296
R3476 n_2_18_10 n_3_18_10 23.905153264398777
R3477 n_2_18_10 n_2_19_10 3097.374943064684
R3478 n_2_18_10 n_2_18_11 0.45986876210831007
R3479 n_2_18_11 n_3_18_11 23.905153264399075
R3480 n_2_18_11 n_2_19_11 3097.374943064723
R3481 n_2_18_11 n_2_18_12 0.45986876210830857
R3482 n_2_18_12 n_3_18_12 23.905153264398926
R3483 n_2_18_12 n_2_19_12 3097.374943064703
R3484 n_2_18_12 n_2_18_13 0.45986876210831296
R3485 n_2_18_13 n_3_18_13 23.90515326439862
R3486 n_2_18_13 n_2_19_13 3097.3749430646644
R3487 n_2_18_13 n_2_18_14 2.2993438105415707
R3488 n_2_18_14 n_3_18_14 2.656128140488747
R3489 n_2_18_14 n_2_19_14 344.1527714516308
R3490 n_2_18_14 n_2_18_15 71.04972374573519
R3491 n_2_18_15 n_3_18_15 878.5143824666445
R3492 n_2_18_15 n_2_19_15 113828.52915762576
R3493 n_2_19_0 n_3_19_0 12.550205463809345
R3494 n_2_19_0 n_2_20_0 827.2138145479917
R3495 n_2_19_0 n_2_19_1 56.908759310903925
R3496 n_2_19_1 n_3_19_1 17.570287649333082
R3497 n_2_19_1 n_2_20_1 1158.0993403671882
R3498 n_2_19_1 n_2_19_2 129.33808934296349
R3499 n_2_19_2 n_3_19_2 31.37551365952336
R3500 n_2_19_2 n_2_20_2 2068.034536369979
R3501 n_2_19_2 n_2_19_3 121.06045162501383
R3502 n_2_19_3 n_3_19_3 439.2571912333266
R3503 n_2_19_3 n_2_20_3 28952.483509179678
R3504 n_2_19_3 n_2_19_4 1.6095406673791026
R3505 n_2_19_4 n_3_19_4 13.310823976767473
R3506 n_2_19_4 n_2_20_4 877.347985126657
R3507 n_2_19_4 n_2_19_5 1.3303346332419115
R3508 n_2_19_5 n_3_19_5 83.66803642539556
R3509 n_2_19_5 n_2_20_5 5514.7587636532735
R3510 n_2_19_5 n_2_19_6 0.45986876210831507
R3511 n_2_19_6 n_3_19_6 13.944672737565927
R3512 n_2_19_6 n_2_20_6 919.1264606088788
R3513 n_2_19_6 n_2_19_7 0.6241076057184269
R3514 n_2_19_7 n_3_19_7 23.9051532643988
R3515 n_2_19_7 n_2_20_7 1575.645361043797
R3516 n_2_19_7 n_2_19_8 0.4598687621083136
R3517 n_2_19_8 n_3_19_8 23.9051532643988
R3518 n_2_19_8 n_2_20_8 1575.645361043797
R3519 n_2_19_8 n_2_19_9 0.4598687621083136
R3520 n_2_19_9 n_3_19_9 23.9051532643988
R3521 n_2_19_9 n_2_20_9 1575.645361043797
R3522 n_2_19_9 n_2_19_10 0.4598687621083136
R3523 n_2_19_10 n_3_19_10 23.9051532643988
R3524 n_2_19_10 n_2_20_10 1575.645361043797
R3525 n_2_19_10 n_2_19_11 0.4598687621083107
R3526 n_2_19_11 n_3_19_11 23.90515326439911
R3527 n_2_19_11 n_2_20_11 1575.6453610438173
R3528 n_2_19_11 n_2_19_12 0.4598687621083092
R3529 n_2_19_12 n_3_19_12 23.905153264398955
R3530 n_2_19_12 n_2_20_12 1575.645361043807
R3531 n_2_19_12 n_2_19_13 0.4598687621083136
R3532 n_2_19_13 n_3_19_13 23.90515326439865
R3533 n_2_19_13 n_2_20_13 1575.6453610437873
R3534 n_2_19_13 n_2_19_14 2.2993438105415738
R3535 n_2_19_14 n_3_19_14 2.6561281404887502
R3536 n_2_19_14 n_2_20_14 175.07170678264376
R3537 n_2_19_14 n_2_19_15 71.04972374573529
R3538 n_2_19_15 n_3_19_15 878.5143824666454
R3539 n_2_19_15 n_2_20_15 57904.967018358846
R3540 n_2_20_0 n_3_20_0 720.9891545366872
R3541 n_2_20_0 n_2_21_0 28.30578398702899
R3542 n_2_20_0 n_2_20_1 3269.316855378916
R3543 n_2_20_1 n_3_20_1 1009.384816351362
R3544 n_2_20_1 n_2_21_1 39.62809758184058
R3545 n_2_20_1 n_2_20_2 7430.265580406627
R3546 n_2_20_2 n_3_20_2 1802.4728863417183
R3547 n_2_20_2 n_2_21_2 70.76445996757246
R3548 n_2_20_2 n_2_20_3 6954.728583260603
R3549 n_2_20_3 n_3_20_3 25234.62040878403
R3550 n_2_20_3 n_2_21_3 990.7024395460135
R3551 n_2_20_3 n_2_20_4 92.46552722283812
R3552 n_2_20_4 n_3_20_4 764.6854669328495
R3553 n_2_20_4 n_2_21_4 30.021286046848896
R3554 n_2_20_4 n_2_20_5 76.42558882703966
R3555 n_2_20_5 n_3_20_5 4806.59436357791
R3556 n_2_20_5 n_2_21_5 188.70522658019308
R3557 n_2_20_5 n_2_20_6 26.41872206366803
R3558 n_2_20_6 n_3_20_6 801.0990605963184
R3559 n_2_20_6 n_2_21_6 31.450871096698847
R3560 n_2_20_6 n_2_20_7 35.853979943549426
R3561 n_2_20_7 n_3_20_7 1373.3126753079787
R3562 n_2_20_7 n_2_21_7 53.915779022912474
R3563 n_2_20_7 n_2_20_8 26.418722063667946
R3564 n_2_20_8 n_3_20_8 1373.3126753079787
R3565 n_2_20_8 n_2_21_8 53.915779022912474
R3566 n_2_20_8 n_2_20_9 26.418722063667946
R3567 n_2_20_9 n_3_20_9 1373.3126753079787
R3568 n_2_20_9 n_2_21_9 53.915779022912474
R3569 n_2_20_9 n_2_20_10 26.418722063667946
R3570 n_2_20_10 n_3_20_10 1373.3126753079787
R3571 n_2_20_10 n_2_21_10 53.915779022912474
R3572 n_2_20_10 n_2_20_11 26.41872206366778
R3573 n_2_20_11 n_3_20_11 1373.3126753079964
R3574 n_2_20_11 n_2_21_11 53.91577902291316
R3575 n_2_20_11 n_2_20_12 26.418722063667694
R3576 n_2_20_12 n_3_20_12 1373.3126753079873
R3577 n_2_20_12 n_2_21_12 53.915779022912815
R3578 n_2_20_12 n_2_20_13 26.41872206366795
R3579 n_2_20_13 n_3_20_13 1373.31267530797
R3580 n_2_20_13 n_2_21_13 53.91577902291213
R3581 n_2_20_13 n_2_20_14 132.09361031834007
R3582 n_2_20_14 n_3_20_14 152.59029725644177
R3583 n_2_20_14 n_2_21_14 5.9906421136569294
R3584 n_2_20_14 n_2_20_15 4081.692558836746
R3585 n_2_20_15 n_3_20_15 50469.24081756761
R3586 n_2_20_15 n_2_21_15 1981.4048790920097
R3587 n_2_21_0 n_3_21_0 720.9891545366872
R3588 n_2_21_0 n_2_22_0 28.305783987027983
R3589 n_2_21_0 n_2_21_1 3269.316855378916
R3590 n_2_21_1 n_3_21_1 1009.384816351362
R3591 n_2_21_1 n_2_22_1 39.62809758183917
R3592 n_2_21_1 n_2_21_2 7430.265580406627
R3593 n_2_21_2 n_3_21_2 1802.4728863417183
R3594 n_2_21_2 n_2_22_2 70.76445996756995
R3595 n_2_21_2 n_2_21_3 6954.728583260603
R3596 n_2_21_3 n_3_21_3 25234.62040878403
R3597 n_2_21_3 n_2_22_3 990.7024395459782
R3598 n_2_21_3 n_2_21_4 92.46552722283812
R3599 n_2_21_4 n_3_21_4 764.6854669328495
R3600 n_2_21_4 n_2_22_4 30.02128604684783
R3601 n_2_21_4 n_2_21_5 76.42558882703966
R3602 n_2_21_5 n_3_21_5 4806.59436357791
R3603 n_2_21_5 n_2_22_5 188.70522658018638
R3604 n_2_21_5 n_2_21_6 26.41872206366803
R3605 n_2_21_6 n_3_21_6 801.0990605963184
R3606 n_2_21_6 n_2_22_6 31.450871096697732
R3607 n_2_21_6 n_2_21_7 35.853979943549426
R3608 n_2_21_7 n_3_21_7 1373.3126753079787
R3609 n_2_21_7 n_2_22_7 53.915779022910556
R3610 n_2_21_7 n_2_21_8 26.418722063667946
R3611 n_2_21_8 n_3_21_8 1373.3126753079787
R3612 n_2_21_8 n_2_22_8 53.915779022910556
R3613 n_2_21_8 n_2_21_9 26.418722063667946
R3614 n_2_21_9 n_3_21_9 1373.3126753079787
R3615 n_2_21_9 n_2_22_9 53.915779022910556
R3616 n_2_21_9 n_2_21_10 26.418722063667946
R3617 n_2_21_10 n_3_21_10 1373.3126753079787
R3618 n_2_21_10 n_2_22_10 53.915779022910556
R3619 n_2_21_10 n_2_21_11 26.41872206366778
R3620 n_2_21_11 n_3_21_11 1373.3126753079964
R3621 n_2_21_11 n_2_22_11 53.91577902291125
R3622 n_2_21_11 n_2_21_12 26.418722063667694
R3623 n_2_21_12 n_3_21_12 1373.3126753079873
R3624 n_2_21_12 n_2_22_12 53.9157790229109
R3625 n_2_21_12 n_2_21_13 26.41872206366795
R3626 n_2_21_13 n_3_21_13 1373.31267530797
R3627 n_2_21_13 n_2_22_13 53.915779022910215
R3628 n_2_21_13 n_2_21_14 132.09361031834007
R3629 n_2_21_14 n_3_21_14 152.59029725644177
R3630 n_2_21_14 n_2_22_14 5.990642113656717
R3631 n_2_21_14 n_2_21_15 4081.692558836746
R3632 n_2_21_15 n_3_21_15 50469.24081756761
R3633 n_2_21_15 n_2_22_15 1981.4048790919392
R3634 n_2_22_0 n_3_22_0 720.9891545367384
R3635 n_2_22_0 n_2_23_0 28.305783987027983
R3636 n_2_22_0 n_2_22_1 3269.316855379149
R3637 n_2_22_1 n_3_22_1 1009.3848163514338
R3638 n_2_22_1 n_2_23_1 39.62809758183917
R3639 n_2_22_1 n_2_22_2 7430.2655804071555
R3640 n_2_22_2 n_3_22_2 1802.472886341846
R3641 n_2_22_2 n_2_23_2 70.76445996756995
R3642 n_2_22_2 n_2_22_3 6954.728583261098
R3643 n_2_22_3 n_3_22_3 25234.62040878582
R3644 n_2_22_3 n_2_23_3 990.7024395459782
R3645 n_2_22_3 n_2_22_4 92.4655272228447
R3646 n_2_22_4 n_3_22_4 764.6854669329036
R3647 n_2_22_4 n_2_23_4 30.02128604684783
R3648 n_2_22_4 n_2_22_5 76.4255888270451
R3649 n_2_22_5 n_3_22_5 4806.594363578251
R3650 n_2_22_5 n_2_23_5 188.70522658018638
R3651 n_2_22_5 n_2_22_6 26.41872206366991
R3652 n_2_22_6 n_3_22_6 801.0990605963752
R3653 n_2_22_6 n_2_23_6 31.450871096697732
R3654 n_2_22_6 n_2_22_7 35.853979943551984
R3655 n_2_22_7 n_3_22_7 1373.3126753080765
R3656 n_2_22_7 n_2_23_7 53.915779022910556
R3657 n_2_22_7 n_2_22_8 26.41872206366983
R3658 n_2_22_8 n_3_22_8 1373.3126753080765
R3659 n_2_22_8 n_2_23_8 53.915779022910556
R3660 n_2_22_8 n_2_22_9 26.41872206366983
R3661 n_2_22_9 n_3_22_9 1373.3126753080765
R3662 n_2_22_9 n_2_23_9 53.915779022910556
R3663 n_2_22_9 n_2_22_10 26.41872206366983
R3664 n_2_22_10 n_3_22_10 1373.3126753080765
R3665 n_2_22_10 n_2_23_10 53.915779022910556
R3666 n_2_22_10 n_2_22_11 26.418722063669662
R3667 n_2_22_11 n_3_22_11 1373.3126753080937
R3668 n_2_22_11 n_2_23_11 53.91577902291125
R3669 n_2_22_11 n_2_22_12 26.418722063669577
R3670 n_2_22_12 n_3_22_12 1373.312675308085
R3671 n_2_22_12 n_2_23_12 53.9157790229109
R3672 n_2_22_12 n_2_22_13 26.418722063669833
R3673 n_2_22_13 n_3_22_13 1373.3126753080676
R3674 n_2_22_13 n_2_23_13 53.915779022910215
R3675 n_2_22_13 n_2_22_14 132.09361031834948
R3676 n_2_22_14 n_3_22_14 152.5902972564526
R3677 n_2_22_14 n_2_23_14 5.990642113656717
R3678 n_2_22_14 n_2_22_15 4081.6925588370364
R3679 n_2_22_15 n_3_22_15 50469.24081757119
R3680 n_2_22_15 n_2_23_15 1981.4048790919392
R3681 n_2_23_0 n_3_23_0 720.9891545366872
R3682 n_2_23_0 n_2_24_0 326.2736359366233
R3683 n_2_23_0 n_2_23_1 3269.316855378916
R3684 n_2_23_1 n_3_23_1 1009.384816351362
R3685 n_2_23_1 n_2_24_1 456.78309031127253
R3686 n_2_23_1 n_2_23_2 7430.265580406627
R3687 n_2_23_2 n_3_23_2 1802.4728863417183
R3688 n_2_23_2 n_2_24_2 815.6840898415581
R3689 n_2_23_2 n_2_23_3 6954.728583260603
R3690 n_2_23_3 n_3_23_3 25234.62040878403
R3691 n_2_23_3 n_2_24_3 11419.577257781802
R3692 n_2_23_3 n_2_23_4 92.46552722283812
R3693 n_2_23_4 n_3_23_4 764.6854669328495
R3694 n_2_23_4 n_2_24_4 346.0477956903577
R3695 n_2_23_4 n_2_23_5 76.42558882703966
R3696 n_2_23_5 n_3_23_5 4806.59436357791
R3697 n_2_23_5 n_2_24_5 2175.15757291082
R3698 n_2_23_5 n_2_23_6 26.41872206366803
R3699 n_2_23_6 n_3_23_6 801.0990605963184
R3700 n_2_23_6 n_2_24_6 362.52626215180334
R3701 n_2_23_6 n_2_23_7 35.853979943549426
R3702 n_2_23_7 n_3_23_7 1373.3126753079787
R3703 n_2_23_7 n_2_24_7 621.4735922602362
R3704 n_2_23_7 n_2_23_8 26.418722063667946
R3705 n_2_23_8 n_3_23_8 1373.3126753079787
R3706 n_2_23_8 n_2_24_8 621.4735922602362
R3707 n_2_23_8 n_2_23_9 26.418722063667946
R3708 n_2_23_9 n_3_23_9 1373.3126753079787
R3709 n_2_23_9 n_2_24_9 621.4735922602362
R3710 n_2_23_9 n_2_23_10 26.418722063667946
R3711 n_2_23_10 n_3_23_10 1373.3126753079787
R3712 n_2_23_10 n_2_24_10 621.4735922602362
R3713 n_2_23_10 n_2_23_11 26.41872206366778
R3714 n_2_23_11 n_3_23_11 1373.3126753079964
R3715 n_2_23_11 n_2_24_11 621.4735922602441
R3716 n_2_23_11 n_2_23_12 26.418722063667694
R3717 n_2_23_12 n_3_23_12 1373.3126753079873
R3718 n_2_23_12 n_2_24_12 621.4735922602401
R3719 n_2_23_12 n_2_23_13 26.41872206366795
R3720 n_2_23_13 n_3_23_13 1373.31267530797
R3721 n_2_23_13 n_2_24_13 621.4735922602323
R3722 n_2_23_13 n_2_23_14 132.09361031834007
R3723 n_2_23_14 n_3_23_14 152.59029725644177
R3724 n_2_23_14 n_2_24_14 69.05262136224832
R3725 n_2_23_14 n_2_23_15 4081.692558836746
R3726 n_2_23_15 n_3_23_15 50469.24081756761
R3727 n_2_23_15 n_2_24_15 22839.15451556341
R3728 n_2_24_0 n_3_24_0 32.692737764693376
R3729 n_2_24_0 n_2_25_0 624.2414878862166
R3730 n_2_24_0 n_2_24_1 148.24483551528402
R3731 n_2_24_1 n_3_24_1 45.769832870570724
R3732 n_2_24_1 n_2_25_1 873.9380830407031
R3733 n_2_24_1 n_2_24_2 336.9200807165546
R3734 n_2_24_2 n_3_24_2 81.73184441173345
R3735 n_2_24_2 n_2_25_2 1560.6037197155415
R3736 n_2_24_2 n_2_24_3 315.3571955506951
R3737 n_2_24_3 n_3_24_3 1144.2458217642672
R3738 n_2_24_3 n_2_25_3 21848.45207601756
R3739 n_2_24_3 n_2_24_4 4.192783226694905
R3740 n_2_24_4 n_3_24_4 34.6741158110384
R3741 n_2_24_4 n_2_25_4 662.0743053338655
R3742 n_2_24_4 n_2_24_5 3.4654636873702787
R3743 n_2_24_5 n_3_24_5 217.95158509795567
R3744 n_2_24_5 n_2_25_5 4161.60991924144
R3745 n_2_24_5 n_2_24_6 1.1979380647699729
R3746 n_2_24_6 n_3_24_6 36.32526418299261
R3747 n_2_24_6 n_2_25_6 693.6016532069068
R3748 n_2_24_6 n_2_24_7 1.6257730879021042
R3749 n_2_24_7 n_3_24_7 62.27188145655895
R3750 n_2_24_7 n_2_25_7 1189.031405497558
R3751 n_2_24_7 n_2_24_8 1.1979380647699691
R3752 n_2_24_8 n_3_24_8 62.27188145655895
R3753 n_2_24_8 n_2_25_8 1189.031405497558
R3754 n_2_24_8 n_2_24_9 1.1979380647699691
R3755 n_2_24_9 n_3_24_9 62.27188145655895
R3756 n_2_24_9 n_2_25_9 1189.031405497558
R3757 n_2_24_9 n_2_24_10 1.1979380647699691
R3758 n_2_24_10 n_3_24_10 62.27188145655895
R3759 n_2_24_10 n_2_25_10 1189.031405497558
R3760 n_2_24_10 n_2_24_11 1.1979380647699616
R3761 n_2_24_11 n_3_24_11 62.27188145655974
R3762 n_2_24_11 n_2_25_11 1189.0314054975734
R3763 n_2_24_11 n_2_24_12 1.1979380647699576
R3764 n_2_24_12 n_3_24_12 62.271881456559356
R3765 n_2_24_12 n_2_25_12 1189.0314054975656
R3766 n_2_24_12 n_2_24_13 1.1979380647699691
R3767 n_2_24_13 n_3_24_13 62.27188145655856
R3768 n_2_24_13 n_2_25_13 1189.0314054975506
R3769 n_2_24_13 n_2_24_14 5.98969032384986
R3770 n_2_24_14 n_3_24_14 6.919097939617647
R3771 n_2_24_14 n_2_25_14 132.11460061083952
R3772 n_2_24_14 n_2_24_15 185.08143100696242
R3773 n_2_24_15 n_3_24_15 2288.491643528514
R3774 n_2_24_15 n_2_25_15 43696.90415203474
R3775 n_2_25_0 n_3_25_0 32.69273776469348
R3776 n_2_25_0 n_2_26_0 624.2414878862166
R3777 n_2_25_0 n_2_25_1 148.24483551528448
R3778 n_2_25_1 n_3_25_1 45.76983287057087
R3779 n_2_25_1 n_2_26_1 873.9380830407031
R3780 n_2_25_1 n_2_25_2 336.9200807165557
R3781 n_2_25_2 n_3_25_2 81.7318444117337
R3782 n_2_25_2 n_2_26_2 1560.6037197155415
R3783 n_2_25_2 n_2_25_3 315.35719555069613
R3784 n_2_25_3 n_3_25_3 1144.2458217642709
R3785 n_2_25_3 n_2_26_3 21848.45207601756
R3786 n_2_25_3 n_2_25_4 4.192783226694919
R3787 n_2_25_4 n_3_25_4 34.67411581103852
R3788 n_2_25_4 n_2_26_4 662.0743053338655
R3789 n_2_25_4 n_2_25_5 3.4654636873702906
R3790 n_2_25_5 n_3_25_5 217.95158509795635
R3791 n_2_25_5 n_2_26_5 4161.60991924144
R3792 n_2_25_5 n_2_25_6 1.197938064769977
R3793 n_2_25_6 n_3_25_6 36.325264182992726
R3794 n_2_25_6 n_2_26_6 693.6016532069068
R3795 n_2_25_6 n_2_25_7 1.6257730879021097
R3796 n_2_25_7 n_3_25_7 62.27188145655916
R3797 n_2_25_7 n_2_26_7 1189.031405497558
R3798 n_2_25_7 n_2_25_8 1.197938064769973
R3799 n_2_25_8 n_3_25_8 62.27188145655916
R3800 n_2_25_8 n_2_26_8 1189.031405497558
R3801 n_2_25_8 n_2_25_9 1.197938064769973
R3802 n_2_25_9 n_3_25_9 62.27188145655916
R3803 n_2_25_9 n_2_26_9 1189.031405497558
R3804 n_2_25_9 n_2_25_10 1.197938064769973
R3805 n_2_25_10 n_3_25_10 62.27188145655916
R3806 n_2_25_10 n_2_26_10 1189.031405497558
R3807 n_2_25_10 n_2_25_11 1.1979380647699656
R3808 n_2_25_11 n_3_25_11 62.27188145655995
R3809 n_2_25_11 n_2_26_11 1189.0314054975734
R3810 n_2_25_11 n_2_25_12 1.1979380647699616
R3811 n_2_25_12 n_3_25_12 62.271881456559534
R3812 n_2_25_12 n_2_26_12 1189.0314054975656
R3813 n_2_25_12 n_2_25_13 1.197938064769973
R3814 n_2_25_13 n_3_25_13 62.271881456558766
R3815 n_2_25_13 n_2_26_13 1189.0314054975506
R3816 n_2_25_13 n_2_25_14 5.989690323849881
R3817 n_2_25_14 n_3_25_14 6.919097939617668
R3818 n_2_25_14 n_2_26_14 132.11460061083952
R3819 n_2_25_14 n_2_25_15 185.08143100696304
R3820 n_2_25_15 n_3_25_15 2288.4916435285213
R3821 n_2_25_15 n_2_26_15 43696.90415203474
R3822 n_2_26_0 n_3_26_0 32.692737764693376
R3823 n_2_26_0 n_2_27_0 624.2414878862176
R3824 n_2_26_0 n_2_26_1 148.24483551528402
R3825 n_2_26_1 n_3_26_1 45.769832870570724
R3826 n_2_26_1 n_2_27_1 873.9380830407044
R3827 n_2_26_1 n_2_26_2 336.9200807165546
R3828 n_2_26_2 n_3_26_2 81.73184441173345
R3829 n_2_26_2 n_2_27_2 1560.6037197155438
R3830 n_2_26_2 n_2_26_3 315.3571955506951
R3831 n_2_26_3 n_3_26_3 1144.2458217642672
R3832 n_2_26_3 n_2_27_3 21848.45207601759
R3833 n_2_26_3 n_2_26_4 4.192783226694905
R3834 n_2_26_4 n_3_26_4 34.6741158110384
R3835 n_2_26_4 n_2_27_4 662.0743053338665
R3836 n_2_26_4 n_2_26_5 3.4654636873702787
R3837 n_2_26_5 n_3_26_5 217.95158509795567
R3838 n_2_26_5 n_2_27_5 4161.609919241447
R3839 n_2_26_5 n_2_26_6 1.1979380647699729
R3840 n_2_26_6 n_3_26_6 36.32526418299261
R3841 n_2_26_6 n_2_27_6 693.6016532069078
R3842 n_2_26_6 n_2_26_7 1.6257730879021042
R3843 n_2_26_7 n_3_26_7 62.27188145655895
R3844 n_2_26_7 n_2_27_7 1189.03140549756
R3845 n_2_26_7 n_2_26_8 1.1979380647699691
R3846 n_2_26_8 n_3_26_8 62.27188145655895
R3847 n_2_26_8 n_2_27_8 1189.03140549756
R3848 n_2_26_8 n_2_26_9 1.1979380647699691
R3849 n_2_26_9 n_3_26_9 62.27188145655895
R3850 n_2_26_9 n_2_27_9 1189.03140549756
R3851 n_2_26_9 n_2_26_10 1.1979380647699691
R3852 n_2_26_10 n_3_26_10 62.27188145655895
R3853 n_2_26_10 n_2_27_10 1189.03140549756
R3854 n_2_26_10 n_2_26_11 1.1979380647699616
R3855 n_2_26_11 n_3_26_11 62.27188145655974
R3856 n_2_26_11 n_2_27_11 1189.0314054975752
R3857 n_2_26_11 n_2_26_12 1.1979380647699576
R3858 n_2_26_12 n_3_26_12 62.271881456559356
R3859 n_2_26_12 n_2_27_12 1189.0314054975674
R3860 n_2_26_12 n_2_26_13 1.1979380647699691
R3861 n_2_26_13 n_3_26_13 62.27188145655856
R3862 n_2_26_13 n_2_27_13 1189.0314054975524
R3863 n_2_26_13 n_2_26_14 5.98969032384986
R3864 n_2_26_14 n_3_26_14 6.919097939617647
R3865 n_2_26_14 n_2_27_14 132.11460061083972
R3866 n_2_26_14 n_2_26_15 185.08143100696242
R3867 n_2_26_15 n_3_26_15 2288.491643528514
R3868 n_2_26_15 n_2_27_15 43696.904152034804
R3869 n_2_27_0 n_3_27_0 32.692737764693376
R3870 n_2_27_0 n_2_27_1 148.24483551528402
R3871 n_2_27_1 n_3_27_1 45.769832870570724
R3872 n_2_27_1 n_2_27_2 336.9200807165546
R3873 n_2_27_2 n_3_27_2 81.73184441173345
R3874 n_2_27_2 n_2_27_3 315.3571955506951
R3875 n_2_27_3 n_3_27_3 1144.2458217642672
R3876 n_2_27_3 n_2_27_4 4.192783226694905
R3877 n_2_27_4 n_3_27_4 34.6741158110384
R3878 n_2_27_4 n_2_27_5 3.4654636873702787
R3879 n_2_27_5 n_3_27_5 217.95158509795567
R3880 n_2_27_5 n_2_27_6 1.1979380647699729
R3881 n_2_27_6 n_3_27_6 36.32526418299261
R3882 n_2_27_6 n_2_27_7 1.6257730879021042
R3883 n_2_27_7 n_3_27_7 62.27188145655895
R3884 n_2_27_7 n_2_27_8 1.1979380647699691
R3885 n_2_27_8 n_3_27_8 62.27188145655895
R3886 n_2_27_8 n_2_27_9 1.1979380647699691
R3887 n_2_27_9 n_3_27_9 62.27188145655895
R3888 n_2_27_9 n_2_27_10 1.1979380647699691
R3889 n_2_27_10 n_3_27_10 62.27188145655895
R3890 n_2_27_10 n_2_27_11 1.1979380647699616
R3891 n_2_27_11 n_3_27_11 62.27188145655974
R3892 n_2_27_11 n_2_27_12 1.1979380647699576
R3893 n_2_27_12 n_3_27_12 62.271881456559356
R3894 n_2_27_12 n_2_27_13 1.1979380647699691
R3895 n_2_27_13 n_3_27_13 62.27188145655856
R3896 n_2_27_13 n_2_27_14 5.98969032384986
R3897 n_2_27_14 n_3_27_14 6.919097939617647
R3898 n_2_27_14 n_2_27_15 185.08143100696242
R3899 n_2_27_15 n_3_27_15 2288.491643528514
R3900 n_3_0_0 n_4_0_0 19.585244095872355
R3901 n_3_0_0 n_3_1_0 624.2415416457984
R3902 n_3_0_0 n_3_0_1 148.2448227484626
R3903 n_3_0_1 n_4_0_1 27.41934173422129
R3904 n_3_0_1 n_3_1_1 873.9381583041177
R3905 n_3_0_1 n_3_0_2 336.92005170105136
R3906 n_3_0_2 n_4_0_2 48.96311023968088
R3907 n_3_0_2 n_3_1_2 1560.6038541144958
R3908 n_3_0_2 n_3_0_3 315.35716839218406
R3909 n_3_0_3 n_4_0_3 685.4835433555317
R3910 n_3_0_3 n_3_1_3 21848.453957602924
R3911 n_3_0_3 n_3_0_4 4.192782865613087
R3912 n_3_0_4 n_4_0_4 20.772228586531263
R3913 n_3_0_4 n_3_1_4 662.0743623516037
R3914 n_3_0_4 n_3_0_5 3.465463388925103
R3915 n_3_0_5 n_4_0_5 130.5682939724822
R3916 n_3_0_5 n_3_1_5 4161.610277638652
R3917 n_3_0_5 n_3_0_6 1.197937961603739
R3918 n_3_0_6 n_4_0_6 21.76138232874704
R3919 n_3_0_6 n_3_1_6 693.6017129397753
R3920 n_3_0_6 n_3_0_7 1.6257729478907872
R3921 n_3_0_7 n_4_0_7 37.30522684928075
R3922 n_3_0_7 n_3_1_7 1189.0315078967615
R3923 n_3_0_7 n_3_0_8 1.1979379616037356
R3924 n_3_0_8 n_4_0_8 37.30522684928075
R3925 n_3_0_8 n_3_1_8 1189.0315078967615
R3926 n_3_0_8 n_3_0_9 1.1979379616037356
R3927 n_3_0_9 n_4_0_9 37.30522684928075
R3928 n_3_0_9 n_3_1_9 1189.0315078967615
R3929 n_3_0_9 n_3_0_10 1.1979379616037356
R3930 n_3_0_10 n_4_0_10 37.30522684928075
R3931 n_3_0_10 n_3_1_10 1189.0315078967615
R3932 n_3_0_10 n_3_0_11 1.1979379616037278
R3933 n_3_0_11 n_4_0_11 37.305226849281226
R3934 n_3_0_11 n_3_1_11 1189.0315078967762
R3935 n_3_0_11 n_3_0_12 1.197937961603724
R3936 n_3_0_12 n_4_0_12 37.305226849281
R3937 n_3_0_12 n_3_1_12 1189.031507896769
R3938 n_3_0_12 n_3_0_13 1.1979379616037353
R3939 n_3_0_13 n_4_0_13 37.305226849280515
R3940 n_3_0_13 n_3_1_13 1189.031507896754
R3941 n_3_0_13 n_3_0_14 5.989689808018693
R3942 n_3_0_14 n_4_0_14 4.145025205475631
R3943 n_3_0_14 n_3_1_14 132.1146119885288
R3944 n_3_0_14 n_3_0_15 185.0814150677793
R3945 n_3_0_15 n_4_0_15 1370.967086711051
R3946 n_3_0_15 n_3_1_15 43696.907915205455
R3947 n_3_1_0 n_4_1_0 19.585244095872355
R3948 n_3_1_0 n_3_2_0 624.2415416457984
R3949 n_3_1_0 n_3_1_1 148.2448227484626
R3950 n_3_1_1 n_4_1_1 27.41934173422129
R3951 n_3_1_1 n_3_2_1 873.9381583041177
R3952 n_3_1_1 n_3_1_2 336.92005170105136
R3953 n_3_1_2 n_4_1_2 48.96311023968088
R3954 n_3_1_2 n_3_2_2 1560.6038541144958
R3955 n_3_1_2 n_3_1_3 315.35716839218406
R3956 n_3_1_3 n_4_1_3 685.4835433555317
R3957 n_3_1_3 n_3_2_3 21848.453957602924
R3958 n_3_1_3 n_3_1_4 4.192782865613087
R3959 n_3_1_4 n_4_1_4 20.772228586531263
R3960 n_3_1_4 n_3_2_4 662.0743623516037
R3961 n_3_1_4 n_3_1_5 3.465463388925103
R3962 n_3_1_5 n_4_1_5 130.5682939724822
R3963 n_3_1_5 n_3_2_5 4161.610277638652
R3964 n_3_1_5 n_3_1_6 1.197937961603739
R3965 n_3_1_6 n_4_1_6 21.76138232874704
R3966 n_3_1_6 n_3_2_6 693.6017129397753
R3967 n_3_1_6 n_3_1_7 1.6257729478907872
R3968 n_3_1_7 n_4_1_7 37.30522684928075
R3969 n_3_1_7 n_3_2_7 1189.0315078967615
R3970 n_3_1_7 n_3_1_8 1.1979379616037356
R3971 n_3_1_8 n_4_1_8 37.30522684928075
R3972 n_3_1_8 n_3_2_8 1189.0315078967615
R3973 n_3_1_8 n_3_1_9 1.1979379616037356
R3974 n_3_1_9 n_4_1_9 37.30522684928075
R3975 n_3_1_9 n_3_2_9 1189.0315078967615
R3976 n_3_1_9 n_3_1_10 1.1979379616037356
R3977 n_3_1_10 n_4_1_10 37.30522684928075
R3978 n_3_1_10 n_3_2_10 1189.0315078967615
R3979 n_3_1_10 n_3_1_11 1.1979379616037278
R3980 n_3_1_11 n_4_1_11 37.305226849281226
R3981 n_3_1_11 n_3_2_11 1189.0315078967762
R3982 n_3_1_11 n_3_1_12 1.197937961603724
R3983 n_3_1_12 n_4_1_12 37.305226849281
R3984 n_3_1_12 n_3_2_12 1189.031507896769
R3985 n_3_1_12 n_3_1_13 1.1979379616037353
R3986 n_3_1_13 n_4_1_13 37.305226849280515
R3987 n_3_1_13 n_3_2_13 1189.031507896754
R3988 n_3_1_13 n_3_1_14 5.989689808018693
R3989 n_3_1_14 n_4_1_14 4.145025205475631
R3990 n_3_1_14 n_3_2_14 132.1146119885288
R3991 n_3_1_14 n_3_1_15 185.0814150677793
R3992 n_3_1_15 n_4_1_15 1370.967086711051
R3993 n_3_1_15 n_3_2_15 43696.907915205455
R3994 n_3_2_0 n_4_2_0 19.585244095872355
R3995 n_3_2_0 n_3_3_0 624.2415416457984
R3996 n_3_2_0 n_3_2_1 148.2448227484626
R3997 n_3_2_1 n_4_2_1 27.41934173422129
R3998 n_3_2_1 n_3_3_1 873.9381583041177
R3999 n_3_2_1 n_3_2_2 336.92005170105136
R4000 n_3_2_2 n_4_2_2 48.96311023968088
R4001 n_3_2_2 n_3_3_2 1560.6038541144958
R4002 n_3_2_2 n_3_2_3 315.35716839218406
R4003 n_3_2_3 n_4_2_3 685.4835433555317
R4004 n_3_2_3 n_3_3_3 21848.453957602924
R4005 n_3_2_3 n_3_2_4 4.192782865613087
R4006 n_3_2_4 n_4_2_4 20.772228586531263
R4007 n_3_2_4 n_3_3_4 662.0743623516037
R4008 n_3_2_4 n_3_2_5 3.465463388925103
R4009 n_3_2_5 n_4_2_5 130.5682939724822
R4010 n_3_2_5 n_3_3_5 4161.610277638652
R4011 n_3_2_5 n_3_2_6 1.197937961603739
R4012 n_3_2_6 n_4_2_6 21.76138232874704
R4013 n_3_2_6 n_3_3_6 693.6017129397753
R4014 n_3_2_6 n_3_2_7 1.6257729478907872
R4015 n_3_2_7 n_4_2_7 37.30522684928075
R4016 n_3_2_7 n_3_3_7 1189.0315078967615
R4017 n_3_2_7 n_3_2_8 1.1979379616037356
R4018 n_3_2_8 n_4_2_8 37.30522684928075
R4019 n_3_2_8 n_3_3_8 1189.0315078967615
R4020 n_3_2_8 n_3_2_9 1.1979379616037356
R4021 n_3_2_9 n_4_2_9 37.30522684928075
R4022 n_3_2_9 n_3_3_9 1189.0315078967615
R4023 n_3_2_9 n_3_2_10 1.1979379616037356
R4024 n_3_2_10 n_4_2_10 37.30522684928075
R4025 n_3_2_10 n_3_3_10 1189.0315078967615
R4026 n_3_2_10 n_3_2_11 1.1979379616037278
R4027 n_3_2_11 n_4_2_11 37.305226849281226
R4028 n_3_2_11 n_3_3_11 1189.0315078967762
R4029 n_3_2_11 n_3_2_12 1.197937961603724
R4030 n_3_2_12 n_4_2_12 37.305226849281
R4031 n_3_2_12 n_3_3_12 1189.031507896769
R4032 n_3_2_12 n_3_2_13 1.1979379616037353
R4033 n_3_2_13 n_4_2_13 37.305226849280515
R4034 n_3_2_13 n_3_3_13 1189.031507896754
R4035 n_3_2_13 n_3_2_14 5.989689808018693
R4036 n_3_2_14 n_4_2_14 4.145025205475631
R4037 n_3_2_14 n_3_3_14 132.1146119885288
R4038 n_3_2_14 n_3_2_15 185.0814150677793
R4039 n_3_2_15 n_4_2_15 1370.967086711051
R4040 n_3_2_15 n_3_3_15 43696.907915205455
R4041 n_3_3_0 n_4_3_0 19.585244095872355
R4042 n_3_3_0 n_3_4_0 326.27363593662244
R4043 n_3_3_0 n_3_3_1 148.2448227484626
R4044 n_3_3_1 n_4_3_1 27.41934173422129
R4045 n_3_3_1 n_3_4_1 456.78309031127134
R4046 n_3_3_1 n_3_3_2 336.92005170105136
R4047 n_3_3_2 n_4_3_2 48.96311023968088
R4048 n_3_3_2 n_3_4_2 815.684089841556
R4049 n_3_3_2 n_3_3_3 315.35716839218406
R4050 n_3_3_3 n_4_3_3 685.4835433555317
R4051 n_3_3_3 n_3_4_3 11419.577257781775
R4052 n_3_3_3 n_3_3_4 4.192782865613087
R4053 n_3_3_4 n_4_3_4 20.772228586531263
R4054 n_3_3_4 n_3_4_4 346.04779569035674
R4055 n_3_3_4 n_3_3_5 3.465463388925103
R4056 n_3_3_5 n_4_3_5 130.5682939724822
R4057 n_3_3_5 n_3_4_5 2175.1575729108145
R4058 n_3_3_5 n_3_3_6 1.197937961603739
R4059 n_3_3_6 n_4_3_6 21.76138232874704
R4060 n_3_3_6 n_3_4_6 362.52626215180237
R4061 n_3_3_6 n_3_3_7 1.6257729478907872
R4062 n_3_3_7 n_4_3_7 37.30522684928075
R4063 n_3_3_7 n_3_4_7 621.4735922602346
R4064 n_3_3_7 n_3_3_8 1.1979379616037356
R4065 n_3_3_8 n_4_3_8 37.30522684928075
R4066 n_3_3_8 n_3_4_8 621.4735922602346
R4067 n_3_3_8 n_3_3_9 1.1979379616037356
R4068 n_3_3_9 n_4_3_9 37.30522684928075
R4069 n_3_3_9 n_3_4_9 621.4735922602346
R4070 n_3_3_9 n_3_3_10 1.1979379616037356
R4071 n_3_3_10 n_4_3_10 37.30522684928075
R4072 n_3_3_10 n_3_4_10 621.4735922602346
R4073 n_3_3_10 n_3_3_11 1.1979379616037278
R4074 n_3_3_11 n_4_3_11 37.305226849281226
R4075 n_3_3_11 n_3_4_11 621.4735922602423
R4076 n_3_3_11 n_3_3_12 1.197937961603724
R4077 n_3_3_12 n_4_3_12 37.305226849281
R4078 n_3_3_12 n_3_4_12 621.4735922602384
R4079 n_3_3_12 n_3_3_13 1.1979379616037353
R4080 n_3_3_13 n_4_3_13 37.305226849280515
R4081 n_3_3_13 n_3_4_13 621.4735922602306
R4082 n_3_3_13 n_3_3_14 5.989689808018693
R4083 n_3_3_14 n_4_3_14 4.145025205475631
R4084 n_3_3_14 n_3_4_14 69.05262136224815
R4085 n_3_3_14 n_3_3_15 185.0814150677793
R4086 n_3_3_15 n_4_3_15 1370.967086711051
R4087 n_3_3_15 n_3_4_15 22839.154515563343
R4088 n_3_4_0 n_4_4_0 431.9239556682358
R4089 n_3_4_0 n_3_5_0 28.305730227446706
R4090 n_3_4_0 n_3_4_1 3269.323064620219
R4091 n_3_4_1 n_4_4_1 604.6935379355301
R4092 n_3_4_1 n_3_5_1 39.628022318425394
R4093 n_3_4_1 n_3_4_2 7430.27969231868
R4094 n_3_4_2 n_4_4_2 1079.8098891705897
R4095 n_3_4_2 n_3_5_2 70.76432556861675
R4096 n_3_4_2 n_3_4_3 6954.741792010284
R4097 n_3_4_3 n_4_4_3 15117.338448388244
R4098 n_3_4_3 n_3_5_3 990.7005579606339
R4099 n_3_4_3 n_3_4_4 92.46570283774365
R4100 n_3_4_4 n_4_4_4 458.10116510267403
R4101 n_3_4_4 n_3_5_4 30.021229029110113
R4102 n_3_4_4 n_3_4_5 76.42573397813506
R4103 n_3_4_5 n_3_5_5 188.7048681829779
R4104 n_3_4_5 n_3_4_6 26.41877223935533
R4105 n_3_4_6 n_3_5_6 31.450811363829644
R4106 n_3_4_6 n_3_4_7 35.85404803912505
R4107 n_3_4_7 n_3_5_7 53.91567662370813
R4108 n_3_4_7 n_3_4_8 26.41877223935525
R4109 n_3_4_8 n_3_5_8 53.91567662370813
R4110 n_3_4_8 n_3_4_9 26.41877223935525
R4111 n_3_4_9 n_3_5_9 53.91567662370813
R4112 n_3_4_9 n_3_4_10 26.41877223935525
R4113 n_3_4_10 n_3_5_10 53.91567662370813
R4114 n_3_4_10 n_3_4_11 26.41877223935508
R4115 n_3_4_11 n_3_5_11 53.915676623708805
R4116 n_3_4_11 n_3_4_12 26.418772239354993
R4117 n_3_4_12 n_3_5_12 53.91567662370848
R4118 n_3_4_12 n_3_4_13 26.41877223935525
R4119 n_3_4_13 n_3_5_13 53.915676623707796
R4120 n_3_4_13 n_3_4_14 132.09386119677657
R4121 n_3_4_14 n_3_5_14 5.990630735967558
R4122 n_3_4_14 n_3_4_15 4081.7003109804336
R4123 n_3_4_15 n_4_4_15 30234.67689677622
R4124 n_3_4_15 n_3_5_15 1981.40111592125
R4125 n_3_5_0 n_4_5_0 431.92395566822825
R4126 n_3_5_0 n_3_6_0 28.305730227446958
R4127 n_3_5_0 n_3_5_1 3269.3230646201605
R4128 n_3_5_1 n_4_5_1 604.6935379355194
R4129 n_3_5_1 n_3_6_1 39.62802231842574
R4130 n_3_5_1 n_3_5_2 7430.279692318547
R4131 n_3_5_2 n_4_5_2 1079.8098891705704
R4132 n_3_5_2 n_3_6_2 70.76432556861738
R4133 n_3_5_2 n_3_5_3 6954.74179201016
R4134 n_3_5_3 n_4_5_3 15117.338448387973
R4135 n_3_5_3 n_3_6_3 990.7005579606426
R4136 n_3_5_3 n_3_5_4 92.46570283774201
R4137 n_3_5_4 n_4_5_4 458.10116510266585
R4138 n_3_5_4 n_3_6_4 30.02122902911038
R4139 n_3_5_4 n_3_5_5 76.4257339781337
R4140 n_3_5_5 n_3_6_5 188.70486818297957
R4141 n_3_5_5 n_3_5_6 26.418772239354862
R4142 n_3_5_6 n_3_6_6 31.45081136382992
R4143 n_3_5_6 n_3_5_7 35.854048039124415
R4144 n_3_5_7 n_3_6_7 53.915676623708606
R4145 n_3_5_7 n_3_5_8 26.41877223935478
R4146 n_3_5_8 n_3_6_8 53.915676623708606
R4147 n_3_5_8 n_3_5_9 26.41877223935478
R4148 n_3_5_9 n_3_6_9 53.915676623708606
R4149 n_3_5_9 n_3_5_10 26.41877223935478
R4150 n_3_5_10 n_3_6_10 53.915676623708606
R4151 n_3_5_10 n_3_5_11 26.41877223935461
R4152 n_3_5_11 n_3_6_11 53.91567662370929
R4153 n_3_5_11 n_3_5_12 26.418772239354524
R4154 n_3_5_12 n_3_6_12 53.915676623708954
R4155 n_3_5_12 n_3_5_13 26.41877223935478
R4156 n_3_5_13 n_3_6_13 53.91567662370827
R4157 n_3_5_13 n_3_5_14 132.0938611967742
R4158 n_3_5_14 n_3_6_14 5.990630735967612
R4159 n_3_5_14 n_3_5_15 4081.700310980361
R4160 n_3_5_15 n_4_5_15 30234.676896775676
R4161 n_3_5_15 n_3_6_15 1981.4011159212675
R4162 n_3_6_0 n_4_6_0 431.92395566822825
R4163 n_3_6_0 n_3_7_0 28.305730227446706
R4164 n_3_6_0 n_3_6_1 3269.3230646201605
R4165 n_3_6_1 n_4_6_1 604.6935379355194
R4166 n_3_6_1 n_3_7_1 39.628022318425394
R4167 n_3_6_1 n_3_6_2 7430.279692318547
R4168 n_3_6_2 n_4_6_2 1079.8098891705704
R4169 n_3_6_2 n_3_7_2 70.76432556861675
R4170 n_3_6_2 n_3_6_3 6954.74179201016
R4171 n_3_6_3 n_4_6_3 15117.338448387973
R4172 n_3_6_3 n_3_7_3 990.7005579606339
R4173 n_3_6_3 n_3_6_4 92.46570283774201
R4174 n_3_6_4 n_4_6_4 458.10116510266585
R4175 n_3_6_4 n_3_7_4 30.021229029110113
R4176 n_3_6_4 n_3_6_5 76.4257339781337
R4177 n_3_6_5 n_3_7_5 188.7048681829779
R4178 n_3_6_5 n_3_6_6 26.418772239354862
R4179 n_3_6_6 n_3_7_6 31.450811363829644
R4180 n_3_6_6 n_3_6_7 35.854048039124415
R4181 n_3_6_7 n_3_7_7 53.91567662370813
R4182 n_3_6_7 n_3_6_8 26.41877223935478
R4183 n_3_6_8 n_3_7_8 53.91567662370813
R4184 n_3_6_8 n_3_6_9 26.41877223935478
R4185 n_3_6_9 n_3_7_9 53.91567662370813
R4186 n_3_6_9 n_3_6_10 26.41877223935478
R4187 n_3_6_10 n_3_7_10 53.91567662370813
R4188 n_3_6_10 n_3_6_11 26.41877223935461
R4189 n_3_6_11 n_3_7_11 53.915676623708805
R4190 n_3_6_11 n_3_6_12 26.418772239354524
R4191 n_3_6_12 n_3_7_12 53.91567662370848
R4192 n_3_6_12 n_3_6_13 26.41877223935478
R4193 n_3_6_13 n_3_7_13 53.915676623707796
R4194 n_3_6_13 n_3_6_14 132.0938611967742
R4195 n_3_6_14 n_3_7_14 5.990630735967558
R4196 n_3_6_14 n_3_6_15 4081.700310980361
R4197 n_3_6_15 n_4_6_15 30234.676896775676
R4198 n_3_6_15 n_3_7_15 1981.40111592125
R4199 n_3_7_0 n_4_7_0 431.9239556682358
R4200 n_3_7_0 n_3_8_0 827.2137876682006
R4201 n_3_7_0 n_3_7_1 3269.323064620219
R4202 n_3_7_1 n_4_7_1 604.6935379355301
R4203 n_3_7_1 n_3_8_1 1158.0993027354807
R4204 n_3_7_1 n_3_7_2 7430.27969231868
R4205 n_3_7_2 n_4_7_2 1079.8098891705897
R4206 n_3_7_2 n_3_8_2 2068.0344691705013
R4207 n_3_7_2 n_3_7_3 6954.741792010284
R4208 n_3_7_3 n_4_7_3 15117.338448388244
R4209 n_3_7_3 n_3_8_3 28952.482568386997
R4210 n_3_7_3 n_3_7_4 92.46570283774365
R4211 n_3_7_4 n_4_7_4 458.10116510267403
R4212 n_3_7_4 n_3_8_4 877.3479566177876
R4213 n_3_7_4 n_3_7_5 76.42573397813506
R4214 n_3_7_5 n_3_8_5 5514.758584454666
R4215 n_3_7_5 n_3_7_6 26.41877223935533
R4216 n_3_7_6 n_3_8_6 919.1264307424442
R4217 n_3_7_6 n_3_7_7 35.85404803912505
R4218 n_3_7_7 n_3_8_7 1575.6453098441948
R4219 n_3_7_7 n_3_7_8 26.41877223935525
R4220 n_3_7_8 n_3_8_8 1575.6453098441948
R4221 n_3_7_8 n_3_7_9 26.41877223935525
R4222 n_3_7_9 n_3_8_9 1575.6453098441948
R4223 n_3_7_9 n_3_7_10 26.41877223935525
R4224 n_3_7_10 n_3_8_10 1575.6453098441948
R4225 n_3_7_10 n_3_7_11 26.41877223935508
R4226 n_3_7_11 n_3_8_11 1575.6453098442148
R4227 n_3_7_11 n_3_7_12 26.418772239354993
R4228 n_3_7_12 n_3_8_12 1575.645309844205
R4229 n_3_7_12 n_3_7_13 26.41877223935525
R4230 n_3_7_13 n_3_8_13 1575.6453098441852
R4231 n_3_7_13 n_3_7_14 132.09386119677657
R4232 n_3_7_14 n_3_8_14 175.0717010937991
R4233 n_3_7_14 n_3_7_15 4081.7003109804336
R4234 n_3_7_15 n_4_7_15 30234.67689677622
R4235 n_3_7_15 n_3_8_15 57904.96513677348
R4236 n_3_8_0 n_4_8_0 7.518454416370907
R4237 n_3_8_0 n_3_9_0 1626.121845108955
R4238 n_3_8_0 n_3_8_1 56.90875931090387
R4239 n_3_8_1 n_4_8_1 10.525836182919269
R4240 n_3_8_1 n_3_9_1 2276.5705831525374
R4241 n_3_8_1 n_3_8_2 129.33808934296334
R4242 n_3_8_2 n_4_8_2 18.796136040927266
R4243 n_3_8_2 n_3_9_2 4065.3046127723874
R4244 n_3_8_2 n_3_8_3 121.06045162501368
R4245 n_3_8_3 n_4_8_3 263.14590457298146
R4246 n_3_8_3 n_3_9_3 56914.26457881338
R4247 n_3_8_3 n_3_8_4 1.6095406673791008
R4248 n_3_8_4 n_4_8_4 7.974118320393379
R4249 n_3_8_4 n_3_9_4 1724.6746842064658
R4250 n_3_8_4 n_3_8_5 1.3303346332419097
R4251 n_3_8_5 n_3_9_5 10840.812300726358
R4252 n_3_8_5 n_3_8_6 0.4598687621083145
R4253 n_3_8_6 n_3_9_6 1806.8020501210594
R4254 n_3_8_6 n_3_8_7 0.624107605718426
R4255 n_3_8_7 n_3_9_7 3097.374943064683
R4256 n_3_8_7 n_3_8_8 0.45986876210831307
R4257 n_3_8_8 n_3_9_8 3097.374943064683
R4258 n_3_8_8 n_3_8_9 0.45986876210831307
R4259 n_3_8_9 n_3_9_9 3097.374943064683
R4260 n_3_8_9 n_3_8_10 0.45986876210831307
R4261 n_3_8_10 n_3_9_10 3097.374943064683
R4262 n_3_8_10 n_3_8_11 0.4598687621083101
R4263 n_3_8_11 n_3_9_11 3097.374943064722
R4264 n_3_8_11 n_3_8_12 0.4598687621083086
R4265 n_3_8_12 n_3_9_12 3097.374943064703
R4266 n_3_8_12 n_3_8_13 0.45986876210831307
R4267 n_3_8_13 n_3_9_13 3097.374943064664
R4268 n_3_8_13 n_3_8_14 2.299343810541571
R4269 n_3_8_14 n_3_9_14 344.15277145163077
R4270 n_3_8_14 n_3_8_15 71.04972374573519
R4271 n_3_8_15 n_4_8_15 526.2918091459583
R4272 n_3_8_15 n_3_9_15 113828.52915762574
R4273 n_3_9_0 n_4_9_0 7.518454416370901
R4274 n_3_9_0 n_3_10_0 1626.121845108955
R4275 n_3_9_0 n_3_9_1 56.90875931090384
R4276 n_3_9_1 n_4_9_1 10.525836182919262
R4277 n_3_9_1 n_3_10_1 2276.5705831525374
R4278 n_3_9_1 n_3_9_2 129.33808934296326
R4279 n_3_9_2 n_4_9_2 18.796136040927255
R4280 n_3_9_2 n_3_10_2 4065.3046127723874
R4281 n_3_9_2 n_3_9_3 121.06045162501361
R4282 n_3_9_3 n_4_9_3 263.14590457298135
R4283 n_3_9_3 n_3_10_3 56914.26457881338
R4284 n_3_9_3 n_3_9_4 1.6095406673791
R4285 n_3_9_4 n_4_9_4 7.974118320393374
R4286 n_3_9_4 n_3_10_4 1724.6746842064658
R4287 n_3_9_4 n_3_9_5 1.330334633241909
R4288 n_3_9_5 n_3_10_5 10840.812300726358
R4289 n_3_9_5 n_3_9_6 0.45986876210831423
R4290 n_3_9_6 n_3_10_6 1806.8020501210594
R4291 n_3_9_6 n_3_9_7 0.6241076057184257
R4292 n_3_9_7 n_3_10_7 3097.374943064683
R4293 n_3_9_7 n_3_9_8 0.4598687621083128
R4294 n_3_9_8 n_3_10_8 3097.374943064683
R4295 n_3_9_8 n_3_9_9 0.4598687621083128
R4296 n_3_9_9 n_3_10_9 3097.374943064683
R4297 n_3_9_9 n_3_9_10 0.4598687621083128
R4298 n_3_9_10 n_3_10_10 3097.374943064683
R4299 n_3_9_10 n_3_9_11 0.45986876210830985
R4300 n_3_9_11 n_3_10_11 3097.374943064722
R4301 n_3_9_11 n_3_9_12 0.4598687621083084
R4302 n_3_9_12 n_3_10_12 3097.374943064703
R4303 n_3_9_12 n_3_9_13 0.45986876210831285
R4304 n_3_9_13 n_3_10_13 3097.374943064664
R4305 n_3_9_13 n_3_9_14 2.29934381054157
R4306 n_3_9_14 n_3_10_14 344.15277145163077
R4307 n_3_9_14 n_3_9_15 71.04972374573515
R4308 n_3_9_15 n_4_9_15 526.291809145958
R4309 n_3_9_15 n_3_10_15 113828.52915762574
R4310 n_3_10_0 n_4_10_0 7.518454416370907
R4311 n_3_10_0 n_3_11_0 1626.1218451089546
R4312 n_3_10_0 n_3_10_1 56.90875931090387
R4313 n_3_10_1 n_4_10_1 10.525836182919269
R4314 n_3_10_1 n_3_11_1 2276.5705831525365
R4315 n_3_10_1 n_3_10_2 129.33808934296334
R4316 n_3_10_2 n_4_10_2 18.796136040927266
R4317 n_3_10_2 n_3_11_2 4065.3046127723865
R4318 n_3_10_2 n_3_10_3 121.06045162501368
R4319 n_3_10_3 n_4_10_3 263.14590457298146
R4320 n_3_10_3 n_3_11_3 56914.26457881337
R4321 n_3_10_3 n_3_10_4 1.6095406673791008
R4322 n_3_10_4 n_4_10_4 7.974118320393379
R4323 n_3_10_4 n_3_11_4 1724.6746842064654
R4324 n_3_10_4 n_3_10_5 1.3303346332419097
R4325 n_3_10_5 n_3_11_5 10840.812300726355
R4326 n_3_10_5 n_3_10_6 0.4598687621083145
R4327 n_3_10_6 n_3_11_6 1806.802050121059
R4328 n_3_10_6 n_3_10_7 0.624107605718426
R4329 n_3_10_7 n_3_11_7 3097.374943064682
R4330 n_3_10_7 n_3_10_8 0.45986876210831307
R4331 n_3_10_8 n_3_11_8 3097.374943064682
R4332 n_3_10_8 n_3_10_9 0.45986876210831307
R4333 n_3_10_9 n_3_11_9 3097.374943064682
R4334 n_3_10_9 n_3_10_10 0.45986876210831307
R4335 n_3_10_10 n_3_11_10 3097.374943064682
R4336 n_3_10_10 n_3_10_11 0.4598687621083101
R4337 n_3_10_11 n_3_11_11 3097.3749430647213
R4338 n_3_10_11 n_3_10_12 0.4598687621083086
R4339 n_3_10_12 n_3_11_12 3097.374943064702
R4340 n_3_10_12 n_3_10_13 0.45986876210831307
R4341 n_3_10_13 n_3_11_13 3097.374943064663
R4342 n_3_10_13 n_3_10_14 2.299343810541571
R4343 n_3_10_14 n_3_11_14 344.1527714516307
R4344 n_3_10_14 n_3_10_15 71.04972374573519
R4345 n_3_10_15 n_4_10_15 526.2918091459583
R4346 n_3_10_15 n_3_11_15 113828.52915762572
R4347 n_3_11_0 n_4_11_0 7.518454416370907
R4348 n_3_11_0 n_3_12_0 827.2138119611456
R4349 n_3_11_0 n_3_11_1 56.90875931090387
R4350 n_3_11_1 n_4_11_1 10.525836182919269
R4351 n_3_11_1 n_3_12_1 1158.0993367456038
R4352 n_3_11_1 n_3_11_2 129.33808934296334
R4353 n_3_11_2 n_4_11_2 18.796136040927266
R4354 n_3_11_2 n_3_12_2 2068.034529902864
R4355 n_3_11_2 n_3_11_3 121.06045162501368
R4356 n_3_11_3 n_4_11_3 263.14590457298146
R4357 n_3_11_3 n_3_12_3 28952.483418640073
R4358 n_3_11_3 n_3_11_4 1.6095406673791008
R4359 n_3_11_4 n_4_11_4 7.974118320393379
R4360 n_3_11_4 n_3_12_4 877.3479823830323
R4361 n_3_11_4 n_3_11_5 1.3303346332419097
R4362 n_3_11_5 n_3_12_5 5514.758746407632
R4363 n_3_11_5 n_3_11_6 0.4598687621083145
R4364 n_3_11_6 n_3_12_6 919.1264577346053
R4365 n_3_11_6 n_3_11_7 0.624107605718426
R4366 n_3_11_7 n_3_12_7 1575.6453561164712
R4367 n_3_11_7 n_3_11_8 0.45986876210831307
R4368 n_3_11_8 n_3_12_8 1575.6453561164712
R4369 n_3_11_8 n_3_11_9 0.45986876210831307
R4370 n_3_11_9 n_3_12_9 1575.6453561164712
R4371 n_3_11_9 n_3_11_10 0.45986876210831307
R4372 n_3_11_10 n_3_12_10 1575.6453561164712
R4373 n_3_11_10 n_3_11_11 0.4598687621083101
R4374 n_3_11_11 n_3_12_11 1575.645356116491
R4375 n_3_11_11 n_3_11_12 0.4598687621083086
R4376 n_3_11_12 n_3_12_12 1575.6453561164815
R4377 n_3_11_12 n_3_11_13 0.45986876210831307
R4378 n_3_11_13 n_3_12_13 1575.6453561164615
R4379 n_3_11_13 n_3_11_14 2.299343810541571
R4380 n_3_11_14 n_3_12_14 175.07170623516313
R4381 n_3_11_14 n_3_11_15 71.04972374573519
R4382 n_3_11_15 n_4_11_15 526.2918091459583
R4383 n_3_11_15 n_3_12_15 57904.96683727963
R4384 n_3_12_0 n_4_12_0 431.9232142857082
R4385 n_3_12_0 n_3_13_0 28.305778813336563
R4386 n_3_12_0 n_3_12_1 3269.3174529402795
R4387 n_3_12_1 n_4_12_1 604.6924999999915
R4388 n_3_12_1 n_3_13_1 39.628090338671186
R4389 n_3_12_1 n_3_12_2 7430.266938500636
R4390 n_3_12_2 n_4_12_2 1079.8080357142708
R4391 n_3_12_2 n_3_13_2 70.7644470333414
R4392 n_3_12_2 n_3_12_3 6954.729854436595
R4393 n_3_12_3 n_4_12_3 15117.312499999774
R4394 n_3_12_3 n_3_13_3 990.7022584667787
R4395 n_3_12_3 n_3_12_4 92.46554412356353
R4396 n_3_12_4 n_4_12_4 458.100378787872
R4397 n_3_12_4 n_3_13_4 30.02128055959935
R4398 n_3_12_4 n_3_12_5 76.42560279600659
R4399 n_3_12_5 n_3_13_5 188.70519208891025
R4400 n_3_12_5 n_3_12_6 26.418726892446728
R4401 n_3_12_6 n_3_13_6 31.450865348151705
R4402 n_3_12_6 n_3_12_7 35.85398649689195
R4403 n_3_12_7 n_3_13_7 53.91576916826023
R4404 n_3_12_7 n_3_12_8 26.418726892446646
R4405 n_3_12_8 n_3_13_8 53.91576916826023
R4406 n_3_12_8 n_3_12_9 26.418726892446646
R4407 n_3_12_9 n_3_13_9 53.91576916826023
R4408 n_3_12_9 n_3_12_10 26.418726892446646
R4409 n_3_12_10 n_3_13_10 53.91576916826023
R4410 n_3_12_10 n_3_12_11 26.41872689244648
R4411 n_3_12_11 n_3_13_11 53.91576916826091
R4412 n_3_12_11 n_3_12_12 26.418726892446394
R4413 n_3_12_12 n_3_13_12 53.91576916826058
R4414 n_3_12_12 n_3_12_13 26.41872689244665
R4415 n_3_12_13 n_3_13_13 53.9157691682599
R4416 n_3_12_13 n_3_12_14 132.09363446223358
R4417 n_3_12_14 n_3_13_14 5.99064101869557
R4418 n_3_12_14 n_3_12_15 4081.6933048830547
R4419 n_3_12_15 n_4_12_15 30234.62499999928
R4420 n_3_12_15 n_3_13_15 1981.40451693354
R4421 n_3_13_0 n_4_13_0 431.9232142857082
R4422 n_3_13_0 n_3_14_0 28.305778813336563
R4423 n_3_13_0 n_3_13_1 3269.3174529402795
R4424 n_3_13_1 n_4_13_1 604.6924999999915
R4425 n_3_13_1 n_3_14_1 39.628090338671186
R4426 n_3_13_1 n_3_13_2 7430.266938500636
R4427 n_3_13_2 n_4_13_2 1079.8080357142708
R4428 n_3_13_2 n_3_14_2 70.7644470333414
R4429 n_3_13_2 n_3_13_3 6954.729854436595
R4430 n_3_13_3 n_4_13_3 15117.312499999774
R4431 n_3_13_3 n_3_14_3 990.7022584667787
R4432 n_3_13_3 n_3_13_4 92.46554412356353
R4433 n_3_13_4 n_4_13_4 458.100378787872
R4434 n_3_13_4 n_3_14_4 30.02128055959935
R4435 n_3_13_4 n_3_13_5 76.42560279600659
R4436 n_3_13_5 n_3_14_5 188.70519208891025
R4437 n_3_13_5 n_3_13_6 26.418726892446728
R4438 n_3_13_6 n_3_14_6 31.450865348151705
R4439 n_3_13_6 n_3_13_7 35.85398649689195
R4440 n_3_13_7 n_3_14_7 53.91576916826023
R4441 n_3_13_7 n_3_13_8 26.418726892446646
R4442 n_3_13_8 n_3_14_8 53.91576916826023
R4443 n_3_13_8 n_3_13_9 26.418726892446646
R4444 n_3_13_9 n_3_14_9 53.91576916826023
R4445 n_3_13_9 n_3_13_10 26.418726892446646
R4446 n_3_13_10 n_3_14_10 53.91576916826023
R4447 n_3_13_10 n_3_13_11 26.41872689244648
R4448 n_3_13_11 n_3_14_11 53.91576916826091
R4449 n_3_13_11 n_3_13_12 26.418726892446394
R4450 n_3_13_12 n_3_14_12 53.91576916826058
R4451 n_3_13_12 n_3_13_13 26.41872689244665
R4452 n_3_13_13 n_3_14_13 53.9157691682599
R4453 n_3_13_13 n_3_13_14 132.09363446223358
R4454 n_3_13_14 n_3_14_14 5.99064101869557
R4455 n_3_13_14 n_3_13_15 4081.6933048830547
R4456 n_3_13_15 n_4_13_15 30234.62499999928
R4457 n_3_13_15 n_3_14_15 1981.40451693354
R4458 n_3_14_0 n_4_14_0 431.9232142857082
R4459 n_3_14_0 n_3_15_0 28.305778813336563
R4460 n_3_14_0 n_3_14_1 3269.3174529402795
R4461 n_3_14_1 n_4_14_1 604.6924999999915
R4462 n_3_14_1 n_3_15_1 39.628090338671186
R4463 n_3_14_1 n_3_14_2 7430.266938500636
R4464 n_3_14_2 n_4_14_2 1079.8080357142708
R4465 n_3_14_2 n_3_15_2 70.7644470333414
R4466 n_3_14_2 n_3_14_3 6954.729854436595
R4467 n_3_14_3 n_4_14_3 15117.312499999774
R4468 n_3_14_3 n_3_15_3 990.7022584667787
R4469 n_3_14_3 n_3_14_4 92.46554412356353
R4470 n_3_14_4 n_4_14_4 458.100378787872
R4471 n_3_14_4 n_3_15_4 30.02128055959935
R4472 n_3_14_4 n_3_14_5 76.42560279600659
R4473 n_3_14_5 n_3_15_5 188.70519208891025
R4474 n_3_14_5 n_3_14_6 26.418726892446728
R4475 n_3_14_6 n_3_15_6 31.450865348151705
R4476 n_3_14_6 n_3_14_7 35.85398649689195
R4477 n_3_14_7 n_3_15_7 53.91576916826023
R4478 n_3_14_7 n_3_14_8 26.418726892446646
R4479 n_3_14_8 n_3_15_8 53.91576916826023
R4480 n_3_14_8 n_3_14_9 26.418726892446646
R4481 n_3_14_9 n_3_15_9 53.91576916826023
R4482 n_3_14_9 n_3_14_10 26.418726892446646
R4483 n_3_14_10 n_3_15_10 53.91576916826023
R4484 n_3_14_10 n_3_14_11 26.41872689244648
R4485 n_3_14_11 n_3_15_11 53.91576916826091
R4486 n_3_14_11 n_3_14_12 26.418726892446394
R4487 n_3_14_12 n_3_15_12 53.91576916826058
R4488 n_3_14_12 n_3_14_13 26.41872689244665
R4489 n_3_14_13 n_3_15_13 53.9157691682599
R4490 n_3_14_13 n_3_14_14 132.09363446223358
R4491 n_3_14_14 n_3_15_14 5.99064101869557
R4492 n_3_14_14 n_3_14_15 4081.6933048830547
R4493 n_3_14_15 n_4_14_15 30234.62499999928
R4494 n_3_14_15 n_3_15_15 1981.40451693354
R4495 n_3_15_0 n_4_15_0 431.9232142857082
R4496 n_3_15_0 n_3_16_0 827.2138119611451
R4497 n_3_15_0 n_3_15_1 3269.3174529402795
R4498 n_3_15_1 n_4_15_1 604.6924999999915
R4499 n_3_15_1 n_3_16_1 1158.099336745603
R4500 n_3_15_1 n_3_15_2 7430.266938500636
R4501 n_3_15_2 n_4_15_2 1079.8080357142708
R4502 n_3_15_2 n_3_16_2 2068.0345299028627
R4503 n_3_15_2 n_3_15_3 6954.729854436595
R4504 n_3_15_3 n_4_15_3 15117.312499999774
R4505 n_3_15_3 n_3_16_3 28952.483418640055
R4506 n_3_15_3 n_3_15_4 92.46554412356353
R4507 n_3_15_4 n_4_15_4 458.100378787872
R4508 n_3_15_4 n_3_16_4 877.3479823830318
R4509 n_3_15_4 n_3_15_5 76.42560279600659
R4510 n_3_15_5 n_3_16_5 5514.75874640763
R4511 n_3_15_5 n_3_15_6 26.418726892446728
R4512 n_3_15_6 n_3_16_6 919.1264577346047
R4513 n_3_15_6 n_3_15_7 35.85398649689195
R4514 n_3_15_7 n_3_16_7 1575.6453561164703
R4515 n_3_15_7 n_3_15_8 26.418726892446646
R4516 n_3_15_8 n_3_16_8 1575.6453561164703
R4517 n_3_15_8 n_3_15_9 26.418726892446646
R4518 n_3_15_9 n_3_16_9 1575.6453561164703
R4519 n_3_15_9 n_3_15_10 26.418726892446646
R4520 n_3_15_10 n_3_16_10 1575.6453561164703
R4521 n_3_15_10 n_3_15_11 26.41872689244648
R4522 n_3_15_11 n_3_16_11 1575.6453561164901
R4523 n_3_15_11 n_3_15_12 26.418726892446394
R4524 n_3_15_12 n_3_16_12 1575.6453561164806
R4525 n_3_15_12 n_3_15_13 26.41872689244665
R4526 n_3_15_13 n_3_16_13 1575.6453561164606
R4527 n_3_15_13 n_3_15_14 132.09363446223358
R4528 n_3_15_14 n_3_16_14 175.07170623516302
R4529 n_3_15_14 n_3_15_15 4081.6933048830547
R4530 n_3_15_15 n_4_15_15 30234.62499999928
R4531 n_3_15_15 n_3_16_15 57904.96683727959
R4532 n_3_16_0 n_4_16_0 7.518454416370912
R4533 n_3_16_0 n_3_17_0 1626.1218451089546
R4534 n_3_16_0 n_3_16_1 56.9087593109039
R4535 n_3_16_1 n_4_16_1 10.525836182919274
R4536 n_3_16_1 n_3_17_1 2276.5705831525365
R4537 n_3_16_1 n_3_16_2 129.33808934296343
R4538 n_3_16_2 n_4_16_2 18.796136040927276
R4539 n_3_16_2 n_3_17_2 4065.3046127723865
R4540 n_3_16_2 n_3_16_3 121.06045162501377
R4541 n_3_16_3 n_4_16_3 263.14590457298164
R4542 n_3_16_3 n_3_17_3 56914.26457881337
R4543 n_3_16_3 n_3_16_4 1.6095406673791017
R4544 n_3_16_4 n_4_16_4 7.974118320393382
R4545 n_3_16_4 n_3_17_4 1724.6746842064654
R4546 n_3_16_4 n_3_16_5 1.3303346332419106
R4547 n_3_16_5 n_3_17_5 10840.812300726357
R4548 n_3_16_5 n_3_16_6 0.45986876210831473
R4549 n_3_16_6 n_3_17_6 1806.802050121059
R4550 n_3_16_6 n_3_16_7 0.6241076057184265
R4551 n_3_16_7 n_3_17_7 3097.374943064682
R4552 n_3_16_7 n_3_16_8 0.4598687621083133
R4553 n_3_16_8 n_3_17_8 3097.374943064682
R4554 n_3_16_8 n_3_16_9 0.4598687621083133
R4555 n_3_16_9 n_3_17_9 3097.374943064682
R4556 n_3_16_9 n_3_16_10 0.4598687621083133
R4557 n_3_16_10 n_3_17_10 3097.374943064682
R4558 n_3_16_10 n_3_16_11 0.45986876210831035
R4559 n_3_16_11 n_3_17_11 3097.3749430647213
R4560 n_3_16_11 n_3_16_12 0.45986876210830885
R4561 n_3_16_12 n_3_17_12 3097.374943064702
R4562 n_3_16_12 n_3_16_13 0.4598687621083133
R4563 n_3_16_13 n_3_17_13 3097.374943064663
R4564 n_3_16_13 n_3_16_14 2.2993438105415724
R4565 n_3_16_14 n_3_17_14 344.15277145163066
R4566 n_3_16_14 n_3_16_15 71.04972374573525
R4567 n_3_16_15 n_4_16_15 526.2918091459586
R4568 n_3_16_15 n_3_17_15 113828.52915762572
R4569 n_3_17_0 n_4_17_0 7.518454416370901
R4570 n_3_17_0 n_3_18_0 1626.1218451089555
R4571 n_3_17_0 n_3_17_1 56.90875931090384
R4572 n_3_17_1 n_4_17_1 10.525836182919262
R4573 n_3_17_1 n_3_18_1 2276.570583152538
R4574 n_3_17_1 n_3_17_2 129.33808934296326
R4575 n_3_17_2 n_4_17_2 18.796136040927255
R4576 n_3_17_2 n_3_18_2 4065.3046127723887
R4577 n_3_17_2 n_3_17_3 121.06045162501361
R4578 n_3_17_3 n_4_17_3 263.14590457298135
R4579 n_3_17_3 n_3_18_3 56914.264578813396
R4580 n_3_17_3 n_3_17_4 1.6095406673791
R4581 n_3_17_4 n_4_17_4 7.974118320393374
R4582 n_3_17_4 n_3_18_4 1724.6746842064663
R4583 n_3_17_4 n_3_17_5 1.330334633241909
R4584 n_3_17_5 n_3_18_5 10840.812300726362
R4585 n_3_17_5 n_3_17_6 0.45986876210831423
R4586 n_3_17_6 n_3_18_6 1806.8020501210601
R4587 n_3_17_6 n_3_17_7 0.6241076057184257
R4588 n_3_17_7 n_3_18_7 3097.374943064684
R4589 n_3_17_7 n_3_17_8 0.4598687621083128
R4590 n_3_17_8 n_3_18_8 3097.374943064684
R4591 n_3_17_8 n_3_17_9 0.4598687621083128
R4592 n_3_17_9 n_3_18_9 3097.374943064684
R4593 n_3_17_9 n_3_17_10 0.4598687621083128
R4594 n_3_17_10 n_3_18_10 3097.374943064684
R4595 n_3_17_10 n_3_17_11 0.45986876210830985
R4596 n_3_17_11 n_3_18_11 3097.374943064723
R4597 n_3_17_11 n_3_17_12 0.4598687621083084
R4598 n_3_17_12 n_3_18_12 3097.374943064704
R4599 n_3_17_12 n_3_17_13 0.45986876210831285
R4600 n_3_17_13 n_3_18_13 3097.3749430646653
R4601 n_3_17_13 n_3_17_14 2.29934381054157
R4602 n_3_17_14 n_3_18_14 344.1527714516309
R4603 n_3_17_14 n_3_17_15 71.04972374573515
R4604 n_3_17_15 n_4_17_15 526.291809145958
R4605 n_3_17_15 n_3_18_15 113828.52915762579
R4606 n_3_18_0 n_4_18_0 7.518454416370901
R4607 n_3_18_0 n_3_19_0 1626.1218451089546
R4608 n_3_18_0 n_3_18_1 56.90875931090384
R4609 n_3_18_1 n_4_18_1 10.525836182919262
R4610 n_3_18_1 n_3_19_1 2276.5705831525365
R4611 n_3_18_1 n_3_18_2 129.33808934296326
R4612 n_3_18_2 n_4_18_2 18.796136040927255
R4613 n_3_18_2 n_3_19_2 4065.3046127723865
R4614 n_3_18_2 n_3_18_3 121.06045162501361
R4615 n_3_18_3 n_4_18_3 263.14590457298135
R4616 n_3_18_3 n_3_19_3 56914.26457881337
R4617 n_3_18_3 n_3_18_4 1.6095406673791
R4618 n_3_18_4 n_4_18_4 7.974118320393374
R4619 n_3_18_4 n_3_19_4 1724.6746842064654
R4620 n_3_18_4 n_3_18_5 1.330334633241909
R4621 n_3_18_5 n_3_19_5 10840.812300726357
R4622 n_3_18_5 n_3_18_6 0.45986876210831423
R4623 n_3_18_6 n_3_19_6 1806.802050121059
R4624 n_3_18_6 n_3_18_7 0.6241076057184257
R4625 n_3_18_7 n_3_19_7 3097.374943064682
R4626 n_3_18_7 n_3_18_8 0.4598687621083128
R4627 n_3_18_8 n_3_19_8 3097.374943064682
R4628 n_3_18_8 n_3_18_9 0.4598687621083128
R4629 n_3_18_9 n_3_19_9 3097.374943064682
R4630 n_3_18_9 n_3_18_10 0.4598687621083128
R4631 n_3_18_10 n_3_19_10 3097.374943064682
R4632 n_3_18_10 n_3_18_11 0.45986876210830985
R4633 n_3_18_11 n_3_19_11 3097.3749430647213
R4634 n_3_18_11 n_3_18_12 0.4598687621083084
R4635 n_3_18_12 n_3_19_12 3097.374943064702
R4636 n_3_18_12 n_3_18_13 0.45986876210831285
R4637 n_3_18_13 n_3_19_13 3097.374943064663
R4638 n_3_18_13 n_3_18_14 2.29934381054157
R4639 n_3_18_14 n_3_19_14 344.15277145163066
R4640 n_3_18_14 n_3_18_15 71.04972374573515
R4641 n_3_18_15 n_4_18_15 526.291809145958
R4642 n_3_18_15 n_3_19_15 113828.52915762572
R4643 n_3_19_0 n_4_19_0 7.518454416370912
R4644 n_3_19_0 n_3_20_0 827.2138145479913
R4645 n_3_19_0 n_3_19_1 56.9087593109039
R4646 n_3_19_1 n_4_19_1 10.525836182919274
R4647 n_3_19_1 n_3_20_1 1158.0993403671878
R4648 n_3_19_1 n_3_19_2 129.33808934296343
R4649 n_3_19_2 n_4_19_2 18.796136040927276
R4650 n_3_19_2 n_3_20_2 2068.034536369978
R4651 n_3_19_2 n_3_19_3 121.06045162501377
R4652 n_3_19_3 n_4_19_3 263.14590457298164
R4653 n_3_19_3 n_3_20_3 28952.48350917967
R4654 n_3_19_3 n_3_19_4 1.6095406673791017
R4655 n_3_19_4 n_4_19_4 7.974118320393382
R4656 n_3_19_4 n_3_20_4 877.3479851266566
R4657 n_3_19_4 n_3_19_5 1.3303346332419106
R4658 n_3_19_5 n_3_20_5 5514.758763653271
R4659 n_3_19_5 n_3_19_6 0.45986876210831473
R4660 n_3_19_6 n_3_20_6 919.1264606088783
R4661 n_3_19_6 n_3_19_7 0.6241076057184265
R4662 n_3_19_7 n_3_20_7 1575.6453610437964
R4663 n_3_19_7 n_3_19_8 0.4598687621083133
R4664 n_3_19_8 n_3_20_8 1575.6453610437964
R4665 n_3_19_8 n_3_19_9 0.4598687621083133
R4666 n_3_19_9 n_3_20_9 1575.6453610437964
R4667 n_3_19_9 n_3_19_10 0.4598687621083133
R4668 n_3_19_10 n_3_20_10 1575.6453610437964
R4669 n_3_19_10 n_3_19_11 0.45986876210831035
R4670 n_3_19_11 n_3_20_11 1575.6453610438164
R4671 n_3_19_11 n_3_19_12 0.45986876210830885
R4672 n_3_19_12 n_3_20_12 1575.6453610438066
R4673 n_3_19_12 n_3_19_13 0.4598687621083133
R4674 n_3_19_13 n_3_20_13 1575.6453610437866
R4675 n_3_19_13 n_3_19_14 2.2993438105415724
R4676 n_3_19_14 n_3_20_14 175.0717067826437
R4677 n_3_19_14 n_3_19_15 71.04972374573525
R4678 n_3_19_15 n_4_19_15 526.2918091459586
R4679 n_3_19_15 n_3_20_15 57904.967018358824
R4680 n_3_20_0 n_4_20_0 431.92313533937494
R4681 n_3_20_0 n_3_21_0 28.305783987028974
R4682 n_3_20_0 n_3_20_1 3269.3168553789146
R4683 n_3_20_1 n_4_20_1 604.6923894751247
R4684 n_3_20_1 n_3_21_1 39.628097581840564
R4685 n_3_20_1 n_3_20_2 7430.265580406624
R4686 n_3_20_2 n_4_20_2 1079.8078383484374
R4687 n_3_20_2 n_3_21_2 70.76445996757244
R4688 n_3_20_2 n_3_20_3 6954.7285832606
R4689 n_3_20_3 n_4_20_3 15117.309736878105
R4690 n_3_20_3 n_3_21_3 990.7024395460132
R4691 n_3_20_3 n_3_20_4 92.46552722283808
R4692 n_3_20_4 n_4_20_4 458.1002950569124
R4693 n_3_20_4 n_3_21_4 30.021286046848882
R4694 n_3_20_4 n_3_20_5 76.42558882703963
R4695 n_3_20_5 n_3_21_5 188.705226580193
R4696 n_3_20_5 n_3_20_6 26.41872206366802
R4697 n_3_20_6 n_3_21_6 31.45087109669883
R4698 n_3_20_6 n_3_20_7 35.85397994354942
R4699 n_3_20_7 n_3_21_7 53.915779022912446
R4700 n_3_20_7 n_3_20_8 26.41872206366794
R4701 n_3_20_8 n_3_21_8 53.915779022912446
R4702 n_3_20_8 n_3_20_9 26.41872206366794
R4703 n_3_20_9 n_3_21_9 53.915779022912446
R4704 n_3_20_9 n_3_20_10 26.41872206366794
R4705 n_3_20_10 n_3_21_10 53.915779022912446
R4706 n_3_20_10 n_3_20_11 26.418722063667772
R4707 n_3_20_11 n_3_21_11 53.91577902291313
R4708 n_3_20_11 n_3_20_12 26.418722063667687
R4709 n_3_20_12 n_3_21_12 53.915779022912794
R4710 n_3_20_12 n_3_20_13 26.418722063667936
R4711 n_3_20_13 n_3_21_13 53.91577902291212
R4712 n_3_20_13 n_3_20_14 132.09361031834004
R4713 n_3_20_14 n_3_21_14 5.990642113656927
R4714 n_3_20_14 n_3_20_15 4081.6925588367444
R4715 n_3_20_15 n_4_20_15 30234.61947375594
R4716 n_3_20_15 n_3_21_15 1981.4048790920087
R4717 n_3_21_0 n_4_21_0 431.92313533937494
R4718 n_3_21_0 n_3_22_0 28.30578398702797
R4719 n_3_21_0 n_3_21_1 3269.3168553789146
R4720 n_3_21_1 n_4_21_1 604.6923894751247
R4721 n_3_21_1 n_3_22_1 39.62809758183916
R4722 n_3_21_1 n_3_21_2 7430.265580406624
R4723 n_3_21_2 n_4_21_2 1079.8078383484374
R4724 n_3_21_2 n_3_22_2 70.76445996756992
R4725 n_3_21_2 n_3_21_3 6954.7285832606
R4726 n_3_21_3 n_4_21_3 15117.309736878105
R4727 n_3_21_3 n_3_22_3 990.702439545978
R4728 n_3_21_3 n_3_21_4 92.46552722283808
R4729 n_3_21_4 n_4_21_4 458.1002950569124
R4730 n_3_21_4 n_3_22_4 30.021286046847816
R4731 n_3_21_4 n_3_21_5 76.42558882703963
R4732 n_3_21_5 n_3_22_5 188.70522658018632
R4733 n_3_21_5 n_3_21_6 26.41872206366802
R4734 n_3_21_6 n_3_22_6 31.45087109669771
R4735 n_3_21_6 n_3_21_7 35.85397994354942
R4736 n_3_21_7 n_3_22_7 53.915779022910534
R4737 n_3_21_7 n_3_21_8 26.41872206366794
R4738 n_3_21_8 n_3_22_8 53.915779022910534
R4739 n_3_21_8 n_3_21_9 26.41872206366794
R4740 n_3_21_9 n_3_22_9 53.915779022910534
R4741 n_3_21_9 n_3_21_10 26.41872206366794
R4742 n_3_21_10 n_3_22_10 53.915779022910534
R4743 n_3_21_10 n_3_21_11 26.418722063667772
R4744 n_3_21_11 n_3_22_11 53.91577902291121
R4745 n_3_21_11 n_3_21_12 26.418722063667687
R4746 n_3_21_12 n_3_22_12 53.91577902291088
R4747 n_3_21_12 n_3_21_13 26.418722063667936
R4748 n_3_21_13 n_3_22_13 53.9157790229102
R4749 n_3_21_13 n_3_21_14 132.09361031834004
R4750 n_3_21_14 n_3_22_14 5.990642113656714
R4751 n_3_21_14 n_3_21_15 4081.6925588367444
R4752 n_3_21_15 n_4_21_15 30234.61947375594
R4753 n_3_21_15 n_3_22_15 1981.4048790919383
R4754 n_3_22_0 n_4_22_0 431.9231353394056
R4755 n_3_22_0 n_3_23_0 28.30578398702797
R4756 n_3_22_0 n_3_22_1 3269.316855379147
R4757 n_3_22_1 n_4_22_1 604.6923894751677
R4758 n_3_22_1 n_3_23_1 39.62809758183916
R4759 n_3_22_1 n_3_22_2 7430.265580407153
R4760 n_3_22_2 n_4_22_2 1079.807838348514
R4761 n_3_22_2 n_3_23_2 70.76445996756992
R4762 n_3_22_2 n_3_22_3 6954.728583261095
R4763 n_3_22_3 n_4_22_3 15117.30973687918
R4764 n_3_22_3 n_3_23_3 990.702439545978
R4765 n_3_22_3 n_3_22_4 92.46552722284464
R4766 n_3_22_4 n_4_22_4 458.10029505694484
R4767 n_3_22_4 n_3_23_4 30.021286046847816
R4768 n_3_22_4 n_3_22_5 76.42558882704506
R4769 n_3_22_5 n_3_23_5 188.70522658018632
R4770 n_3_22_5 n_3_22_6 26.418722063669897
R4771 n_3_22_6 n_3_23_6 31.45087109669771
R4772 n_3_22_6 n_3_22_7 35.85397994355196
R4773 n_3_22_7 n_3_23_7 53.915779022910534
R4774 n_3_22_7 n_3_22_8 26.418722063669815
R4775 n_3_22_8 n_3_23_8 53.915779022910534
R4776 n_3_22_8 n_3_22_9 26.418722063669815
R4777 n_3_22_9 n_3_23_9 53.915779022910534
R4778 n_3_22_9 n_3_22_10 26.418722063669815
R4779 n_3_22_10 n_3_23_10 53.915779022910534
R4780 n_3_22_10 n_3_22_11 26.418722063669648
R4781 n_3_22_11 n_3_23_11 53.91577902291121
R4782 n_3_22_11 n_3_22_12 26.418722063669563
R4783 n_3_22_12 n_3_23_12 53.91577902291088
R4784 n_3_22_12 n_3_22_13 26.41872206366981
R4785 n_3_22_13 n_3_23_13 53.9157790229102
R4786 n_3_22_13 n_3_22_14 132.0936103183494
R4787 n_3_22_14 n_3_23_14 5.990642113656714
R4788 n_3_22_14 n_3_22_15 4081.692558837034
R4789 n_3_22_15 n_4_22_15 30234.61947375809
R4790 n_3_22_15 n_3_23_15 1981.4048790919383
R4791 n_3_23_0 n_4_23_0 431.92313533937494
R4792 n_3_23_0 n_3_24_0 326.2736359366231
R4793 n_3_23_0 n_3_23_1 3269.3168553789146
R4794 n_3_23_1 n_4_23_1 604.6923894751247
R4795 n_3_23_1 n_3_24_1 456.7830903112724
R4796 n_3_23_1 n_3_23_2 7430.265580406624
R4797 n_3_23_2 n_4_23_2 1079.8078383484374
R4798 n_3_23_2 n_3_24_2 815.6840898415578
R4799 n_3_23_2 n_3_23_3 6954.7285832606
R4800 n_3_23_3 n_4_23_3 15117.309736878105
R4801 n_3_23_3 n_3_24_3 11419.5772577818
R4802 n_3_23_3 n_3_23_4 92.46552722283808
R4803 n_3_23_4 n_4_23_4 458.1002950569124
R4804 n_3_23_4 n_3_24_4 346.04779569035753
R4805 n_3_23_4 n_3_23_5 76.42558882703963
R4806 n_3_23_5 n_3_24_5 2175.157572910819
R4807 n_3_23_5 n_3_23_6 26.41872206366802
R4808 n_3_23_6 n_3_24_6 362.52626215180317
R4809 n_3_23_6 n_3_23_7 35.85397994354942
R4810 n_3_23_7 n_3_24_7 621.4735922602358
R4811 n_3_23_7 n_3_23_8 26.41872206366794
R4812 n_3_23_8 n_3_24_8 621.4735922602358
R4813 n_3_23_8 n_3_23_9 26.41872206366794
R4814 n_3_23_9 n_3_24_9 621.4735922602358
R4815 n_3_23_9 n_3_23_10 26.41872206366794
R4816 n_3_23_10 n_3_24_10 621.4735922602358
R4817 n_3_23_10 n_3_23_11 26.418722063667772
R4818 n_3_23_11 n_3_24_11 621.4735922602437
R4819 n_3_23_11 n_3_23_12 26.418722063667687
R4820 n_3_23_12 n_3_24_12 621.4735922602399
R4821 n_3_23_12 n_3_23_13 26.418722063667936
R4822 n_3_23_13 n_3_24_13 621.4735922602321
R4823 n_3_23_13 n_3_23_14 132.09361031834004
R4824 n_3_23_14 n_3_24_14 69.05262136224829
R4825 n_3_23_14 n_3_23_15 4081.6925588367444
R4826 n_3_23_15 n_4_23_15 30234.61947375594
R4827 n_3_23_15 n_3_24_15 22839.154515563394
R4828 n_3_24_0 n_4_24_0 19.58524578255056
R4829 n_3_24_0 n_3_25_0 624.2414878862163
R4830 n_3_24_0 n_3_24_1 148.24483551528397
R4831 n_3_24_1 n_4_24_1 27.41934409557079
R4832 n_3_24_1 n_3_25_1 873.9380830407028
R4833 n_3_24_1 n_3_24_2 336.9200807165545
R4834 n_3_24_2 n_4_24_2 48.96311445637642
R4835 n_3_24_2 n_3_25_2 1560.6037197155406
R4836 n_3_24_2 n_3_24_3 315.357195550695
R4837 n_3_24_3 n_4_24_3 685.4836023892691
R4838 n_3_24_3 n_3_25_3 21848.45207601755
R4839 n_3_24_3 n_3_24_4 4.192783226694903
R4840 n_3_24_4 n_4_24_4 20.772230375432397
R4841 n_3_24_4 n_3_25_4 662.0743053338651
R4842 n_3_24_4 n_3_24_5 3.4654636873702773
R4843 n_3_24_5 n_4_24_5 130.56830521700365
R4844 n_3_24_5 n_3_25_5 4161.609919241439
R4845 n_3_24_5 n_3_24_6 1.1979380647699724
R4846 n_3_24_6 n_4_24_6 21.76138420283394
R4847 n_3_24_6 n_3_25_6 693.6016532069063
R4848 n_3_24_6 n_3_24_7 1.6257730879021035
R4849 n_3_24_7 n_4_24_7 37.30523006200116
R4850 n_3_24_7 n_3_25_7 1189.0314054975574
R4851 n_3_24_7 n_3_24_8 1.1979380647699687
R4852 n_3_24_8 n_4_24_8 37.30523006200116
R4853 n_3_24_8 n_3_25_8 1189.0314054975574
R4854 n_3_24_8 n_3_24_9 1.1979380647699687
R4855 n_3_24_9 n_4_24_9 37.30523006200116
R4856 n_3_24_9 n_3_25_9 1189.0314054975574
R4857 n_3_24_9 n_3_24_10 1.1979380647699687
R4858 n_3_24_10 n_4_24_10 37.30523006200116
R4859 n_3_24_10 n_3_25_10 1189.0314054975574
R4860 n_3_24_10 n_3_24_11 1.1979380647699611
R4861 n_3_24_11 n_4_24_11 37.30523006200163
R4862 n_3_24_11 n_3_25_11 1189.0314054975725
R4863 n_3_24_11 n_3_24_12 1.1979380647699571
R4864 n_3_24_12 n_4_24_12 37.30523006200139
R4865 n_3_24_12 n_3_25_12 1189.0314054975652
R4866 n_3_24_12 n_3_24_13 1.1979380647699687
R4867 n_3_24_13 n_4_24_13 37.30523006200092
R4868 n_3_24_13 n_3_25_13 1189.0314054975502
R4869 n_3_24_13 n_3_24_14 5.9896903238498584
R4870 n_3_24_14 n_4_24_14 4.145025562444563
R4871 n_3_24_14 n_3_25_14 132.11460061083946
R4872 n_3_24_14 n_3_24_15 185.08143100696236
R4873 n_3_24_15 n_4_24_15 1370.967204778526
R4874 n_3_24_15 n_3_25_15 43696.90415203471
R4875 n_3_25_0 n_4_25_0 19.585245782550626
R4876 n_3_25_0 n_3_26_0 624.2414878862163
R4877 n_3_25_0 n_3_25_1 148.24483551528445
R4878 n_3_25_1 n_4_25_1 27.419344095570874
R4879 n_3_25_1 n_3_26_1 873.9380830407028
R4880 n_3_25_1 n_3_25_2 336.92008071655556
R4881 n_3_25_2 n_4_25_2 48.96311445637657
R4882 n_3_25_2 n_3_26_2 1560.6037197155406
R4883 n_3_25_2 n_3_25_3 315.357195550696
R4884 n_3_25_3 n_4_25_3 685.4836023892713
R4885 n_3_25_3 n_3_26_3 21848.45207601755
R4886 n_3_25_3 n_3_25_4 4.1927832266949165
R4887 n_3_25_4 n_4_25_4 20.772230375432468
R4888 n_3_25_4 n_3_26_4 662.0743053338651
R4889 n_3_25_4 n_3_25_5 3.4654636873702884
R4890 n_3_25_5 n_4_25_5 130.56830521700405
R4891 n_3_25_5 n_3_26_5 4161.609919241439
R4892 n_3_25_5 n_3_25_6 1.1979380647699762
R4893 n_3_25_6 n_4_25_6 21.76138420283401
R4894 n_3_25_6 n_3_26_6 693.6016532069063
R4895 n_3_25_6 n_3_25_7 1.6257730879021088
R4896 n_3_25_7 n_4_25_7 37.30523006200128
R4897 n_3_25_7 n_3_26_7 1189.0314054975574
R4898 n_3_25_7 n_3_25_8 1.1979380647699727
R4899 n_3_25_8 n_4_25_8 37.30523006200128
R4900 n_3_25_8 n_3_26_8 1189.0314054975574
R4901 n_3_25_8 n_3_25_9 1.1979380647699727
R4902 n_3_25_9 n_4_25_9 37.30523006200128
R4903 n_3_25_9 n_3_26_9 1189.0314054975574
R4904 n_3_25_9 n_3_25_10 1.1979380647699727
R4905 n_3_25_10 n_4_25_10 37.30523006200128
R4906 n_3_25_10 n_3_26_10 1189.0314054975574
R4907 n_3_25_10 n_3_25_11 1.1979380647699651
R4908 n_3_25_11 n_4_25_11 37.305230062001755
R4909 n_3_25_11 n_3_26_11 1189.0314054975725
R4910 n_3_25_11 n_3_25_12 1.1979380647699611
R4911 n_3_25_12 n_4_25_12 37.305230062001506
R4912 n_3_25_12 n_3_26_12 1189.0314054975652
R4913 n_3_25_12 n_3_25_13 1.1979380647699727
R4914 n_3_25_13 n_4_25_13 37.305230062001044
R4915 n_3_25_13 n_3_26_13 1189.0314054975502
R4916 n_3_25_13 n_3_25_14 5.989690323849878
R4917 n_3_25_14 n_4_25_14 4.145025562444577
R4918 n_3_25_14 n_3_26_14 132.11460061083946
R4919 n_3_25_14 n_3_25_15 185.08143100696296
R4920 n_3_25_15 n_4_25_15 1370.9672047785302
R4921 n_3_25_15 n_3_26_15 43696.90415203471
R4922 n_3_26_0 n_4_26_0 19.58524578255056
R4923 n_3_26_0 n_3_27_0 624.2414878862173
R4924 n_3_26_0 n_3_26_1 148.24483551528397
R4925 n_3_26_1 n_4_26_1 27.41934409557079
R4926 n_3_26_1 n_3_27_1 873.9380830407042
R4927 n_3_26_1 n_3_26_2 336.9200807165545
R4928 n_3_26_2 n_4_26_2 48.96311445637642
R4929 n_3_26_2 n_3_27_2 1560.603719715543
R4930 n_3_26_2 n_3_26_3 315.357195550695
R4931 n_3_26_3 n_4_26_3 685.4836023892691
R4932 n_3_26_3 n_3_27_3 21848.452076017587
R4933 n_3_26_3 n_3_26_4 4.192783226694903
R4934 n_3_26_4 n_4_26_4 20.772230375432397
R4935 n_3_26_4 n_3_27_4 662.0743053338662
R4936 n_3_26_4 n_3_26_5 3.4654636873702773
R4937 n_3_26_5 n_4_26_5 130.56830521700365
R4938 n_3_26_5 n_3_27_5 4161.609919241445
R4939 n_3_26_5 n_3_26_6 1.1979380647699724
R4940 n_3_26_6 n_4_26_6 21.76138420283394
R4941 n_3_26_6 n_3_27_6 693.6016532069075
R4942 n_3_26_6 n_3_26_7 1.6257730879021035
R4943 n_3_26_7 n_4_26_7 37.30523006200116
R4944 n_3_26_7 n_3_27_7 1189.0314054975593
R4945 n_3_26_7 n_3_26_8 1.1979380647699687
R4946 n_3_26_8 n_4_26_8 37.30523006200116
R4947 n_3_26_8 n_3_27_8 1189.0314054975593
R4948 n_3_26_8 n_3_26_9 1.1979380647699687
R4949 n_3_26_9 n_4_26_9 37.30523006200116
R4950 n_3_26_9 n_3_27_9 1189.0314054975593
R4951 n_3_26_9 n_3_26_10 1.1979380647699687
R4952 n_3_26_10 n_4_26_10 37.30523006200116
R4953 n_3_26_10 n_3_27_10 1189.0314054975593
R4954 n_3_26_10 n_3_26_11 1.1979380647699611
R4955 n_3_26_11 n_4_26_11 37.30523006200163
R4956 n_3_26_11 n_3_27_11 1189.0314054975743
R4957 n_3_26_11 n_3_26_12 1.1979380647699571
R4958 n_3_26_12 n_4_26_12 37.30523006200139
R4959 n_3_26_12 n_3_27_12 1189.031405497567
R4960 n_3_26_12 n_3_26_13 1.1979380647699687
R4961 n_3_26_13 n_4_26_13 37.30523006200092
R4962 n_3_26_13 n_3_27_13 1189.031405497552
R4963 n_3_26_13 n_3_26_14 5.9896903238498584
R4964 n_3_26_14 n_4_26_14 4.145025562444563
R4965 n_3_26_14 n_3_27_14 132.11460061083966
R4966 n_3_26_14 n_3_26_15 185.08143100696236
R4967 n_3_26_15 n_4_26_15 1370.967204778526
R4968 n_3_26_15 n_3_27_15 43696.90415203478
R4969 n_3_27_0 n_4_27_0 19.58524578255056
R4970 n_3_27_0 n_3_27_1 148.24483551528397
R4971 n_3_27_1 n_4_27_1 27.41934409557079
R4972 n_3_27_1 n_3_27_2 336.9200807165545
R4973 n_3_27_2 n_4_27_2 48.96311445637642
R4974 n_3_27_2 n_3_27_3 315.357195550695
R4975 n_3_27_3 n_4_27_3 685.4836023892691
R4976 n_3_27_3 n_3_27_4 4.192783226694903
R4977 n_3_27_4 n_4_27_4 20.772230375432397
R4978 n_3_27_4 n_3_27_5 3.4654636873702773
R4979 n_3_27_5 n_4_27_5 130.56830521700365
R4980 n_3_27_5 n_3_27_6 1.1979380647699724
R4981 n_3_27_6 n_4_27_6 21.76138420283394
R4982 n_3_27_6 n_3_27_7 1.6257730879021035
R4983 n_3_27_7 n_4_27_7 37.30523006200116
R4984 n_3_27_7 n_3_27_8 1.1979380647699687
R4985 n_3_27_8 n_4_27_8 37.30523006200116
R4986 n_3_27_8 n_3_27_9 1.1979380647699687
R4987 n_3_27_9 n_4_27_9 37.30523006200116
R4988 n_3_27_9 n_3_27_10 1.1979380647699687
R4989 n_3_27_10 n_4_27_10 37.30523006200116
R4990 n_3_27_10 n_3_27_11 1.1979380647699611
R4991 n_3_27_11 n_4_27_11 37.30523006200163
R4992 n_3_27_11 n_3_27_12 1.1979380647699571
R4993 n_3_27_12 n_4_27_12 37.30523006200139
R4994 n_3_27_12 n_3_27_13 1.1979380647699687
R4995 n_3_27_13 n_4_27_13 37.30523006200092
R4996 n_3_27_13 n_3_27_14 5.9896903238498584
R4997 n_3_27_14 n_4_27_14 4.145025562444563
R4998 n_3_27_14 n_3_27_15 185.08143100696236
R4999 n_3_27_15 n_4_27_15 1370.967204778526
R5000 n_4_0_0 n_5_0_0 6.477753242544629
R5001 n_4_0_0 n_4_1_0 3150.5002585262537
R5002 n_4_0_0 n_4_0_1 748.180505838903
R5003 n_4_0_1 n_5_0_1 9.068854539562478
R5004 n_4_0_1 n_4_1_1 4410.700361936755
R5005 n_4_0_1 n_4_0_2 1700.4102405429612
R5006 n_4_0_2 n_5_0_2 16.19438310636157
R5007 n_4_0_2 n_4_1_2 7876.250646315634
R5008 n_4_0_2 n_4_0_3 1591.5839851482117
R5009 n_4_0_3 n_5_0_3 226.72136348906173
R5010 n_4_0_3 n_4_1_3 110267.50904841878
R5011 n_4_0_3 n_4_0_4 21.160660771201314
R5012 n_4_0_4 n_5_0_4 6.870344348153387
R5013 n_4_0_4 n_4_1_4 3341.439668133902
R5014 n_4_0_4 n_4_0_5 17.489933902727618
R5015 n_4_0_5 n_5_0_5 43.18502161696414
R5016 n_4_0_5 n_4_1_5 21003.33505684167
R5017 n_4_0_5 n_4_0_6 6.0459030774860905
R5018 n_4_0_6 n_5_0_6 7.197503602827358
R5019 n_4_0_6 n_4_1_6 3500.5558428069457
R5020 n_4_0_6 n_4_0_7 8.205154176588255
R5021 n_4_0_7 n_5_0_7 12.338577604846938
R5022 n_4_0_7 n_4_1_7 6000.952873383354
R5023 n_4_0_7 n_4_0_8 6.045903077486072
R5024 n_4_0_8 n_5_0_8 12.338577604846938
R5025 n_4_0_8 n_4_1_8 6000.952873383354
R5026 n_4_0_8 n_4_0_9 6.045903077486072
R5027 n_4_0_9 n_5_0_9 12.338577604846938
R5028 n_4_0_9 n_4_1_9 6000.952873383354
R5029 n_4_0_9 n_4_0_10 6.045903077486072
R5030 n_4_0_10 n_5_0_10 12.338577604846938
R5031 n_4_0_10 n_4_1_10 6000.952873383354
R5032 n_4_0_10 n_4_0_11 6.045903077486033
R5033 n_4_0_11 n_5_0_11 12.338577604847094
R5034 n_4_0_11 n_4_1_11 6000.9528733834295
R5035 n_4_0_11 n_4_0_12 6.045903077486013
R5036 n_4_0_12 n_5_0_12 12.33857760484702
R5037 n_4_0_12 n_4_1_12 6000.952873383392
R5038 n_4_0_12 n_4_0_13 6.045903077486072
R5039 n_4_0_13 n_5_0_13 12.33857760484686
R5040 n_4_0_13 n_4_1_13 6000.952873383315
R5041 n_4_0_13 n_4_0_14 30.229515387430432
R5042 n_4_0_14 n_5_0_14 1.3709530672052124
R5043 n_4_0_14 n_4_1_14 666.772541487038
R5044 n_4_0_14 n_4_0_15 934.0920254716088
R5045 n_4_0_15 n_5_0_15 453.44272697811954
R5046 n_4_0_15 n_4_1_15 220535.01809683556
R5047 n_4_1_0 n_5_1_0 6.477753242544629
R5048 n_4_1_0 n_4_2_0 3150.5002585262537
R5049 n_4_1_0 n_4_1_1 748.180505838903
R5050 n_4_1_1 n_5_1_1 9.068854539562478
R5051 n_4_1_1 n_4_2_1 4410.700361936755
R5052 n_4_1_1 n_4_1_2 1700.4102405429612
R5053 n_4_1_2 n_5_1_2 16.19438310636157
R5054 n_4_1_2 n_4_2_2 7876.250646315634
R5055 n_4_1_2 n_4_1_3 1591.5839851482117
R5056 n_4_1_3 n_5_1_3 226.72136348906173
R5057 n_4_1_3 n_4_2_3 110267.50904841878
R5058 n_4_1_3 n_4_1_4 21.160660771201314
R5059 n_4_1_4 n_5_1_4 6.870344348153387
R5060 n_4_1_4 n_4_2_4 3341.439668133902
R5061 n_4_1_4 n_4_1_5 17.489933902727618
R5062 n_4_1_5 n_5_1_5 43.18502161696414
R5063 n_4_1_5 n_4_2_5 21003.33505684167
R5064 n_4_1_5 n_4_1_6 6.0459030774860905
R5065 n_4_1_6 n_5_1_6 7.197503602827358
R5066 n_4_1_6 n_4_2_6 3500.5558428069457
R5067 n_4_1_6 n_4_1_7 8.205154176588255
R5068 n_4_1_7 n_5_1_7 12.338577604846938
R5069 n_4_1_7 n_4_2_7 6000.952873383354
R5070 n_4_1_7 n_4_1_8 6.045903077486072
R5071 n_4_1_8 n_5_1_8 12.338577604846938
R5072 n_4_1_8 n_4_2_8 6000.952873383354
R5073 n_4_1_8 n_4_1_9 6.045903077486072
R5074 n_4_1_9 n_5_1_9 12.338577604846938
R5075 n_4_1_9 n_4_2_9 6000.952873383354
R5076 n_4_1_9 n_4_1_10 6.045903077486072
R5077 n_4_1_10 n_5_1_10 12.338577604846938
R5078 n_4_1_10 n_4_2_10 6000.952873383354
R5079 n_4_1_10 n_4_1_11 6.045903077486033
R5080 n_4_1_11 n_5_1_11 12.338577604847094
R5081 n_4_1_11 n_4_2_11 6000.9528733834295
R5082 n_4_1_11 n_4_1_12 6.045903077486013
R5083 n_4_1_12 n_5_1_12 12.33857760484702
R5084 n_4_1_12 n_4_2_12 6000.952873383392
R5085 n_4_1_12 n_4_1_13 6.045903077486072
R5086 n_4_1_13 n_5_1_13 12.33857760484686
R5087 n_4_1_13 n_4_2_13 6000.952873383315
R5088 n_4_1_13 n_4_1_14 30.229515387430432
R5089 n_4_1_14 n_5_1_14 1.3709530672052124
R5090 n_4_1_14 n_4_2_14 666.772541487038
R5091 n_4_1_14 n_4_1_15 934.0920254716088
R5092 n_4_1_15 n_5_1_15 453.44272697811954
R5093 n_4_1_15 n_4_2_15 220535.01809683556
R5094 n_4_2_0 n_5_2_0 6.477753242544629
R5095 n_4_2_0 n_4_3_0 3150.5002585262537
R5096 n_4_2_0 n_4_2_1 748.180505838903
R5097 n_4_2_1 n_5_2_1 9.068854539562478
R5098 n_4_2_1 n_4_3_1 4410.700361936755
R5099 n_4_2_1 n_4_2_2 1700.4102405429612
R5100 n_4_2_2 n_5_2_2 16.19438310636157
R5101 n_4_2_2 n_4_3_2 7876.250646315634
R5102 n_4_2_2 n_4_2_3 1591.5839851482117
R5103 n_4_2_3 n_5_2_3 226.72136348906173
R5104 n_4_2_3 n_4_3_3 110267.50904841878
R5105 n_4_2_3 n_4_2_4 21.160660771201314
R5106 n_4_2_4 n_5_2_4 6.870344348153387
R5107 n_4_2_4 n_4_3_4 3341.439668133902
R5108 n_4_2_4 n_4_2_5 17.489933902727618
R5109 n_4_2_5 n_5_2_5 43.18502161696414
R5110 n_4_2_5 n_4_3_5 21003.33505684167
R5111 n_4_2_5 n_4_2_6 6.0459030774860905
R5112 n_4_2_6 n_5_2_6 7.197503602827358
R5113 n_4_2_6 n_4_3_6 3500.5558428069457
R5114 n_4_2_6 n_4_2_7 8.205154176588255
R5115 n_4_2_7 n_5_2_7 12.338577604846938
R5116 n_4_2_7 n_4_3_7 6000.952873383354
R5117 n_4_2_7 n_4_2_8 6.045903077486072
R5118 n_4_2_8 n_5_2_8 12.338577604846938
R5119 n_4_2_8 n_4_3_8 6000.952873383354
R5120 n_4_2_8 n_4_2_9 6.045903077486072
R5121 n_4_2_9 n_5_2_9 12.338577604846938
R5122 n_4_2_9 n_4_3_9 6000.952873383354
R5123 n_4_2_9 n_4_2_10 6.045903077486072
R5124 n_4_2_10 n_5_2_10 12.338577604846938
R5125 n_4_2_10 n_4_3_10 6000.952873383354
R5126 n_4_2_10 n_4_2_11 6.045903077486033
R5127 n_4_2_11 n_5_2_11 12.338577604847094
R5128 n_4_2_11 n_4_3_11 6000.9528733834295
R5129 n_4_2_11 n_4_2_12 6.045903077486013
R5130 n_4_2_12 n_5_2_12 12.33857760484702
R5131 n_4_2_12 n_4_3_12 6000.952873383392
R5132 n_4_2_12 n_4_2_13 6.045903077486072
R5133 n_4_2_13 n_5_2_13 12.33857760484686
R5134 n_4_2_13 n_4_3_13 6000.952873383315
R5135 n_4_2_13 n_4_2_14 30.229515387430432
R5136 n_4_2_14 n_5_2_14 1.3709530672052124
R5137 n_4_2_14 n_4_3_14 666.772541487038
R5138 n_4_2_14 n_4_2_15 934.0920254716088
R5139 n_4_2_15 n_5_2_15 453.44272697811954
R5140 n_4_2_15 n_4_3_15 220535.01809683556
R5141 n_4_3_0 n_5_3_0 6.477753242544629
R5142 n_4_3_0 n_4_4_0 1646.6785783889497
R5143 n_4_3_0 n_4_3_1 748.180505838903
R5144 n_4_3_1 n_5_3_1 9.068854539562478
R5145 n_4_3_1 n_4_4_1 2305.35000974453
R5146 n_4_3_1 n_4_3_2 1700.4102405429612
R5147 n_4_3_2 n_5_3_2 16.19438310636157
R5148 n_4_3_2 n_4_4_2 4116.696445972375
R5149 n_4_3_2 n_4_3_3 1591.5839851482117
R5150 n_4_3_3 n_5_3_3 226.72136348906173
R5151 n_4_3_3 n_4_4_3 57633.75024361319
R5152 n_4_3_3 n_4_3_4 21.160660771201314
R5153 n_4_3_4 n_5_3_4 6.870344348153387
R5154 n_4_3_4 n_4_4_4 1746.4772801094905
R5155 n_4_3_4 n_4_3_5 17.489933902727618
R5156 n_4_3_5 n_5_3_5 43.18502161696414
R5157 n_4_3_5 n_4_3_6 6.0459030774860905
R5158 n_4_3_6 n_5_3_6 7.197503602827358
R5159 n_4_3_6 n_4_3_7 8.205154176588255
R5160 n_4_3_7 n_5_3_7 12.338577604846938
R5161 n_4_3_7 n_4_3_8 6.045903077486072
R5162 n_4_3_8 n_5_3_8 12.338577604846938
R5163 n_4_3_8 n_4_3_9 6.045903077486072
R5164 n_4_3_9 n_5_3_9 12.338577604846938
R5165 n_4_3_9 n_4_3_10 6.045903077486072
R5166 n_4_3_10 n_5_3_10 12.338577604846938
R5167 n_4_3_10 n_4_3_11 6.045903077486033
R5168 n_4_3_11 n_5_3_11 12.338577604847094
R5169 n_4_3_11 n_4_3_12 6.045903077486013
R5170 n_4_3_12 n_5_3_12 12.33857760484702
R5171 n_4_3_12 n_4_3_13 6.045903077486072
R5172 n_4_3_13 n_5_3_13 12.33857760484686
R5173 n_4_3_13 n_4_3_14 30.229515387430432
R5174 n_4_3_14 n_5_3_14 1.3709530672052124
R5175 n_4_3_14 n_4_3_15 934.0920254716088
R5176 n_4_3_15 n_5_3_15 453.44272697811954
R5177 n_4_3_15 n_4_4_15 115267.50048722533
R5178 n_4_4_0 n_5_4_0 142.8573874630586
R5179 n_4_4_0 n_4_5_0 142.85689825164724
R5180 n_4_4_0 n_4_4_1 16500.02839147187
R5181 n_4_4_1 n_5_4_1 200.000342448282
R5182 n_4_4_1 n_4_5_1 199.99965755230613
R5183 n_4_4_1 n_4_4_2 37500.06452607243
R5184 n_4_4_2 n_5_4_2 357.14346865764645
R5185 n_4_4_2 n_4_5_2 357.1422456291181
R5186 n_4_4_2 n_4_4_3 35100.060396403795
R5187 n_4_4_3 n_5_4_3 5000.008561207046
R5188 n_4_4_3 n_4_5_3 4999.9914388076495
R5189 n_4_4_3 n_4_4_4 466.6674696577907
R5190 n_4_4_4 n_5_4_4 151.51541094566807
R5191 n_4_4_4 n_4_5_4 151.51489208508025
R5192 n_4_4_15 n_5_4_15 10000.017122414003
R5193 n_4_4_15 n_4_5_15 9999.982877615208
R5194 n_4_5_0 n_5_5_0 142.85738746305609
R5195 n_4_5_0 n_4_6_0 142.85689825164852
R5196 n_4_5_0 n_4_5_1 16500.028391471576
R5197 n_4_5_1 n_5_5_1 200.00034244827845
R5198 n_4_5_1 n_4_6_1 199.99965755230792
R5199 n_4_5_1 n_4_5_2 37500.064526071765
R5200 n_4_5_2 n_5_5_2 357.14346865764014
R5201 n_4_5_2 n_4_6_2 357.1422456291213
R5202 n_4_5_2 n_4_5_3 35100.06039640317
R5203 n_4_5_3 n_5_5_3 5000.008561206957
R5204 n_4_5_3 n_4_6_3 4999.991438807694
R5205 n_4_5_3 n_4_5_4 466.6674696577824
R5206 n_4_5_4 n_5_5_4 151.51541094566537
R5207 n_4_5_4 n_4_6_4 151.5148920850816
R5208 n_4_5_15 n_5_5_15 10000.017122413825
R5209 n_4_5_15 n_4_6_15 9999.982877615297
R5210 n_4_6_0 n_5_6_0 142.85738746305609
R5211 n_4_6_0 n_4_7_0 142.85689825164724
R5212 n_4_6_0 n_4_6_1 16500.028391471576
R5213 n_4_6_1 n_5_6_1 200.00034244827845
R5214 n_4_6_1 n_4_7_1 199.99965755230613
R5215 n_4_6_1 n_4_6_2 37500.064526071765
R5216 n_4_6_2 n_5_6_2 357.14346865764014
R5217 n_4_6_2 n_4_7_2 357.1422456291181
R5218 n_4_6_2 n_4_6_3 35100.06039640317
R5219 n_4_6_3 n_5_6_3 5000.008561206957
R5220 n_4_6_3 n_4_7_3 4999.9914388076495
R5221 n_4_6_3 n_4_6_4 466.6674696577824
R5222 n_4_6_4 n_5_6_4 151.51541094566537
R5223 n_4_6_4 n_4_7_4 151.51489208508025
R5224 n_4_6_15 n_5_6_15 10000.017122413825
R5225 n_4_6_15 n_4_7_15 9999.982877615208
R5226 n_4_7_0 n_5_7_0 142.8573874630586
R5227 n_4_7_0 n_4_8_0 4174.885966470811
R5228 n_4_7_0 n_4_7_1 16500.02839147187
R5229 n_4_7_1 n_5_7_1 200.000342448282
R5230 n_4_7_1 n_4_8_1 5844.840353059133
R5231 n_4_7_1 n_4_7_2 37500.06452607243
R5232 n_4_7_2 n_5_7_2 357.14346865764645
R5233 n_4_7_2 n_4_8_2 10437.214916177025
R5234 n_4_7_2 n_4_7_3 35100.060396403795
R5235 n_4_7_3 n_5_7_3 5000.008561207046
R5236 n_4_7_3 n_4_8_3 146121.00882647824
R5237 n_4_7_3 n_4_7_4 466.6674696577907
R5238 n_4_7_4 n_5_7_4 151.51541094566807
R5239 n_4_7_4 n_4_8_4 4427.909358378128
R5240 n_4_7_15 n_5_7_15 10000.017122414003
R5241 n_4_7_15 n_4_8_15 292242.0176529538
R5242 n_4_8_0 n_5_8_0 2.486703368932474
R5243 n_4_8_0 n_4_9_0 8206.915034689977
R5244 n_4_8_0 n_4_8_1 287.214241539764
R5245 n_4_8_1 n_5_8_1 3.481384716505463
R5246 n_4_8_1 n_4_9_1 11489.681048565966
R5247 n_4_8_1 n_4_8_2 652.7596398631
R5248 n_4_8_2 n_5_8_2 6.216758422331184
R5249 n_4_8_2 n_4_9_2 20517.287586724942
R5250 n_4_8_2 n_4_8_3 610.9830229118617
R5251 n_4_8_3 n_5_8_3 87.0346179126365
R5252 n_4_8_3 n_4_9_3 287242.02621414897
R5253 n_4_8_3 n_4_8_4 8.123231073851919
R5254 n_4_8_4 n_5_8_4 2.6374126640192883
R5255 n_4_8_4 n_4_9_4 8704.30382467118
R5256 n_4_8_15 n_5_8_15 174.06923582527145
R5257 n_4_8_15 n_4_9_15 574484.0524282926
R5258 n_4_9_0 n_5_9_0 2.486703368932472
R5259 n_4_9_0 n_4_10_0 8206.915034689977
R5260 n_4_9_0 n_4_9_1 287.2142415397638
R5261 n_4_9_1 n_5_9_1 3.481384716505461
R5262 n_4_9_1 n_4_10_1 11489.681048565966
R5263 n_4_9_1 n_4_9_2 652.7596398630996
R5264 n_4_9_2 n_5_9_2 6.21675842233118
R5265 n_4_9_2 n_4_10_2 20517.287586724942
R5266 n_4_9_2 n_4_9_3 610.9830229118612
R5267 n_4_9_3 n_5_9_3 87.03461791263645
R5268 n_4_9_3 n_4_10_3 287242.02621414897
R5269 n_4_9_3 n_4_9_4 8.123231073851914
R5270 n_4_9_4 n_5_9_4 2.6374126640192865
R5271 n_4_9_4 n_4_10_4 8704.30382467118
R5272 n_4_9_15 n_5_9_15 174.06923582527136
R5273 n_4_9_15 n_4_10_15 574484.0524282926
R5274 n_4_10_0 n_5_10_0 2.486703368932474
R5275 n_4_10_0 n_4_11_0 8206.915034689975
R5276 n_4_10_0 n_4_10_1 287.214241539764
R5277 n_4_10_1 n_5_10_1 3.481384716505463
R5278 n_4_10_1 n_4_11_1 11489.681048565963
R5279 n_4_10_1 n_4_10_2 652.7596398631
R5280 n_4_10_2 n_5_10_2 6.216758422331184
R5281 n_4_10_2 n_4_11_2 20517.287586724935
R5282 n_4_10_2 n_4_10_3 610.9830229118617
R5283 n_4_10_3 n_5_10_3 87.0346179126365
R5284 n_4_10_3 n_4_11_3 287242.02621414885
R5285 n_4_10_3 n_4_10_4 8.123231073851919
R5286 n_4_10_4 n_5_10_4 2.6374126640192883
R5287 n_4_10_4 n_4_11_4 8704.303824671177
R5288 n_4_10_15 n_5_10_15 174.06923582527145
R5289 n_4_10_15 n_4_11_15 574484.0524282925
R5290 n_4_11_0 n_5_11_0 2.486703368932474
R5291 n_4_11_0 n_4_12_0 4174.886089075483
R5292 n_4_11_0 n_4_11_1 287.214241539764
R5293 n_4_11_1 n_5_11_1 3.481384716505463
R5294 n_4_11_1 n_4_12_1 5844.840524705674
R5295 n_4_11_1 n_4_11_2 652.7596398631
R5296 n_4_11_2 n_5_11_2 6.216758422331184
R5297 n_4_11_2 n_4_12_2 10437.215222688706
R5298 n_4_11_2 n_4_11_3 610.9830229118617
R5299 n_4_11_3 n_5_11_3 87.0346179126365
R5300 n_4_11_3 n_4_12_3 146121.01311764176
R5301 n_4_11_3 n_4_11_4 8.123231073851919
R5302 n_4_11_4 n_5_11_4 2.6374126640192883
R5303 n_4_11_4 n_4_12_4 4427.9094884133865
R5304 n_4_11_15 n_5_11_15 174.06923582527145
R5305 n_4_11_15 n_4_12_15 292242.02623528085
R5306 n_4_12_0 n_5_12_0 142.8571422532951
R5307 n_4_12_0 n_4_13_0 142.85714346099064
R5308 n_4_12_0 n_4_12_1 16500.00006974395
R5309 n_4_12_1 n_5_12_1 199.99999915461314
R5310 n_4_12_1 n_4_13_1 200.0000008453869
R5311 n_4_12_1 n_4_12_2 37500.00015850898
R5312 n_4_12_2 n_5_12_2 357.1428556332378
R5313 n_4_12_2 n_4_13_2 357.14285865247666
R5314 n_4_12_2 n_4_12_3 35100.0001483644
R5315 n_4_12_3 n_5_12_3 4999.999978865324
R5316 n_4_12_3 n_4_13_3 5000.000021134669
R5317 n_4_12_3 n_4_12_4 466.6666686392232
R5318 n_4_12_4 n_5_12_4 151.5151508747068
R5319 n_4_12_4 n_4_13_4 151.51515215559598
R5320 n_4_12_15 n_5_12_15 9999.99995773056
R5321 n_4_12_15 n_4_13_15 10000.000042269246
R5322 n_4_13_0 n_5_13_0 142.8571422532951
R5323 n_4_13_0 n_4_14_0 142.85714346099064
R5324 n_4_13_0 n_4_13_1 16500.00006974395
R5325 n_4_13_1 n_5_13_1 199.99999915461314
R5326 n_4_13_1 n_4_14_1 200.0000008453869
R5327 n_4_13_1 n_4_13_2 37500.00015850898
R5328 n_4_13_2 n_5_13_2 357.1428556332378
R5329 n_4_13_2 n_4_14_2 357.14285865247666
R5330 n_4_13_2 n_4_13_3 35100.0001483644
R5331 n_4_13_3 n_5_13_3 4999.999978865324
R5332 n_4_13_3 n_4_14_3 5000.000021134669
R5333 n_4_13_3 n_4_13_4 466.6666686392232
R5334 n_4_13_4 n_5_13_4 151.5151508747068
R5335 n_4_13_4 n_4_14_4 151.51515215559598
R5336 n_4_13_15 n_5_13_15 9999.99995773056
R5337 n_4_13_15 n_4_14_15 10000.000042269246
R5338 n_4_14_0 n_5_14_0 142.8571422532951
R5339 n_4_14_0 n_4_15_0 142.85714346099064
R5340 n_4_14_0 n_4_14_1 16500.00006974395
R5341 n_4_14_1 n_5_14_1 199.99999915461314
R5342 n_4_14_1 n_4_15_1 200.0000008453869
R5343 n_4_14_1 n_4_14_2 37500.00015850898
R5344 n_4_14_2 n_5_14_2 357.1428556332378
R5345 n_4_14_2 n_4_15_2 357.14285865247666
R5346 n_4_14_2 n_4_14_3 35100.0001483644
R5347 n_4_14_3 n_5_14_3 4999.999978865324
R5348 n_4_14_3 n_4_15_3 5000.000021134669
R5349 n_4_14_3 n_4_14_4 466.6666686392232
R5350 n_4_14_4 n_5_14_4 151.5151508747068
R5351 n_4_14_4 n_4_15_4 151.51515215559598
R5352 n_4_14_15 n_5_14_15 9999.99995773056
R5353 n_4_14_15 n_4_15_15 10000.000042269246
R5354 n_4_15_0 n_5_15_0 142.8571422532951
R5355 n_4_15_0 n_4_16_0 4174.88608907548
R5356 n_4_15_0 n_4_15_1 16500.00006974395
R5357 n_4_15_1 n_5_15_1 199.99999915461314
R5358 n_4_15_1 n_4_16_1 5844.840524705671
R5359 n_4_15_1 n_4_15_2 37500.00015850898
R5360 n_4_15_2 n_5_15_2 357.1428556332378
R5361 n_4_15_2 n_4_16_2 10437.215222688701
R5362 n_4_15_2 n_4_15_3 35100.0001483644
R5363 n_4_15_3 n_5_15_3 4999.999978865324
R5364 n_4_15_3 n_4_16_3 146121.01311764168
R5365 n_4_15_3 n_4_15_4 466.6666686392232
R5366 n_4_15_4 n_5_15_4 151.5151508747068
R5367 n_4_15_4 n_4_16_4 4427.909488413384
R5368 n_4_15_15 n_5_15_15 9999.99995773056
R5369 n_4_15_15 n_4_16_15 292242.0262352807
R5370 n_4_16_0 n_5_16_0 2.4867033689324756
R5371 n_4_16_0 n_4_17_0 8206.915034689973
R5372 n_4_16_0 n_4_16_1 287.21424153976415
R5373 n_4_16_1 n_5_16_1 3.481384716505465
R5374 n_4_16_1 n_4_17_1 11489.681048565963
R5375 n_4_16_1 n_4_16_2 652.7596398631005
R5376 n_4_16_2 n_5_16_2 6.216758422331188
R5377 n_4_16_2 n_4_17_2 20517.28758672494
R5378 n_4_16_2 n_4_16_3 610.983022911862
R5379 n_4_16_3 n_5_16_3 87.03461791263655
R5380 n_4_16_3 n_4_17_3 287242.02621414885
R5381 n_4_16_3 n_4_16_4 8.123231073851922
R5382 n_4_16_4 n_5_16_4 2.637412664019289
R5383 n_4_16_4 n_4_17_4 8704.303824671177
R5384 n_4_16_15 n_5_16_15 174.06923582527156
R5385 n_4_16_15 n_4_17_15 574484.0524282925
R5386 n_4_17_0 n_5_17_0 2.486703368932472
R5387 n_4_17_0 n_4_18_0 8206.915034689979
R5388 n_4_17_0 n_4_17_1 287.2142415397638
R5389 n_4_17_1 n_5_17_1 3.481384716505461
R5390 n_4_17_1 n_4_18_1 11489.68104856597
R5391 n_4_17_1 n_4_17_2 652.7596398630996
R5392 n_4_17_2 n_5_17_2 6.21675842233118
R5393 n_4_17_2 n_4_18_2 20517.28758672495
R5394 n_4_17_2 n_4_17_3 610.9830229118612
R5395 n_4_17_3 n_5_17_3 87.03461791263645
R5396 n_4_17_3 n_4_18_3 287242.026214149
R5397 n_4_17_3 n_4_17_4 8.123231073851914
R5398 n_4_17_4 n_5_17_4 2.6374126640192865
R5399 n_4_17_4 n_4_18_4 8704.303824671182
R5400 n_4_17_15 n_5_17_15 174.06923582527136
R5401 n_4_17_15 n_4_18_15 574484.0524282928
R5402 n_4_18_0 n_5_18_0 2.486703368932472
R5403 n_4_18_0 n_4_19_0 8206.915034689973
R5404 n_4_18_0 n_4_18_1 287.2142415397638
R5405 n_4_18_1 n_5_18_1 3.481384716505461
R5406 n_4_18_1 n_4_19_1 11489.681048565963
R5407 n_4_18_1 n_4_18_2 652.7596398630996
R5408 n_4_18_2 n_5_18_2 6.21675842233118
R5409 n_4_18_2 n_4_19_2 20517.28758672494
R5410 n_4_18_2 n_4_18_3 610.9830229118612
R5411 n_4_18_3 n_5_18_3 87.03461791263645
R5412 n_4_18_3 n_4_19_3 287242.02621414885
R5413 n_4_18_3 n_4_18_4 8.123231073851914
R5414 n_4_18_4 n_5_18_4 2.6374126640192865
R5415 n_4_18_4 n_4_19_4 8704.303824671177
R5416 n_4_18_15 n_5_18_15 174.06923582527136
R5417 n_4_18_15 n_4_19_15 574484.0524282925
R5418 n_4_19_0 n_5_19_0 2.4867033689324756
R5419 n_4_19_0 n_4_20_0 4174.886102131099
R5420 n_4_19_0 n_4_19_1 287.21424153976415
R5421 n_4_19_1 n_5_19_1 3.481384716505465
R5422 n_4_19_1 n_4_20_1 5844.8405429835375
R5423 n_4_19_1 n_4_19_2 652.7596398631005
R5424 n_4_19_2 n_5_19_2 6.216758422331188
R5425 n_4_19_2 n_4_20_2 10437.215255327748
R5426 n_4_19_2 n_4_19_3 610.983022911862
R5427 n_4_19_3 n_5_19_3 87.03461791263655
R5428 n_4_19_3 n_4_20_3 146121.01357458835
R5429 n_4_19_3 n_4_19_4 8.123231073851922
R5430 n_4_19_4 n_5_19_4 2.637412664019289
R5431 n_4_19_4 n_4_20_4 4427.909502260252
R5432 n_4_19_15 n_5_19_15 174.06923582527156
R5433 n_4_19_15 n_4_20_15 292242.027149174
R5434 n_4_20_0 n_5_20_0 142.85711614206238
R5435 n_4_20_0 n_4_21_0 142.85716957222837
R5436 n_4_20_0 n_4_20_1 16499.997053896546
R5437 n_4_20_1 n_5_20_1 199.9999625988873
R5438 n_4_20_1 n_4_21_1 200.0000374011197
R5439 n_4_20_1 n_4_20_2 37499.99330431033
R5440 n_4_20_2 n_5_20_2 357.14279035515597
R5441 n_4_20_2 n_4_21_2 357.14292393057093
R5442 n_4_20_2 n_4_20_3 35099.99373283447
R5443 n_4_20_3 n_5_20_3 4999.999064972178
R5444 n_4_20_3 n_4_21_3 5000.000935027988
R5445 n_4_20_3 n_4_20_4 466.666583342529
R5446 n_4_20_4 n_5_20_4 151.5151231809751
R5447 n_4_20_4 n_4_21_4 151.51517984933295
R5448 n_4_20_15 n_5_20_15 9999.998129944266
R5449 n_4_20_15 n_4_21_15 10000.001870055885
R5450 n_4_21_0 n_5_21_0 142.85711614206238
R5451 n_4_21_0 n_4_22_0 142.8571695722233
R5452 n_4_21_0 n_4_21_1 16499.997053896546
R5453 n_4_21_1 n_5_21_1 199.9999625988873
R5454 n_4_21_1 n_4_22_1 200.0000374011126
R5455 n_4_21_1 n_4_21_2 37499.99330431033
R5456 n_4_21_2 n_5_21_2 357.14279035515597
R5457 n_4_21_2 n_4_22_2 357.14292393055825
R5458 n_4_21_2 n_4_21_3 35099.99373283447
R5459 n_4_21_3 n_5_21_3 4999.999064972178
R5460 n_4_21_3 n_4_22_3 5000.000935027811
R5461 n_4_21_3 n_4_21_4 466.666583342529
R5462 n_4_21_4 n_5_21_4 151.5151231809751
R5463 n_4_21_4 n_4_22_4 151.51517984932758
R5464 n_4_21_15 n_5_21_15 9999.998129944266
R5465 n_4_21_15 n_4_22_15 10000.00187005553
R5466 n_4_22_0 n_5_22_0 142.85711614207253
R5467 n_4_22_0 n_4_23_0 142.8571695722233
R5468 n_4_22_0 n_4_22_1 16499.997053897714
R5469 n_4_22_1 n_5_22_1 199.99996259890153
R5470 n_4_22_1 n_4_23_1 200.0000374011126
R5471 n_4_22_1 n_4_22_2 37499.993304312986
R5472 n_4_22_2 n_5_22_2 357.1427903551813
R5473 n_4_22_2 n_4_23_2 357.14292393055825
R5474 n_4_22_2 n_4_22_3 35099.993732836956
R5475 n_4_22_3 n_5_22_3 4999.999064972534
R5476 n_4_22_3 n_4_23_3 5000.000935027811
R5477 n_4_22_3 n_4_22_4 466.66658334256203
R5478 n_4_22_4 n_5_22_4 151.51512318098585
R5479 n_4_22_4 n_4_23_4 151.51517984932758
R5480 n_4_22_15 n_5_22_15 9999.998129944977
R5481 n_4_22_15 n_4_23_15 10000.00187005553
R5482 n_4_23_0 n_5_23_0 142.85711614206238
R5483 n_4_23_0 n_4_24_0 1646.6785783889536
R5484 n_4_23_0 n_4_23_1 16499.997053896546
R5485 n_4_23_1 n_5_23_1 199.9999625988873
R5486 n_4_23_1 n_4_24_1 2305.350009744535
R5487 n_4_23_1 n_4_23_2 37499.99330431033
R5488 n_4_23_2 n_5_23_2 357.14279035515597
R5489 n_4_23_2 n_4_24_2 4116.696445972384
R5490 n_4_23_2 n_4_23_3 35099.99373283447
R5491 n_4_23_3 n_5_23_3 4999.999064972178
R5492 n_4_23_3 n_4_24_3 57633.75024361332
R5493 n_4_23_3 n_4_23_4 466.666583342529
R5494 n_4_23_4 n_5_23_4 151.5151231809751
R5495 n_4_23_4 n_4_24_4 1746.4772801094944
R5496 n_4_23_15 n_5_23_15 9999.998129944266
R5497 n_4_23_15 n_4_24_15 115267.5004872256
R5498 n_4_24_0 n_5_24_0 6.477753800407742
R5499 n_4_24_0 n_4_25_0 3150.4999872056737
R5500 n_4_24_0 n_4_24_1 748.1805702720933
R5501 n_4_24_1 n_5_24_1 9.068855320570838
R5502 n_4_24_1 n_4_25_1 4410.699982087943
R5503 n_4_24_1 n_4_24_2 1700.4103869820299
R5504 n_4_24_2 n_5_24_2 16.194384501019357
R5505 n_4_24_2 n_4_25_2 7876.249968014185
R5506 n_4_24_2 n_4_24_3 1591.58412221518
R5507 n_4_24_3 n_5_24_3 226.72138301427077
R5508 n_4_24_3 n_4_25_3 110267.49955219848
R5509 n_4_24_3 n_4_24_4 21.16066259355417
R5510 n_4_24_4 n_5_24_4 6.870344939826387
R5511 n_4_24_4 n_4_25_4 3341.4393803696503
R5512 n_4_24_4 n_4_24_5 17.48993540895804
R5513 n_4_24_5 n_5_24_5 43.185025336051574
R5514 n_4_24_5 n_4_25_5 21003.333248037805
R5515 n_4_24_5 n_4_24_6 6.045903598158334
R5516 n_4_24_6 n_5_24_6 7.197504222675262
R5517 n_4_24_6 n_4_25_6 3500.5555413396346
R5518 n_4_24_6 n_4_24_7 8.205154883214872
R5519 n_4_24_7 n_5_24_7 12.338578667443345
R5520 n_4_24_7 n_4_25_7 6000.952356582249
R5521 n_4_24_7 n_4_24_8 6.045903598158315
R5522 n_4_24_8 n_5_24_8 12.338578667443345
R5523 n_4_24_8 n_4_25_8 6000.952356582249
R5524 n_4_24_8 n_4_24_9 6.045903598158315
R5525 n_4_24_9 n_5_24_9 12.338578667443345
R5526 n_4_24_9 n_4_25_9 6000.952356582249
R5527 n_4_24_9 n_4_24_10 6.045903598158315
R5528 n_4_24_10 n_5_24_10 12.338578667443345
R5529 n_4_24_10 n_4_25_10 6000.952356582249
R5530 n_4_24_10 n_4_24_11 6.045903598158276
R5531 n_4_24_11 n_5_24_11 12.338578667443501
R5532 n_4_24_11 n_4_25_11 6000.952356582326
R5533 n_4_24_11 n_4_24_12 6.045903598158256
R5534 n_4_24_12 n_5_24_12 12.338578667443425
R5535 n_4_24_12 n_4_25_12 6000.952356582287
R5536 n_4_24_12 n_4_24_13 6.045903598158315
R5537 n_4_24_13 n_5_24_13 12.338578667443267
R5538 n_4_24_13 n_4_25_13 6000.95235658221
R5539 n_4_24_13 n_4_24_14 30.22951799079165
R5540 n_4_24_14 n_5_24_14 1.3709531852714798
R5541 n_4_24_14 n_4_25_14 666.772484064693
R5542 n_4_24_14 n_4_24_15 934.0921059154706
R5543 n_4_24_15 n_5_24_15 453.44276602853745
R5544 n_4_24_15 n_4_25_15 220534.99910439496
R5545 n_4_25_0 n_5_25_0 6.477753800407763
R5546 n_4_25_0 n_4_26_0 3150.4999872056737
R5547 n_4_25_0 n_4_25_1 748.1805702720957
R5548 n_4_25_1 n_5_25_1 9.068855320570867
R5549 n_4_25_1 n_4_26_1 4410.699982087943
R5550 n_4_25_1 n_4_25_2 1700.4103869820356
R5551 n_4_25_2 n_5_25_2 16.194384501019407
R5552 n_4_25_2 n_4_26_2 7876.249968014185
R5553 n_4_25_2 n_4_25_3 1591.5841222151853
R5554 n_4_25_3 n_5_25_3 226.7213830142715
R5555 n_4_25_3 n_4_26_3 110267.49955219848
R5556 n_4_25_3 n_4_25_4 21.16066259355424
R5557 n_4_25_4 n_5_25_4 6.87034493982641
R5558 n_4_25_4 n_4_26_4 3341.4393803696503
R5559 n_4_25_4 n_4_25_5 17.489935408958093
R5560 n_4_25_5 n_5_25_5 43.18502533605171
R5561 n_4_25_5 n_4_26_5 21003.333248037805
R5562 n_4_25_5 n_4_25_6 6.045903598158354
R5563 n_4_25_6 n_5_25_6 7.197504222675286
R5564 n_4_25_6 n_4_26_6 3500.5555413396346
R5565 n_4_25_6 n_4_25_7 8.205154883214899
R5566 n_4_25_7 n_5_25_7 12.338578667443386
R5567 n_4_25_7 n_4_26_7 6000.952356582249
R5568 n_4_25_7 n_4_25_8 6.0459035981583344
R5569 n_4_25_8 n_5_25_8 12.338578667443386
R5570 n_4_25_8 n_4_26_8 6000.952356582249
R5571 n_4_25_8 n_4_25_9 6.0459035981583344
R5572 n_4_25_9 n_5_25_9 12.338578667443386
R5573 n_4_25_9 n_4_26_9 6000.952356582249
R5574 n_4_25_9 n_4_25_10 6.0459035981583344
R5575 n_4_25_10 n_5_25_10 12.338578667443386
R5576 n_4_25_10 n_4_26_10 6000.952356582249
R5577 n_4_25_10 n_4_25_11 6.045903598158295
R5578 n_4_25_11 n_5_25_11 12.338578667443542
R5579 n_4_25_11 n_4_26_11 6000.952356582326
R5580 n_4_25_11 n_4_25_12 6.045903598158276
R5581 n_4_25_12 n_5_25_12 12.33857866744346
R5582 n_4_25_12 n_4_26_12 6000.952356582287
R5583 n_4_25_12 n_4_25_13 6.0459035981583344
R5584 n_4_25_13 n_5_25_13 12.338578667443308
R5585 n_4_25_13 n_4_26_13 6000.95235658221
R5586 n_4_25_13 n_4_25_14 30.22951799079175
R5587 n_4_25_14 n_5_25_14 1.370953185271484
R5588 n_4_25_14 n_4_26_14 666.772484064693
R5589 n_4_25_14 n_4_25_15 934.0921059154737
R5590 n_4_25_15 n_5_25_15 453.4427660285389
R5591 n_4_25_15 n_4_26_15 220534.99910439496
R5592 n_4_26_0 n_5_26_0 6.477753800407742
R5593 n_4_26_0 n_4_27_0 3150.4999872056787
R5594 n_4_26_0 n_4_26_1 748.1805702720933
R5595 n_4_26_1 n_5_26_1 9.068855320570838
R5596 n_4_26_1 n_4_27_1 4410.69998208795
R5597 n_4_26_1 n_4_26_2 1700.4103869820299
R5598 n_4_26_2 n_5_26_2 16.194384501019357
R5599 n_4_26_2 n_4_27_2 7876.249968014196
R5600 n_4_26_2 n_4_26_3 1591.58412221518
R5601 n_4_26_3 n_5_26_3 226.72138301427077
R5602 n_4_26_3 n_4_27_3 110267.49955219866
R5603 n_4_26_3 n_4_26_4 21.16066259355417
R5604 n_4_26_4 n_5_26_4 6.870344939826387
R5605 n_4_26_4 n_4_27_4 3341.4393803696557
R5606 n_4_26_4 n_4_26_5 17.48993540895804
R5607 n_4_26_5 n_5_26_5 43.185025336051574
R5608 n_4_26_5 n_4_27_5 21003.333248037838
R5609 n_4_26_5 n_4_26_6 6.045903598158334
R5610 n_4_26_6 n_5_26_6 7.197504222675262
R5611 n_4_26_6 n_4_27_6 3500.55554133964
R5612 n_4_26_6 n_4_26_7 8.205154883214872
R5613 n_4_26_7 n_5_26_7 12.338578667443345
R5614 n_4_26_7 n_4_27_7 6000.952356582258
R5615 n_4_26_7 n_4_26_8 6.045903598158315
R5616 n_4_26_8 n_5_26_8 12.338578667443345
R5617 n_4_26_8 n_4_27_8 6000.952356582258
R5618 n_4_26_8 n_4_26_9 6.045903598158315
R5619 n_4_26_9 n_5_26_9 12.338578667443345
R5620 n_4_26_9 n_4_27_9 6000.952356582258
R5621 n_4_26_9 n_4_26_10 6.045903598158315
R5622 n_4_26_10 n_5_26_10 12.338578667443345
R5623 n_4_26_10 n_4_27_10 6000.952356582258
R5624 n_4_26_10 n_4_26_11 6.045903598158276
R5625 n_4_26_11 n_5_26_11 12.338578667443501
R5626 n_4_26_11 n_4_27_11 6000.952356582335
R5627 n_4_26_11 n_4_26_12 6.045903598158256
R5628 n_4_26_12 n_5_26_12 12.338578667443425
R5629 n_4_26_12 n_4_27_12 6000.952356582297
R5630 n_4_26_12 n_4_26_13 6.045903598158315
R5631 n_4_26_13 n_5_26_13 12.338578667443267
R5632 n_4_26_13 n_4_27_13 6000.952356582219
R5633 n_4_26_13 n_4_26_14 30.22951799079165
R5634 n_4_26_14 n_5_26_14 1.3709531852714798
R5635 n_4_26_14 n_4_27_14 666.772484064694
R5636 n_4_26_14 n_4_26_15 934.0921059154706
R5637 n_4_26_15 n_5_26_15 453.44276602853745
R5638 n_4_26_15 n_4_27_15 220534.9991043953
R5639 n_4_27_0 n_5_27_0 6.477753800407742
R5640 n_4_27_0 n_4_27_1 748.1805702720933
R5641 n_4_27_1 n_5_27_1 9.068855320570838
R5642 n_4_27_1 n_4_27_2 1700.4103869820299
R5643 n_4_27_2 n_5_27_2 16.194384501019357
R5644 n_4_27_2 n_4_27_3 1591.58412221518
R5645 n_4_27_3 n_5_27_3 226.72138301427077
R5646 n_4_27_3 n_4_27_4 21.16066259355417
R5647 n_4_27_4 n_5_27_4 6.870344939826387
R5648 n_4_27_4 n_4_27_5 17.48993540895804
R5649 n_4_27_5 n_5_27_5 43.185025336051574
R5650 n_4_27_5 n_4_27_6 6.045903598158334
R5651 n_4_27_6 n_5_27_6 7.197504222675262
R5652 n_4_27_6 n_4_27_7 8.205154883214872
R5653 n_4_27_7 n_5_27_7 12.338578667443345
R5654 n_4_27_7 n_4_27_8 6.045903598158315
R5655 n_4_27_8 n_5_27_8 12.338578667443345
R5656 n_4_27_8 n_4_27_9 6.045903598158315
R5657 n_4_27_9 n_5_27_9 12.338578667443345
R5658 n_4_27_9 n_4_27_10 6.045903598158315
R5659 n_4_27_10 n_5_27_10 12.338578667443345
R5660 n_4_27_10 n_4_27_11 6.045903598158276
R5661 n_4_27_11 n_5_27_11 12.338578667443501
R5662 n_4_27_11 n_4_27_12 6.045903598158256
R5663 n_4_27_12 n_5_27_12 12.338578667443425
R5664 n_4_27_12 n_4_27_13 6.045903598158315
R5665 n_4_27_13 n_5_27_13 12.338578667443267
R5666 n_4_27_13 n_4_27_14 30.22951799079165
R5667 n_4_27_14 n_5_27_14 1.3709531852714798
R5668 n_4_27_14 n_4_27_15 934.0921059154706
R5669 n_4_27_15 n_5_27_15 453.44276602853745
R5670 n_5_0_0 n_6_0_0 6.477753242544629
R5671 n_5_0_0 n_5_1_0 3150.5002585262537
R5672 n_5_0_0 n_5_0_1 748.180505838903
R5673 n_5_0_1 n_6_0_1 9.068854539562478
R5674 n_5_0_1 n_5_1_1 4410.700361936755
R5675 n_5_0_1 n_5_0_2 1700.4102405429612
R5676 n_5_0_2 n_6_0_2 16.19438310636157
R5677 n_5_0_2 n_5_1_2 7876.250646315634
R5678 n_5_0_2 n_5_0_3 1591.5839851482117
R5679 n_5_0_3 n_6_0_3 226.72136348906173
R5680 n_5_0_3 n_5_1_3 110267.50904841878
R5681 n_5_0_3 n_5_0_4 21.160660771201314
R5682 n_5_0_4 n_6_0_4 6.870344348153387
R5683 n_5_0_4 n_5_1_4 3341.439668133902
R5684 n_5_0_4 n_5_0_5 17.489933902727618
R5685 n_5_0_5 n_6_0_5 43.18502161696414
R5686 n_5_0_5 n_5_1_5 21003.33505684167
R5687 n_5_0_5 n_5_0_6 6.0459030774860905
R5688 n_5_0_6 n_6_0_6 7.197503602827358
R5689 n_5_0_6 n_5_1_6 3500.5558428069457
R5690 n_5_0_6 n_5_0_7 8.205154176588255
R5691 n_5_0_7 n_6_0_7 12.338577604846938
R5692 n_5_0_7 n_5_1_7 6000.952873383354
R5693 n_5_0_7 n_5_0_8 6.045903077486072
R5694 n_5_0_8 n_6_0_8 12.338577604846938
R5695 n_5_0_8 n_5_1_8 6000.952873383354
R5696 n_5_0_8 n_5_0_9 6.045903077486072
R5697 n_5_0_9 n_6_0_9 12.338577604846938
R5698 n_5_0_9 n_5_1_9 6000.952873383354
R5699 n_5_0_9 n_5_0_10 6.045903077486072
R5700 n_5_0_10 n_6_0_10 12.338577604846938
R5701 n_5_0_10 n_5_1_10 6000.952873383354
R5702 n_5_0_10 n_5_0_11 6.045903077486033
R5703 n_5_0_11 n_6_0_11 12.338577604847094
R5704 n_5_0_11 n_5_1_11 6000.9528733834295
R5705 n_5_0_11 n_5_0_12 6.045903077486013
R5706 n_5_0_12 n_6_0_12 12.33857760484702
R5707 n_5_0_12 n_5_1_12 6000.952873383392
R5708 n_5_0_12 n_5_0_13 6.045903077486072
R5709 n_5_0_13 n_6_0_13 12.33857760484686
R5710 n_5_0_13 n_5_1_13 6000.952873383315
R5711 n_5_0_13 n_5_0_14 30.229515387430432
R5712 n_5_0_14 n_6_0_14 1.3709530672052124
R5713 n_5_0_14 n_5_1_14 666.772541487038
R5714 n_5_0_14 n_5_0_15 934.0920254716088
R5715 n_5_0_15 n_6_0_15 453.44272697811954
R5716 n_5_0_15 n_5_1_15 220535.01809683556
R5717 n_5_1_0 n_6_1_0 6.477753242544629
R5718 n_5_1_0 n_5_2_0 3150.5002585262537
R5719 n_5_1_0 n_5_1_1 748.180505838903
R5720 n_5_1_1 n_6_1_1 9.068854539562478
R5721 n_5_1_1 n_5_2_1 4410.700361936755
R5722 n_5_1_1 n_5_1_2 1700.4102405429612
R5723 n_5_1_2 n_6_1_2 16.19438310636157
R5724 n_5_1_2 n_5_2_2 7876.250646315634
R5725 n_5_1_2 n_5_1_3 1591.5839851482117
R5726 n_5_1_3 n_6_1_3 226.72136348906173
R5727 n_5_1_3 n_5_2_3 110267.50904841878
R5728 n_5_1_3 n_5_1_4 21.160660771201314
R5729 n_5_1_4 n_6_1_4 6.870344348153387
R5730 n_5_1_4 n_5_2_4 3341.439668133902
R5731 n_5_1_4 n_5_1_5 17.489933902727618
R5732 n_5_1_5 n_6_1_5 43.18502161696414
R5733 n_5_1_5 n_5_2_5 21003.33505684167
R5734 n_5_1_5 n_5_1_6 6.0459030774860905
R5735 n_5_1_6 n_6_1_6 7.197503602827358
R5736 n_5_1_6 n_5_2_6 3500.5558428069457
R5737 n_5_1_6 n_5_1_7 8.205154176588255
R5738 n_5_1_7 n_6_1_7 12.338577604846938
R5739 n_5_1_7 n_5_2_7 6000.952873383354
R5740 n_5_1_7 n_5_1_8 6.045903077486072
R5741 n_5_1_8 n_6_1_8 12.338577604846938
R5742 n_5_1_8 n_5_2_8 6000.952873383354
R5743 n_5_1_8 n_5_1_9 6.045903077486072
R5744 n_5_1_9 n_6_1_9 12.338577604846938
R5745 n_5_1_9 n_5_2_9 6000.952873383354
R5746 n_5_1_9 n_5_1_10 6.045903077486072
R5747 n_5_1_10 n_6_1_10 12.338577604846938
R5748 n_5_1_10 n_5_2_10 6000.952873383354
R5749 n_5_1_10 n_5_1_11 6.045903077486033
R5750 n_5_1_11 n_6_1_11 12.338577604847094
R5751 n_5_1_11 n_5_2_11 6000.9528733834295
R5752 n_5_1_11 n_5_1_12 6.045903077486013
R5753 n_5_1_12 n_6_1_12 12.33857760484702
R5754 n_5_1_12 n_5_2_12 6000.952873383392
R5755 n_5_1_12 n_5_1_13 6.045903077486072
R5756 n_5_1_13 n_6_1_13 12.33857760484686
R5757 n_5_1_13 n_5_2_13 6000.952873383315
R5758 n_5_1_13 n_5_1_14 30.229515387430432
R5759 n_5_1_14 n_6_1_14 1.3709530672052124
R5760 n_5_1_14 n_5_2_14 666.772541487038
R5761 n_5_1_14 n_5_1_15 934.0920254716088
R5762 n_5_1_15 n_6_1_15 453.44272697811954
R5763 n_5_1_15 n_5_2_15 220535.01809683556
R5764 n_5_2_0 n_6_2_0 6.477753242544629
R5765 n_5_2_0 n_5_3_0 3150.5002585262537
R5766 n_5_2_0 n_5_2_1 748.180505838903
R5767 n_5_2_1 n_6_2_1 9.068854539562478
R5768 n_5_2_1 n_5_3_1 4410.700361936755
R5769 n_5_2_1 n_5_2_2 1700.4102405429612
R5770 n_5_2_2 n_6_2_2 16.19438310636157
R5771 n_5_2_2 n_5_3_2 7876.250646315634
R5772 n_5_2_2 n_5_2_3 1591.5839851482117
R5773 n_5_2_3 n_6_2_3 226.72136348906173
R5774 n_5_2_3 n_5_3_3 110267.50904841878
R5775 n_5_2_3 n_5_2_4 21.160660771201314
R5776 n_5_2_4 n_6_2_4 6.870344348153387
R5777 n_5_2_4 n_5_3_4 3341.439668133902
R5778 n_5_2_4 n_5_2_5 17.489933902727618
R5779 n_5_2_5 n_6_2_5 43.18502161696414
R5780 n_5_2_5 n_5_3_5 21003.33505684167
R5781 n_5_2_5 n_5_2_6 6.0459030774860905
R5782 n_5_2_6 n_6_2_6 7.197503602827358
R5783 n_5_2_6 n_5_3_6 3500.5558428069457
R5784 n_5_2_6 n_5_2_7 8.205154176588255
R5785 n_5_2_7 n_6_2_7 12.338577604846938
R5786 n_5_2_7 n_5_3_7 6000.952873383354
R5787 n_5_2_7 n_5_2_8 6.045903077486072
R5788 n_5_2_8 n_6_2_8 12.338577604846938
R5789 n_5_2_8 n_5_3_8 6000.952873383354
R5790 n_5_2_8 n_5_2_9 6.045903077486072
R5791 n_5_2_9 n_6_2_9 12.338577604846938
R5792 n_5_2_9 n_5_3_9 6000.952873383354
R5793 n_5_2_9 n_5_2_10 6.045903077486072
R5794 n_5_2_10 n_6_2_10 12.338577604846938
R5795 n_5_2_10 n_5_3_10 6000.952873383354
R5796 n_5_2_10 n_5_2_11 6.045903077486033
R5797 n_5_2_11 n_6_2_11 12.338577604847094
R5798 n_5_2_11 n_5_3_11 6000.9528733834295
R5799 n_5_2_11 n_5_2_12 6.045903077486013
R5800 n_5_2_12 n_6_2_12 12.33857760484702
R5801 n_5_2_12 n_5_3_12 6000.952873383392
R5802 n_5_2_12 n_5_2_13 6.045903077486072
R5803 n_5_2_13 n_6_2_13 12.33857760484686
R5804 n_5_2_13 n_5_3_13 6000.952873383315
R5805 n_5_2_13 n_5_2_14 30.229515387430432
R5806 n_5_2_14 n_6_2_14 1.3709530672052124
R5807 n_5_2_14 n_5_3_14 666.772541487038
R5808 n_5_2_14 n_5_2_15 934.0920254716088
R5809 n_5_2_15 n_6_2_15 453.44272697811954
R5810 n_5_2_15 n_5_3_15 220535.01809683556
R5811 n_5_3_0 n_6_3_0 6.477753242544629
R5812 n_5_3_0 n_5_4_0 1646.6785783889497
R5813 n_5_3_0 n_5_3_1 748.180505838903
R5814 n_5_3_1 n_6_3_1 9.068854539562478
R5815 n_5_3_1 n_5_4_1 2305.35000974453
R5816 n_5_3_1 n_5_3_2 1700.4102405429612
R5817 n_5_3_2 n_6_3_2 16.19438310636157
R5818 n_5_3_2 n_5_4_2 4116.696445972375
R5819 n_5_3_2 n_5_3_3 1591.5839851482117
R5820 n_5_3_3 n_6_3_3 226.72136348906173
R5821 n_5_3_3 n_5_4_3 57633.75024361319
R5822 n_5_3_3 n_5_3_4 21.160660771201314
R5823 n_5_3_4 n_6_3_4 6.870344348153387
R5824 n_5_3_4 n_5_4_4 1746.4772801094905
R5825 n_5_3_4 n_5_3_5 17.489933902727618
R5826 n_5_3_5 n_6_3_5 43.18502161696414
R5827 n_5_3_5 n_5_3_6 6.0459030774860905
R5828 n_5_3_6 n_6_3_6 7.197503602827358
R5829 n_5_3_6 n_5_3_7 8.205154176588255
R5830 n_5_3_7 n_6_3_7 12.338577604846938
R5831 n_5_3_7 n_5_3_8 6.045903077486072
R5832 n_5_3_8 n_6_3_8 12.338577604846938
R5833 n_5_3_8 n_5_3_9 6.045903077486072
R5834 n_5_3_9 n_6_3_9 12.338577604846938
R5835 n_5_3_9 n_5_3_10 6.045903077486072
R5836 n_5_3_10 n_6_3_10 12.338577604846938
R5837 n_5_3_10 n_5_3_11 6.045903077486033
R5838 n_5_3_11 n_6_3_11 12.338577604847094
R5839 n_5_3_11 n_5_3_12 6.045903077486013
R5840 n_5_3_12 n_6_3_12 12.33857760484702
R5841 n_5_3_12 n_5_3_13 6.045903077486072
R5842 n_5_3_13 n_6_3_13 12.33857760484686
R5843 n_5_3_13 n_5_3_14 30.229515387430432
R5844 n_5_3_14 n_6_3_14 1.3709530672052124
R5845 n_5_3_14 n_5_3_15 934.0920254716088
R5846 n_5_3_15 n_6_3_15 453.44272697811954
R5847 n_5_3_15 n_5_4_15 115267.50048722533
R5848 n_5_4_0 n_6_4_0 142.8573874630586
R5849 n_5_4_0 n_5_5_0 142.85689825164724
R5850 n_5_4_0 n_5_4_1 16500.02839147187
R5851 n_5_4_1 n_6_4_1 200.000342448282
R5852 n_5_4_1 n_5_5_1 199.99965755230613
R5853 n_5_4_1 n_5_4_2 37500.06452607243
R5854 n_5_4_2 n_6_4_2 357.14346865764645
R5855 n_5_4_2 n_5_5_2 357.1422456291181
R5856 n_5_4_2 n_5_4_3 35100.060396403795
R5857 n_5_4_3 n_6_4_3 5000.008561207046
R5858 n_5_4_3 n_5_5_3 4999.9914388076495
R5859 n_5_4_3 n_5_4_4 466.6674696577907
R5860 n_5_4_4 n_6_4_4 151.51541094566807
R5861 n_5_4_4 n_5_5_4 151.51489208508025
R5862 n_5_4_15 n_6_4_15 10000.017122414003
R5863 n_5_4_15 n_5_5_15 9999.982877615208
R5864 n_5_5_0 n_6_5_0 142.85738746305609
R5865 n_5_5_0 n_5_6_0 142.85689825164852
R5866 n_5_5_0 n_5_5_1 16500.028391471576
R5867 n_5_5_1 n_6_5_1 200.00034244827845
R5868 n_5_5_1 n_5_6_1 199.99965755230792
R5869 n_5_5_1 n_5_5_2 37500.064526071765
R5870 n_5_5_2 n_6_5_2 357.14346865764014
R5871 n_5_5_2 n_5_6_2 357.1422456291213
R5872 n_5_5_2 n_5_5_3 35100.06039640317
R5873 n_5_5_3 n_6_5_3 5000.008561206957
R5874 n_5_5_3 n_5_6_3 4999.991438807694
R5875 n_5_5_3 n_5_5_4 466.6674696577824
R5876 n_5_5_4 n_6_5_4 151.51541094566537
R5877 n_5_5_4 n_5_6_4 151.5148920850816
R5878 n_5_5_15 n_6_5_15 10000.017122413825
R5879 n_5_5_15 n_5_6_15 9999.982877615297
R5880 n_5_6_0 n_6_6_0 142.85738746305609
R5881 n_5_6_0 n_5_7_0 142.85689825164724
R5882 n_5_6_0 n_5_6_1 16500.028391471576
R5883 n_5_6_1 n_6_6_1 200.00034244827845
R5884 n_5_6_1 n_5_7_1 199.99965755230613
R5885 n_5_6_1 n_5_6_2 37500.064526071765
R5886 n_5_6_2 n_6_6_2 357.14346865764014
R5887 n_5_6_2 n_5_7_2 357.1422456291181
R5888 n_5_6_2 n_5_6_3 35100.06039640317
R5889 n_5_6_3 n_6_6_3 5000.008561206957
R5890 n_5_6_3 n_5_7_3 4999.9914388076495
R5891 n_5_6_3 n_5_6_4 466.6674696577824
R5892 n_5_6_4 n_6_6_4 151.51541094566537
R5893 n_5_6_4 n_5_7_4 151.51489208508025
R5894 n_5_6_15 n_6_6_15 10000.017122413825
R5895 n_5_6_15 n_5_7_15 9999.982877615208
R5896 n_5_7_0 n_6_7_0 142.8573874630586
R5897 n_5_7_0 n_5_8_0 4174.885966470811
R5898 n_5_7_0 n_5_7_1 16500.02839147187
R5899 n_5_7_1 n_6_7_1 200.000342448282
R5900 n_5_7_1 n_5_8_1 5844.840353059133
R5901 n_5_7_1 n_5_7_2 37500.06452607243
R5902 n_5_7_2 n_6_7_2 357.14346865764645
R5903 n_5_7_2 n_5_8_2 10437.214916177025
R5904 n_5_7_2 n_5_7_3 35100.060396403795
R5905 n_5_7_3 n_6_7_3 5000.008561207046
R5906 n_5_7_3 n_5_8_3 146121.00882647824
R5907 n_5_7_3 n_5_7_4 466.6674696577907
R5908 n_5_7_4 n_6_7_4 151.51541094566807
R5909 n_5_7_4 n_5_8_4 4427.909358378128
R5910 n_5_7_15 n_6_7_15 10000.017122414003
R5911 n_5_7_15 n_5_8_15 292242.0176529538
R5912 n_5_8_0 n_6_8_0 2.486703368932474
R5913 n_5_8_0 n_5_9_0 8206.915034689977
R5914 n_5_8_0 n_5_8_1 287.214241539764
R5915 n_5_8_1 n_6_8_1 3.481384716505463
R5916 n_5_8_1 n_5_9_1 11489.681048565966
R5917 n_5_8_1 n_5_8_2 652.7596398631
R5918 n_5_8_2 n_6_8_2 6.216758422331184
R5919 n_5_8_2 n_5_9_2 20517.287586724942
R5920 n_5_8_2 n_5_8_3 610.9830229118617
R5921 n_5_8_3 n_6_8_3 87.0346179126365
R5922 n_5_8_3 n_5_9_3 287242.02621414897
R5923 n_5_8_3 n_5_8_4 8.123231073851919
R5924 n_5_8_4 n_6_8_4 2.6374126640192883
R5925 n_5_8_4 n_5_9_4 8704.30382467118
R5926 n_5_8_15 n_6_8_15 174.06923582527145
R5927 n_5_8_15 n_5_9_15 574484.0524282926
R5928 n_5_9_0 n_6_9_0 2.486703368932472
R5929 n_5_9_0 n_5_10_0 8206.915034689977
R5930 n_5_9_0 n_5_9_1 287.2142415397638
R5931 n_5_9_1 n_6_9_1 3.481384716505461
R5932 n_5_9_1 n_5_10_1 11489.681048565966
R5933 n_5_9_1 n_5_9_2 652.7596398630996
R5934 n_5_9_2 n_6_9_2 6.21675842233118
R5935 n_5_9_2 n_5_10_2 20517.287586724942
R5936 n_5_9_2 n_5_9_3 610.9830229118612
R5937 n_5_9_3 n_6_9_3 87.03461791263645
R5938 n_5_9_3 n_5_10_3 287242.02621414897
R5939 n_5_9_3 n_5_9_4 8.123231073851914
R5940 n_5_9_4 n_6_9_4 2.6374126640192865
R5941 n_5_9_4 n_5_10_4 8704.30382467118
R5942 n_5_9_15 n_6_9_15 174.06923582527136
R5943 n_5_9_15 n_5_10_15 574484.0524282926
R5944 n_5_10_0 n_6_10_0 2.486703368932474
R5945 n_5_10_0 n_5_11_0 8206.915034689975
R5946 n_5_10_0 n_5_10_1 287.214241539764
R5947 n_5_10_1 n_6_10_1 3.481384716505463
R5948 n_5_10_1 n_5_11_1 11489.681048565963
R5949 n_5_10_1 n_5_10_2 652.7596398631
R5950 n_5_10_2 n_6_10_2 6.216758422331184
R5951 n_5_10_2 n_5_11_2 20517.287586724935
R5952 n_5_10_2 n_5_10_3 610.9830229118617
R5953 n_5_10_3 n_6_10_3 87.0346179126365
R5954 n_5_10_3 n_5_11_3 287242.02621414885
R5955 n_5_10_3 n_5_10_4 8.123231073851919
R5956 n_5_10_4 n_6_10_4 2.6374126640192883
R5957 n_5_10_4 n_5_11_4 8704.303824671177
R5958 n_5_10_15 n_6_10_15 174.06923582527145
R5959 n_5_10_15 n_5_11_15 574484.0524282925
R5960 n_5_11_0 n_6_11_0 2.486703368932474
R5961 n_5_11_0 n_5_12_0 4174.886089075483
R5962 n_5_11_0 n_5_11_1 287.214241539764
R5963 n_5_11_1 n_6_11_1 3.481384716505463
R5964 n_5_11_1 n_5_12_1 5844.840524705674
R5965 n_5_11_1 n_5_11_2 652.7596398631
R5966 n_5_11_2 n_6_11_2 6.216758422331184
R5967 n_5_11_2 n_5_12_2 10437.215222688706
R5968 n_5_11_2 n_5_11_3 610.9830229118617
R5969 n_5_11_3 n_6_11_3 87.0346179126365
R5970 n_5_11_3 n_5_12_3 146121.01311764176
R5971 n_5_11_3 n_5_11_4 8.123231073851919
R5972 n_5_11_4 n_6_11_4 2.6374126640192883
R5973 n_5_11_4 n_5_12_4 4427.9094884133865
R5974 n_5_11_15 n_6_11_15 174.06923582527145
R5975 n_5_11_15 n_5_12_15 292242.02623528085
R5976 n_5_12_0 n_6_12_0 142.8571422532951
R5977 n_5_12_0 n_5_13_0 142.85714346099064
R5978 n_5_12_0 n_5_12_1 16500.00006974395
R5979 n_5_12_1 n_6_12_1 199.99999915461314
R5980 n_5_12_1 n_5_13_1 200.0000008453869
R5981 n_5_12_1 n_5_12_2 37500.00015850898
R5982 n_5_12_2 n_6_12_2 357.1428556332378
R5983 n_5_12_2 n_5_13_2 357.14285865247666
R5984 n_5_12_2 n_5_12_3 35100.0001483644
R5985 n_5_12_3 n_6_12_3 4999.999978865324
R5986 n_5_12_3 n_5_13_3 5000.000021134669
R5987 n_5_12_3 n_5_12_4 466.6666686392232
R5988 n_5_12_4 n_6_12_4 151.5151508747068
R5989 n_5_12_4 n_5_13_4 151.51515215559598
R5990 n_5_12_15 n_6_12_15 9999.99995773056
R5991 n_5_12_15 n_5_13_15 10000.000042269246
R5992 n_5_13_0 n_6_13_0 142.8571422532951
R5993 n_5_13_0 n_5_14_0 142.85714346099064
R5994 n_5_13_0 n_5_13_1 16500.00006974395
R5995 n_5_13_1 n_6_13_1 199.99999915461314
R5996 n_5_13_1 n_5_14_1 200.0000008453869
R5997 n_5_13_1 n_5_13_2 37500.00015850898
R5998 n_5_13_2 n_6_13_2 357.1428556332378
R5999 n_5_13_2 n_5_14_2 357.14285865247666
R6000 n_5_13_2 n_5_13_3 35100.0001483644
R6001 n_5_13_3 n_6_13_3 4999.999978865324
R6002 n_5_13_3 n_5_14_3 5000.000021134669
R6003 n_5_13_3 n_5_13_4 466.6666686392232
R6004 n_5_13_4 n_6_13_4 151.5151508747068
R6005 n_5_13_4 n_5_14_4 151.51515215559598
R6006 n_5_13_15 n_6_13_15 9999.99995773056
R6007 n_5_13_15 n_5_14_15 10000.000042269246
R6008 n_5_14_0 n_6_14_0 142.8571422532951
R6009 n_5_14_0 n_5_15_0 142.85714346099064
R6010 n_5_14_0 n_5_14_1 16500.00006974395
R6011 n_5_14_1 n_6_14_1 199.99999915461314
R6012 n_5_14_1 n_5_15_1 200.0000008453869
R6013 n_5_14_1 n_5_14_2 37500.00015850898
R6014 n_5_14_2 n_6_14_2 357.1428556332378
R6015 n_5_14_2 n_5_15_2 357.14285865247666
R6016 n_5_14_2 n_5_14_3 35100.0001483644
R6017 n_5_14_3 n_6_14_3 4999.999978865324
R6018 n_5_14_3 n_5_15_3 5000.000021134669
R6019 n_5_14_3 n_5_14_4 466.6666686392232
R6020 n_5_14_4 n_6_14_4 151.5151508747068
R6021 n_5_14_4 n_5_15_4 151.51515215559598
R6022 n_5_14_15 n_6_14_15 9999.99995773056
R6023 n_5_14_15 n_5_15_15 10000.000042269246
R6024 n_5_15_0 n_6_15_0 142.8571422532951
R6025 n_5_15_0 n_5_16_0 4174.88608907548
R6026 n_5_15_0 n_5_15_1 16500.00006974395
R6027 n_5_15_1 n_6_15_1 199.99999915461314
R6028 n_5_15_1 n_5_16_1 5844.840524705671
R6029 n_5_15_1 n_5_15_2 37500.00015850898
R6030 n_5_15_2 n_6_15_2 357.1428556332378
R6031 n_5_15_2 n_5_16_2 10437.215222688701
R6032 n_5_15_2 n_5_15_3 35100.0001483644
R6033 n_5_15_3 n_6_15_3 4999.999978865324
R6034 n_5_15_3 n_5_16_3 146121.01311764168
R6035 n_5_15_3 n_5_15_4 466.6666686392232
R6036 n_5_15_4 n_6_15_4 151.5151508747068
R6037 n_5_15_4 n_5_16_4 4427.909488413384
R6038 n_5_15_15 n_6_15_15 9999.99995773056
R6039 n_5_15_15 n_5_16_15 292242.0262352807
R6040 n_5_16_0 n_6_16_0 2.4867033689324756
R6041 n_5_16_0 n_5_17_0 8206.915034689973
R6042 n_5_16_0 n_5_16_1 287.21424153976415
R6043 n_5_16_1 n_6_16_1 3.481384716505465
R6044 n_5_16_1 n_5_17_1 11489.681048565963
R6045 n_5_16_1 n_5_16_2 652.7596398631005
R6046 n_5_16_2 n_6_16_2 6.216758422331188
R6047 n_5_16_2 n_5_17_2 20517.28758672494
R6048 n_5_16_2 n_5_16_3 610.983022911862
R6049 n_5_16_3 n_6_16_3 87.03461791263655
R6050 n_5_16_3 n_5_17_3 287242.02621414885
R6051 n_5_16_3 n_5_16_4 8.123231073851922
R6052 n_5_16_4 n_6_16_4 2.637412664019289
R6053 n_5_16_4 n_5_17_4 8704.303824671177
R6054 n_5_16_15 n_6_16_15 174.06923582527156
R6055 n_5_16_15 n_5_17_15 574484.0524282925
R6056 n_5_17_0 n_6_17_0 2.486703368932472
R6057 n_5_17_0 n_5_18_0 8206.915034689979
R6058 n_5_17_0 n_5_17_1 287.2142415397638
R6059 n_5_17_1 n_6_17_1 3.481384716505461
R6060 n_5_17_1 n_5_18_1 11489.68104856597
R6061 n_5_17_1 n_5_17_2 652.7596398630996
R6062 n_5_17_2 n_6_17_2 6.21675842233118
R6063 n_5_17_2 n_5_18_2 20517.28758672495
R6064 n_5_17_2 n_5_17_3 610.9830229118612
R6065 n_5_17_3 n_6_17_3 87.03461791263645
R6066 n_5_17_3 n_5_18_3 287242.026214149
R6067 n_5_17_3 n_5_17_4 8.123231073851914
R6068 n_5_17_4 n_6_17_4 2.6374126640192865
R6069 n_5_17_4 n_5_18_4 8704.303824671182
R6070 n_5_17_15 n_6_17_15 174.06923582527136
R6071 n_5_17_15 n_5_18_15 574484.0524282928
R6072 n_5_18_0 n_6_18_0 2.486703368932472
R6073 n_5_18_0 n_5_19_0 8206.915034689973
R6074 n_5_18_0 n_5_18_1 287.2142415397638
R6075 n_5_18_1 n_6_18_1 3.481384716505461
R6076 n_5_18_1 n_5_19_1 11489.681048565963
R6077 n_5_18_1 n_5_18_2 652.7596398630996
R6078 n_5_18_2 n_6_18_2 6.21675842233118
R6079 n_5_18_2 n_5_19_2 20517.28758672494
R6080 n_5_18_2 n_5_18_3 610.9830229118612
R6081 n_5_18_3 n_6_18_3 87.03461791263645
R6082 n_5_18_3 n_5_19_3 287242.02621414885
R6083 n_5_18_3 n_5_18_4 8.123231073851914
R6084 n_5_18_4 n_6_18_4 2.6374126640192865
R6085 n_5_18_4 n_5_19_4 8704.303824671177
R6086 n_5_18_15 n_6_18_15 174.06923582527136
R6087 n_5_18_15 n_5_19_15 574484.0524282925
R6088 n_5_19_0 n_6_19_0 2.4867033689324756
R6089 n_5_19_0 n_5_20_0 4174.886102131099
R6090 n_5_19_0 n_5_19_1 287.21424153976415
R6091 n_5_19_1 n_6_19_1 3.481384716505465
R6092 n_5_19_1 n_5_20_1 5844.8405429835375
R6093 n_5_19_1 n_5_19_2 652.7596398631005
R6094 n_5_19_2 n_6_19_2 6.216758422331188
R6095 n_5_19_2 n_5_20_2 10437.215255327748
R6096 n_5_19_2 n_5_19_3 610.983022911862
R6097 n_5_19_3 n_6_19_3 87.03461791263655
R6098 n_5_19_3 n_5_20_3 146121.01357458835
R6099 n_5_19_3 n_5_19_4 8.123231073851922
R6100 n_5_19_4 n_6_19_4 2.637412664019289
R6101 n_5_19_4 n_5_20_4 4427.909502260252
R6102 n_5_19_15 n_6_19_15 174.06923582527156
R6103 n_5_19_15 n_5_20_15 292242.027149174
R6104 n_5_20_0 n_6_20_0 142.85711614206238
R6105 n_5_20_0 n_5_21_0 142.85716957222837
R6106 n_5_20_0 n_5_20_1 16499.997053896546
R6107 n_5_20_1 n_6_20_1 199.9999625988873
R6108 n_5_20_1 n_5_21_1 200.0000374011197
R6109 n_5_20_1 n_5_20_2 37499.99330431033
R6110 n_5_20_2 n_6_20_2 357.14279035515597
R6111 n_5_20_2 n_5_21_2 357.14292393057093
R6112 n_5_20_2 n_5_20_3 35099.99373283447
R6113 n_5_20_3 n_6_20_3 4999.999064972178
R6114 n_5_20_3 n_5_21_3 5000.000935027988
R6115 n_5_20_3 n_5_20_4 466.666583342529
R6116 n_5_20_4 n_6_20_4 151.5151231809751
R6117 n_5_20_4 n_5_21_4 151.51517984933295
R6118 n_5_20_15 n_6_20_15 9999.998129944266
R6119 n_5_20_15 n_5_21_15 10000.001870055885
R6120 n_5_21_0 n_6_21_0 142.85711614206238
R6121 n_5_21_0 n_5_22_0 142.8571695722233
R6122 n_5_21_0 n_5_21_1 16499.997053896546
R6123 n_5_21_1 n_6_21_1 199.9999625988873
R6124 n_5_21_1 n_5_22_1 200.0000374011126
R6125 n_5_21_1 n_5_21_2 37499.99330431033
R6126 n_5_21_2 n_6_21_2 357.14279035515597
R6127 n_5_21_2 n_5_22_2 357.14292393055825
R6128 n_5_21_2 n_5_21_3 35099.99373283447
R6129 n_5_21_3 n_6_21_3 4999.999064972178
R6130 n_5_21_3 n_5_22_3 5000.000935027811
R6131 n_5_21_3 n_5_21_4 466.666583342529
R6132 n_5_21_4 n_6_21_4 151.5151231809751
R6133 n_5_21_4 n_5_22_4 151.51517984932758
R6134 n_5_21_15 n_6_21_15 9999.998129944266
R6135 n_5_21_15 n_5_22_15 10000.00187005553
R6136 n_5_22_0 n_6_22_0 142.85711614207253
R6137 n_5_22_0 n_5_23_0 142.8571695722233
R6138 n_5_22_0 n_5_22_1 16499.997053897714
R6139 n_5_22_1 n_6_22_1 199.99996259890153
R6140 n_5_22_1 n_5_23_1 200.0000374011126
R6141 n_5_22_1 n_5_22_2 37499.993304312986
R6142 n_5_22_2 n_6_22_2 357.1427903551813
R6143 n_5_22_2 n_5_23_2 357.14292393055825
R6144 n_5_22_2 n_5_22_3 35099.993732836956
R6145 n_5_22_3 n_6_22_3 4999.999064972534
R6146 n_5_22_3 n_5_23_3 5000.000935027811
R6147 n_5_22_3 n_5_22_4 466.66658334256203
R6148 n_5_22_4 n_6_22_4 151.51512318098585
R6149 n_5_22_4 n_5_23_4 151.51517984932758
R6150 n_5_22_15 n_6_22_15 9999.998129944977
R6151 n_5_22_15 n_5_23_15 10000.00187005553
R6152 n_5_23_0 n_6_23_0 142.85711614206238
R6153 n_5_23_0 n_5_24_0 1646.6785783889536
R6154 n_5_23_0 n_5_23_1 16499.997053896546
R6155 n_5_23_1 n_6_23_1 199.9999625988873
R6156 n_5_23_1 n_5_24_1 2305.350009744535
R6157 n_5_23_1 n_5_23_2 37499.99330431033
R6158 n_5_23_2 n_6_23_2 357.14279035515597
R6159 n_5_23_2 n_5_24_2 4116.696445972384
R6160 n_5_23_2 n_5_23_3 35099.99373283447
R6161 n_5_23_3 n_6_23_3 4999.999064972178
R6162 n_5_23_3 n_5_24_3 57633.75024361332
R6163 n_5_23_3 n_5_23_4 466.666583342529
R6164 n_5_23_4 n_6_23_4 151.5151231809751
R6165 n_5_23_4 n_5_24_4 1746.4772801094944
R6166 n_5_23_15 n_6_23_15 9999.998129944266
R6167 n_5_23_15 n_5_24_15 115267.5004872256
R6168 n_5_24_0 n_6_24_0 6.477753800407742
R6169 n_5_24_0 n_5_25_0 3150.4999872056737
R6170 n_5_24_0 n_5_24_1 748.1805702720933
R6171 n_5_24_1 n_6_24_1 9.068855320570838
R6172 n_5_24_1 n_5_25_1 4410.699982087943
R6173 n_5_24_1 n_5_24_2 1700.4103869820299
R6174 n_5_24_2 n_6_24_2 16.194384501019357
R6175 n_5_24_2 n_5_25_2 7876.249968014185
R6176 n_5_24_2 n_5_24_3 1591.58412221518
R6177 n_5_24_3 n_6_24_3 226.72138301427077
R6178 n_5_24_3 n_5_25_3 110267.49955219848
R6179 n_5_24_3 n_5_24_4 21.16066259355417
R6180 n_5_24_4 n_6_24_4 6.870344939826387
R6181 n_5_24_4 n_5_25_4 3341.4393803696503
R6182 n_5_24_4 n_5_24_5 17.48993540895804
R6183 n_5_24_5 n_6_24_5 43.185025336051574
R6184 n_5_24_5 n_5_25_5 21003.333248037805
R6185 n_5_24_5 n_5_24_6 6.045903598158334
R6186 n_5_24_6 n_6_24_6 7.197504222675262
R6187 n_5_24_6 n_5_25_6 3500.5555413396346
R6188 n_5_24_6 n_5_24_7 8.205154883214872
R6189 n_5_24_7 n_6_24_7 12.338578667443345
R6190 n_5_24_7 n_5_25_7 6000.952356582249
R6191 n_5_24_7 n_5_24_8 6.045903598158315
R6192 n_5_24_8 n_6_24_8 12.338578667443345
R6193 n_5_24_8 n_5_25_8 6000.952356582249
R6194 n_5_24_8 n_5_24_9 6.045903598158315
R6195 n_5_24_9 n_6_24_9 12.338578667443345
R6196 n_5_24_9 n_5_25_9 6000.952356582249
R6197 n_5_24_9 n_5_24_10 6.045903598158315
R6198 n_5_24_10 n_6_24_10 12.338578667443345
R6199 n_5_24_10 n_5_25_10 6000.952356582249
R6200 n_5_24_10 n_5_24_11 6.045903598158276
R6201 n_5_24_11 n_6_24_11 12.338578667443501
R6202 n_5_24_11 n_5_25_11 6000.952356582326
R6203 n_5_24_11 n_5_24_12 6.045903598158256
R6204 n_5_24_12 n_6_24_12 12.338578667443425
R6205 n_5_24_12 n_5_25_12 6000.952356582287
R6206 n_5_24_12 n_5_24_13 6.045903598158315
R6207 n_5_24_13 n_6_24_13 12.338578667443267
R6208 n_5_24_13 n_5_25_13 6000.95235658221
R6209 n_5_24_13 n_5_24_14 30.22951799079165
R6210 n_5_24_14 n_6_24_14 1.3709531852714798
R6211 n_5_24_14 n_5_25_14 666.772484064693
R6212 n_5_24_14 n_5_24_15 934.0921059154706
R6213 n_5_24_15 n_6_24_15 453.44276602853745
R6214 n_5_24_15 n_5_25_15 220534.99910439496
R6215 n_5_25_0 n_6_25_0 6.477753800407763
R6216 n_5_25_0 n_5_26_0 3150.4999872056737
R6217 n_5_25_0 n_5_25_1 748.1805702720957
R6218 n_5_25_1 n_6_25_1 9.068855320570867
R6219 n_5_25_1 n_5_26_1 4410.699982087943
R6220 n_5_25_1 n_5_25_2 1700.4103869820356
R6221 n_5_25_2 n_6_25_2 16.194384501019407
R6222 n_5_25_2 n_5_26_2 7876.249968014185
R6223 n_5_25_2 n_5_25_3 1591.5841222151853
R6224 n_5_25_3 n_6_25_3 226.7213830142715
R6225 n_5_25_3 n_5_26_3 110267.49955219848
R6226 n_5_25_3 n_5_25_4 21.16066259355424
R6227 n_5_25_4 n_6_25_4 6.87034493982641
R6228 n_5_25_4 n_5_26_4 3341.4393803696503
R6229 n_5_25_4 n_5_25_5 17.489935408958093
R6230 n_5_25_5 n_6_25_5 43.18502533605171
R6231 n_5_25_5 n_5_26_5 21003.333248037805
R6232 n_5_25_5 n_5_25_6 6.045903598158354
R6233 n_5_25_6 n_6_25_6 7.197504222675286
R6234 n_5_25_6 n_5_26_6 3500.5555413396346
R6235 n_5_25_6 n_5_25_7 8.205154883214899
R6236 n_5_25_7 n_6_25_7 12.338578667443386
R6237 n_5_25_7 n_5_26_7 6000.952356582249
R6238 n_5_25_7 n_5_25_8 6.0459035981583344
R6239 n_5_25_8 n_6_25_8 12.338578667443386
R6240 n_5_25_8 n_5_26_8 6000.952356582249
R6241 n_5_25_8 n_5_25_9 6.0459035981583344
R6242 n_5_25_9 n_6_25_9 12.338578667443386
R6243 n_5_25_9 n_5_26_9 6000.952356582249
R6244 n_5_25_9 n_5_25_10 6.0459035981583344
R6245 n_5_25_10 n_6_25_10 12.338578667443386
R6246 n_5_25_10 n_5_26_10 6000.952356582249
R6247 n_5_25_10 n_5_25_11 6.045903598158295
R6248 n_5_25_11 n_6_25_11 12.338578667443542
R6249 n_5_25_11 n_5_26_11 6000.952356582326
R6250 n_5_25_11 n_5_25_12 6.045903598158276
R6251 n_5_25_12 n_6_25_12 12.33857866744346
R6252 n_5_25_12 n_5_26_12 6000.952356582287
R6253 n_5_25_12 n_5_25_13 6.0459035981583344
R6254 n_5_25_13 n_6_25_13 12.338578667443308
R6255 n_5_25_13 n_5_26_13 6000.95235658221
R6256 n_5_25_13 n_5_25_14 30.22951799079175
R6257 n_5_25_14 n_6_25_14 1.370953185271484
R6258 n_5_25_14 n_5_26_14 666.772484064693
R6259 n_5_25_14 n_5_25_15 934.0921059154737
R6260 n_5_25_15 n_6_25_15 453.4427660285389
R6261 n_5_25_15 n_5_26_15 220534.99910439496
R6262 n_5_26_0 n_6_26_0 6.477753800407742
R6263 n_5_26_0 n_5_27_0 3150.4999872056787
R6264 n_5_26_0 n_5_26_1 748.1805702720933
R6265 n_5_26_1 n_6_26_1 9.068855320570838
R6266 n_5_26_1 n_5_27_1 4410.69998208795
R6267 n_5_26_1 n_5_26_2 1700.4103869820299
R6268 n_5_26_2 n_6_26_2 16.194384501019357
R6269 n_5_26_2 n_5_27_2 7876.249968014196
R6270 n_5_26_2 n_5_26_3 1591.58412221518
R6271 n_5_26_3 n_6_26_3 226.72138301427077
R6272 n_5_26_3 n_5_27_3 110267.49955219866
R6273 n_5_26_3 n_5_26_4 21.16066259355417
R6274 n_5_26_4 n_6_26_4 6.870344939826387
R6275 n_5_26_4 n_5_27_4 3341.4393803696557
R6276 n_5_26_4 n_5_26_5 17.48993540895804
R6277 n_5_26_5 n_6_26_5 43.185025336051574
R6278 n_5_26_5 n_5_27_5 21003.333248037838
R6279 n_5_26_5 n_5_26_6 6.045903598158334
R6280 n_5_26_6 n_6_26_6 7.197504222675262
R6281 n_5_26_6 n_5_27_6 3500.55554133964
R6282 n_5_26_6 n_5_26_7 8.205154883214872
R6283 n_5_26_7 n_6_26_7 12.338578667443345
R6284 n_5_26_7 n_5_27_7 6000.952356582258
R6285 n_5_26_7 n_5_26_8 6.045903598158315
R6286 n_5_26_8 n_6_26_8 12.338578667443345
R6287 n_5_26_8 n_5_27_8 6000.952356582258
R6288 n_5_26_8 n_5_26_9 6.045903598158315
R6289 n_5_26_9 n_6_26_9 12.338578667443345
R6290 n_5_26_9 n_5_27_9 6000.952356582258
R6291 n_5_26_9 n_5_26_10 6.045903598158315
R6292 n_5_26_10 n_6_26_10 12.338578667443345
R6293 n_5_26_10 n_5_27_10 6000.952356582258
R6294 n_5_26_10 n_5_26_11 6.045903598158276
R6295 n_5_26_11 n_6_26_11 12.338578667443501
R6296 n_5_26_11 n_5_27_11 6000.952356582335
R6297 n_5_26_11 n_5_26_12 6.045903598158256
R6298 n_5_26_12 n_6_26_12 12.338578667443425
R6299 n_5_26_12 n_5_27_12 6000.952356582297
R6300 n_5_26_12 n_5_26_13 6.045903598158315
R6301 n_5_26_13 n_6_26_13 12.338578667443267
R6302 n_5_26_13 n_5_27_13 6000.952356582219
R6303 n_5_26_13 n_5_26_14 30.22951799079165
R6304 n_5_26_14 n_6_26_14 1.3709531852714798
R6305 n_5_26_14 n_5_27_14 666.772484064694
R6306 n_5_26_14 n_5_26_15 934.0921059154706
R6307 n_5_26_15 n_6_26_15 453.44276602853745
R6308 n_5_26_15 n_5_27_15 220534.9991043953
R6309 n_5_27_0 n_6_27_0 6.477753800407742
R6310 n_5_27_0 n_5_27_1 748.1805702720933
R6311 n_5_27_1 n_6_27_1 9.068855320570838
R6312 n_5_27_1 n_5_27_2 1700.4103869820299
R6313 n_5_27_2 n_6_27_2 16.194384501019357
R6314 n_5_27_2 n_5_27_3 1591.58412221518
R6315 n_5_27_3 n_6_27_3 226.72138301427077
R6316 n_5_27_3 n_5_27_4 21.16066259355417
R6317 n_5_27_4 n_6_27_4 6.870344939826387
R6318 n_5_27_4 n_5_27_5 17.48993540895804
R6319 n_5_27_5 n_6_27_5 43.185025336051574
R6320 n_5_27_5 n_5_27_6 6.045903598158334
R6321 n_5_27_6 n_6_27_6 7.197504222675262
R6322 n_5_27_6 n_5_27_7 8.205154883214872
R6323 n_5_27_7 n_6_27_7 12.338578667443345
R6324 n_5_27_7 n_5_27_8 6.045903598158315
R6325 n_5_27_8 n_6_27_8 12.338578667443345
R6326 n_5_27_8 n_5_27_9 6.045903598158315
R6327 n_5_27_9 n_6_27_9 12.338578667443345
R6328 n_5_27_9 n_5_27_10 6.045903598158315
R6329 n_5_27_10 n_6_27_10 12.338578667443345
R6330 n_5_27_10 n_5_27_11 6.045903598158276
R6331 n_5_27_11 n_6_27_11 12.338578667443501
R6332 n_5_27_11 n_5_27_12 6.045903598158256
R6333 n_5_27_12 n_6_27_12 12.338578667443425
R6334 n_5_27_12 n_5_27_13 6.045903598158315
R6335 n_5_27_13 n_6_27_13 12.338578667443267
R6336 n_5_27_13 n_5_27_14 30.22951799079165
R6337 n_5_27_14 n_6_27_14 1.3709531852714798
R6338 n_5_27_14 n_5_27_15 934.0921059154706
R6339 n_5_27_15 n_6_27_15 453.44276602853745
R6340 n_6_0_0 n_7_0_0 6.477753242544629
R6341 n_6_0_0 n_6_1_0 3150.5002585262537
R6342 n_6_0_0 n_6_0_1 748.180505838903
R6343 n_6_0_1 n_7_0_1 9.068854539562478
R6344 n_6_0_1 n_6_1_1 4410.700361936755
R6345 n_6_0_1 n_6_0_2 1700.4102405429612
R6346 n_6_0_2 n_7_0_2 16.19438310636157
R6347 n_6_0_2 n_6_1_2 7876.250646315634
R6348 n_6_0_2 n_6_0_3 1591.5839851482117
R6349 n_6_0_3 n_7_0_3 226.72136348906173
R6350 n_6_0_3 n_6_1_3 110267.50904841878
R6351 n_6_0_3 n_6_0_4 21.160660771201314
R6352 n_6_0_4 n_7_0_4 6.870344348153387
R6353 n_6_0_4 n_6_1_4 3341.439668133902
R6354 n_6_0_4 n_6_0_5 17.489933902727618
R6355 n_6_0_5 n_7_0_5 43.18502161696414
R6356 n_6_0_5 n_6_1_5 21003.33505684167
R6357 n_6_0_5 n_6_0_6 6.0459030774860905
R6358 n_6_0_6 n_7_0_6 7.197503602827358
R6359 n_6_0_6 n_6_1_6 3500.5558428069457
R6360 n_6_0_6 n_6_0_7 8.205154176588255
R6361 n_6_0_7 n_7_0_7 12.338577604846938
R6362 n_6_0_7 n_6_1_7 6000.952873383354
R6363 n_6_0_7 n_6_0_8 6.045903077486072
R6364 n_6_0_8 n_7_0_8 12.338577604846938
R6365 n_6_0_8 n_6_1_8 6000.952873383354
R6366 n_6_0_8 n_6_0_9 6.045903077486072
R6367 n_6_0_9 n_7_0_9 12.338577604846938
R6368 n_6_0_9 n_6_1_9 6000.952873383354
R6369 n_6_0_9 n_6_0_10 6.045903077486072
R6370 n_6_0_10 n_7_0_10 12.338577604846938
R6371 n_6_0_10 n_6_1_10 6000.952873383354
R6372 n_6_0_10 n_6_0_11 6.045903077486033
R6373 n_6_0_11 n_7_0_11 12.338577604847094
R6374 n_6_0_11 n_6_1_11 6000.9528733834295
R6375 n_6_0_11 n_6_0_12 6.045903077486013
R6376 n_6_0_12 n_7_0_12 12.33857760484702
R6377 n_6_0_12 n_6_1_12 6000.952873383392
R6378 n_6_0_12 n_6_0_13 6.045903077486072
R6379 n_6_0_13 n_7_0_13 12.33857760484686
R6380 n_6_0_13 n_6_1_13 6000.952873383315
R6381 n_6_0_13 n_6_0_14 30.229515387430432
R6382 n_6_0_14 n_7_0_14 1.3709530672052124
R6383 n_6_0_14 n_6_1_14 666.772541487038
R6384 n_6_0_14 n_6_0_15 934.0920254716088
R6385 n_6_0_15 n_7_0_15 453.44272697811954
R6386 n_6_0_15 n_6_1_15 220535.01809683556
R6387 n_6_1_0 n_7_1_0 6.477753242544629
R6388 n_6_1_0 n_6_2_0 3150.5002585262537
R6389 n_6_1_0 n_6_1_1 748.180505838903
R6390 n_6_1_1 n_7_1_1 9.068854539562478
R6391 n_6_1_1 n_6_2_1 4410.700361936755
R6392 n_6_1_1 n_6_1_2 1700.4102405429612
R6393 n_6_1_2 n_7_1_2 16.19438310636157
R6394 n_6_1_2 n_6_2_2 7876.250646315634
R6395 n_6_1_2 n_6_1_3 1591.5839851482117
R6396 n_6_1_3 n_7_1_3 226.72136348906173
R6397 n_6_1_3 n_6_2_3 110267.50904841878
R6398 n_6_1_3 n_6_1_4 21.160660771201314
R6399 n_6_1_4 n_7_1_4 6.870344348153387
R6400 n_6_1_4 n_6_2_4 3341.439668133902
R6401 n_6_1_4 n_6_1_5 17.489933902727618
R6402 n_6_1_5 n_7_1_5 43.18502161696414
R6403 n_6_1_5 n_6_2_5 21003.33505684167
R6404 n_6_1_5 n_6_1_6 6.0459030774860905
R6405 n_6_1_6 n_7_1_6 7.197503602827358
R6406 n_6_1_6 n_6_2_6 3500.5558428069457
R6407 n_6_1_6 n_6_1_7 8.205154176588255
R6408 n_6_1_7 n_7_1_7 12.338577604846938
R6409 n_6_1_7 n_6_2_7 6000.952873383354
R6410 n_6_1_7 n_6_1_8 6.045903077486072
R6411 n_6_1_8 n_7_1_8 12.338577604846938
R6412 n_6_1_8 n_6_2_8 6000.952873383354
R6413 n_6_1_8 n_6_1_9 6.045903077486072
R6414 n_6_1_9 n_7_1_9 12.338577604846938
R6415 n_6_1_9 n_6_2_9 6000.952873383354
R6416 n_6_1_9 n_6_1_10 6.045903077486072
R6417 n_6_1_10 n_7_1_10 12.338577604846938
R6418 n_6_1_10 n_6_2_10 6000.952873383354
R6419 n_6_1_10 n_6_1_11 6.045903077486033
R6420 n_6_1_11 n_7_1_11 12.338577604847094
R6421 n_6_1_11 n_6_2_11 6000.9528733834295
R6422 n_6_1_11 n_6_1_12 6.045903077486013
R6423 n_6_1_12 n_7_1_12 12.33857760484702
R6424 n_6_1_12 n_6_2_12 6000.952873383392
R6425 n_6_1_12 n_6_1_13 6.045903077486072
R6426 n_6_1_13 n_7_1_13 12.33857760484686
R6427 n_6_1_13 n_6_2_13 6000.952873383315
R6428 n_6_1_13 n_6_1_14 30.229515387430432
R6429 n_6_1_14 n_7_1_14 1.3709530672052124
R6430 n_6_1_14 n_6_2_14 666.772541487038
R6431 n_6_1_14 n_6_1_15 934.0920254716088
R6432 n_6_1_15 n_7_1_15 453.44272697811954
R6433 n_6_1_15 n_6_2_15 220535.01809683556
R6434 n_6_2_0 n_7_2_0 6.477753242544629
R6435 n_6_2_0 n_6_3_0 3150.5002585262537
R6436 n_6_2_0 n_6_2_1 748.180505838903
R6437 n_6_2_1 n_7_2_1 9.068854539562478
R6438 n_6_2_1 n_6_3_1 4410.700361936755
R6439 n_6_2_1 n_6_2_2 1700.4102405429612
R6440 n_6_2_2 n_7_2_2 16.19438310636157
R6441 n_6_2_2 n_6_3_2 7876.250646315634
R6442 n_6_2_2 n_6_2_3 1591.5839851482117
R6443 n_6_2_3 n_7_2_3 226.72136348906173
R6444 n_6_2_3 n_6_3_3 110267.50904841878
R6445 n_6_2_3 n_6_2_4 21.160660771201314
R6446 n_6_2_4 n_7_2_4 6.870344348153387
R6447 n_6_2_4 n_6_3_4 3341.439668133902
R6448 n_6_2_4 n_6_2_5 17.489933902727618
R6449 n_6_2_5 n_7_2_5 43.18502161696414
R6450 n_6_2_5 n_6_3_5 21003.33505684167
R6451 n_6_2_5 n_6_2_6 6.0459030774860905
R6452 n_6_2_6 n_7_2_6 7.197503602827358
R6453 n_6_2_6 n_6_3_6 3500.5558428069457
R6454 n_6_2_6 n_6_2_7 8.205154176588255
R6455 n_6_2_7 n_7_2_7 12.338577604846938
R6456 n_6_2_7 n_6_3_7 6000.952873383354
R6457 n_6_2_7 n_6_2_8 6.045903077486072
R6458 n_6_2_8 n_7_2_8 12.338577604846938
R6459 n_6_2_8 n_6_3_8 6000.952873383354
R6460 n_6_2_8 n_6_2_9 6.045903077486072
R6461 n_6_2_9 n_7_2_9 12.338577604846938
R6462 n_6_2_9 n_6_3_9 6000.952873383354
R6463 n_6_2_9 n_6_2_10 6.045903077486072
R6464 n_6_2_10 n_7_2_10 12.338577604846938
R6465 n_6_2_10 n_6_3_10 6000.952873383354
R6466 n_6_2_10 n_6_2_11 6.045903077486033
R6467 n_6_2_11 n_7_2_11 12.338577604847094
R6468 n_6_2_11 n_6_3_11 6000.9528733834295
R6469 n_6_2_11 n_6_2_12 6.045903077486013
R6470 n_6_2_12 n_7_2_12 12.33857760484702
R6471 n_6_2_12 n_6_3_12 6000.952873383392
R6472 n_6_2_12 n_6_2_13 6.045903077486072
R6473 n_6_2_13 n_7_2_13 12.33857760484686
R6474 n_6_2_13 n_6_3_13 6000.952873383315
R6475 n_6_2_13 n_6_2_14 30.229515387430432
R6476 n_6_2_14 n_7_2_14 1.3709530672052124
R6477 n_6_2_14 n_6_3_14 666.772541487038
R6478 n_6_2_14 n_6_2_15 934.0920254716088
R6479 n_6_2_15 n_7_2_15 453.44272697811954
R6480 n_6_2_15 n_6_3_15 220535.01809683556
R6481 n_6_3_0 n_7_3_0 6.477753242544629
R6482 n_6_3_0 n_6_4_0 1646.6785783889497
R6483 n_6_3_0 n_6_3_1 748.180505838903
R6484 n_6_3_1 n_7_3_1 9.068854539562478
R6485 n_6_3_1 n_6_4_1 2305.35000974453
R6486 n_6_3_1 n_6_3_2 1700.4102405429612
R6487 n_6_3_2 n_7_3_2 16.19438310636157
R6488 n_6_3_2 n_6_4_2 4116.696445972375
R6489 n_6_3_2 n_6_3_3 1591.5839851482117
R6490 n_6_3_3 n_7_3_3 226.72136348906173
R6491 n_6_3_3 n_6_4_3 57633.75024361319
R6492 n_6_3_3 n_6_3_4 21.160660771201314
R6493 n_6_3_4 n_7_3_4 6.870344348153387
R6494 n_6_3_4 n_6_4_4 1746.4772801094905
R6495 n_6_3_4 n_6_3_5 17.489933902727618
R6496 n_6_3_5 n_7_3_5 43.18502161696414
R6497 n_6_3_5 n_6_3_6 6.0459030774860905
R6498 n_6_3_6 n_7_3_6 7.197503602827358
R6499 n_6_3_6 n_6_3_7 8.205154176588255
R6500 n_6_3_7 n_7_3_7 12.338577604846938
R6501 n_6_3_7 n_6_3_8 6.045903077486072
R6502 n_6_3_8 n_7_3_8 12.338577604846938
R6503 n_6_3_8 n_6_3_9 6.045903077486072
R6504 n_6_3_9 n_7_3_9 12.338577604846938
R6505 n_6_3_9 n_6_3_10 6.045903077486072
R6506 n_6_3_10 n_7_3_10 12.338577604846938
R6507 n_6_3_10 n_6_3_11 6.045903077486033
R6508 n_6_3_11 n_7_3_11 12.338577604847094
R6509 n_6_3_11 n_6_3_12 6.045903077486013
R6510 n_6_3_12 n_7_3_12 12.33857760484702
R6511 n_6_3_12 n_6_3_13 6.045903077486072
R6512 n_6_3_13 n_7_3_13 12.33857760484686
R6513 n_6_3_13 n_6_3_14 30.229515387430432
R6514 n_6_3_14 n_7_3_14 1.3709530672052124
R6515 n_6_3_14 n_6_3_15 934.0920254716088
R6516 n_6_3_15 n_7_3_15 453.44272697811954
R6517 n_6_3_15 n_6_4_15 115267.50048722533
R6518 n_6_4_0 n_7_4_0 142.8573874630586
R6519 n_6_4_0 n_6_5_0 142.85689825164724
R6520 n_6_4_0 n_6_4_1 16500.02839147187
R6521 n_6_4_1 n_7_4_1 200.000342448282
R6522 n_6_4_1 n_6_5_1 199.99965755230613
R6523 n_6_4_1 n_6_4_2 37500.06452607243
R6524 n_6_4_2 n_7_4_2 357.14346865764645
R6525 n_6_4_2 n_6_5_2 357.1422456291181
R6526 n_6_4_2 n_6_4_3 35100.060396403795
R6527 n_6_4_3 n_7_4_3 5000.008561207046
R6528 n_6_4_3 n_6_5_3 4999.9914388076495
R6529 n_6_4_3 n_6_4_4 466.6674696577907
R6530 n_6_4_4 n_7_4_4 151.51541094566807
R6531 n_6_4_4 n_6_5_4 151.51489208508025
R6532 n_6_4_15 n_7_4_15 10000.017122414003
R6533 n_6_4_15 n_6_5_15 9999.982877615208
R6534 n_6_5_0 n_7_5_0 142.85738746305609
R6535 n_6_5_0 n_6_6_0 142.85689825164852
R6536 n_6_5_0 n_6_5_1 16500.028391471576
R6537 n_6_5_1 n_7_5_1 200.00034244827845
R6538 n_6_5_1 n_6_6_1 199.99965755230792
R6539 n_6_5_1 n_6_5_2 37500.064526071765
R6540 n_6_5_2 n_7_5_2 357.14346865764014
R6541 n_6_5_2 n_6_6_2 357.1422456291213
R6542 n_6_5_2 n_6_5_3 35100.06039640317
R6543 n_6_5_3 n_7_5_3 5000.008561206957
R6544 n_6_5_3 n_6_6_3 4999.991438807694
R6545 n_6_5_3 n_6_5_4 466.6674696577824
R6546 n_6_5_4 n_7_5_4 151.51541094566537
R6547 n_6_5_4 n_6_6_4 151.5148920850816
R6548 n_6_5_15 n_7_5_15 10000.017122413825
R6549 n_6_5_15 n_6_6_15 9999.982877615297
R6550 n_6_6_0 n_7_6_0 142.85738746305609
R6551 n_6_6_0 n_6_7_0 142.85689825164724
R6552 n_6_6_0 n_6_6_1 16500.028391471576
R6553 n_6_6_1 n_7_6_1 200.00034244827845
R6554 n_6_6_1 n_6_7_1 199.99965755230613
R6555 n_6_6_1 n_6_6_2 37500.064526071765
R6556 n_6_6_2 n_7_6_2 357.14346865764014
R6557 n_6_6_2 n_6_7_2 357.1422456291181
R6558 n_6_6_2 n_6_6_3 35100.06039640317
R6559 n_6_6_3 n_7_6_3 5000.008561206957
R6560 n_6_6_3 n_6_7_3 4999.9914388076495
R6561 n_6_6_3 n_6_6_4 466.6674696577824
R6562 n_6_6_4 n_7_6_4 151.51541094566537
R6563 n_6_6_4 n_6_7_4 151.51489208508025
R6564 n_6_6_15 n_7_6_15 10000.017122413825
R6565 n_6_6_15 n_6_7_15 9999.982877615208
R6566 n_6_7_0 n_7_7_0 142.8573874630586
R6567 n_6_7_0 n_6_8_0 4174.885966470811
R6568 n_6_7_0 n_6_7_1 16500.02839147187
R6569 n_6_7_1 n_7_7_1 200.000342448282
R6570 n_6_7_1 n_6_8_1 5844.840353059133
R6571 n_6_7_1 n_6_7_2 37500.06452607243
R6572 n_6_7_2 n_7_7_2 357.14346865764645
R6573 n_6_7_2 n_6_8_2 10437.214916177025
R6574 n_6_7_2 n_6_7_3 35100.060396403795
R6575 n_6_7_3 n_7_7_3 5000.008561207046
R6576 n_6_7_3 n_6_8_3 146121.00882647824
R6577 n_6_7_3 n_6_7_4 466.6674696577907
R6578 n_6_7_4 n_7_7_4 151.51541094566807
R6579 n_6_7_4 n_6_8_4 4427.909358378128
R6580 n_6_7_15 n_7_7_15 10000.017122414003
R6581 n_6_7_15 n_6_8_15 292242.0176529538
R6582 n_6_8_0 n_7_8_0 2.486703368932474
R6583 n_6_8_0 n_6_9_0 8206.915034689977
R6584 n_6_8_0 n_6_8_1 287.214241539764
R6585 n_6_8_1 n_7_8_1 3.481384716505463
R6586 n_6_8_1 n_6_9_1 11489.681048565966
R6587 n_6_8_1 n_6_8_2 652.7596398631
R6588 n_6_8_2 n_7_8_2 6.216758422331184
R6589 n_6_8_2 n_6_9_2 20517.287586724942
R6590 n_6_8_2 n_6_8_3 610.9830229118617
R6591 n_6_8_3 n_7_8_3 87.0346179126365
R6592 n_6_8_3 n_6_9_3 287242.02621414897
R6593 n_6_8_3 n_6_8_4 8.123231073851919
R6594 n_6_8_4 n_7_8_4 2.6374126640192883
R6595 n_6_8_4 n_6_9_4 8704.30382467118
R6596 n_6_8_15 n_7_8_15 174.06923582527145
R6597 n_6_8_15 n_6_9_15 574484.0524282926
R6598 n_6_9_0 n_7_9_0 2.486703368932472
R6599 n_6_9_0 n_6_10_0 8206.915034689977
R6600 n_6_9_0 n_6_9_1 287.2142415397638
R6601 n_6_9_1 n_7_9_1 3.481384716505461
R6602 n_6_9_1 n_6_10_1 11489.681048565966
R6603 n_6_9_1 n_6_9_2 652.7596398630996
R6604 n_6_9_2 n_7_9_2 6.21675842233118
R6605 n_6_9_2 n_6_10_2 20517.287586724942
R6606 n_6_9_2 n_6_9_3 610.9830229118612
R6607 n_6_9_3 n_7_9_3 87.03461791263645
R6608 n_6_9_3 n_6_10_3 287242.02621414897
R6609 n_6_9_3 n_6_9_4 8.123231073851914
R6610 n_6_9_4 n_7_9_4 2.6374126640192865
R6611 n_6_9_4 n_6_10_4 8704.30382467118
R6612 n_6_9_15 n_7_9_15 174.06923582527136
R6613 n_6_9_15 n_6_10_15 574484.0524282926
R6614 n_6_10_0 n_7_10_0 2.486703368932474
R6615 n_6_10_0 n_6_11_0 8206.915034689975
R6616 n_6_10_0 n_6_10_1 287.214241539764
R6617 n_6_10_1 n_7_10_1 3.481384716505463
R6618 n_6_10_1 n_6_11_1 11489.681048565963
R6619 n_6_10_1 n_6_10_2 652.7596398631
R6620 n_6_10_2 n_7_10_2 6.216758422331184
R6621 n_6_10_2 n_6_11_2 20517.287586724935
R6622 n_6_10_2 n_6_10_3 610.9830229118617
R6623 n_6_10_3 n_7_10_3 87.0346179126365
R6624 n_6_10_3 n_6_11_3 287242.02621414885
R6625 n_6_10_3 n_6_10_4 8.123231073851919
R6626 n_6_10_4 n_7_10_4 2.6374126640192883
R6627 n_6_10_4 n_6_11_4 8704.303824671177
R6628 n_6_10_15 n_7_10_15 174.06923582527145
R6629 n_6_10_15 n_6_11_15 574484.0524282925
R6630 n_6_11_0 n_7_11_0 2.486703368932474
R6631 n_6_11_0 n_6_12_0 4174.886089075483
R6632 n_6_11_0 n_6_11_1 287.214241539764
R6633 n_6_11_1 n_7_11_1 3.481384716505463
R6634 n_6_11_1 n_6_12_1 5844.840524705674
R6635 n_6_11_1 n_6_11_2 652.7596398631
R6636 n_6_11_2 n_7_11_2 6.216758422331184
R6637 n_6_11_2 n_6_12_2 10437.215222688706
R6638 n_6_11_2 n_6_11_3 610.9830229118617
R6639 n_6_11_3 n_7_11_3 87.0346179126365
R6640 n_6_11_3 n_6_12_3 146121.01311764176
R6641 n_6_11_3 n_6_11_4 8.123231073851919
R6642 n_6_11_4 n_7_11_4 2.6374126640192883
R6643 n_6_11_4 n_6_12_4 4427.9094884133865
R6644 n_6_11_15 n_7_11_15 174.06923582527145
R6645 n_6_11_15 n_6_12_15 292242.02623528085
R6646 n_6_12_0 n_7_12_0 142.8571422532951
R6647 n_6_12_0 n_6_13_0 142.85714346099064
R6648 n_6_12_0 n_6_12_1 16500.00006974395
R6649 n_6_12_1 n_7_12_1 199.99999915461314
R6650 n_6_12_1 n_6_13_1 200.0000008453869
R6651 n_6_12_1 n_6_12_2 37500.00015850898
R6652 n_6_12_2 n_7_12_2 357.1428556332378
R6653 n_6_12_2 n_6_13_2 357.14285865247666
R6654 n_6_12_2 n_6_12_3 35100.0001483644
R6655 n_6_12_3 n_7_12_3 4999.999978865324
R6656 n_6_12_3 n_6_13_3 5000.000021134669
R6657 n_6_12_3 n_6_12_4 466.6666686392232
R6658 n_6_12_4 n_7_12_4 151.5151508747068
R6659 n_6_12_4 n_6_13_4 151.51515215559598
R6660 n_6_12_15 n_7_12_15 9999.99995773056
R6661 n_6_12_15 n_6_13_15 10000.000042269246
R6662 n_6_13_0 n_7_13_0 142.8571422532951
R6663 n_6_13_0 n_6_14_0 142.85714346099064
R6664 n_6_13_0 n_6_13_1 16500.00006974395
R6665 n_6_13_1 n_7_13_1 199.99999915461314
R6666 n_6_13_1 n_6_14_1 200.0000008453869
R6667 n_6_13_1 n_6_13_2 37500.00015850898
R6668 n_6_13_2 n_7_13_2 357.1428556332378
R6669 n_6_13_2 n_6_14_2 357.14285865247666
R6670 n_6_13_2 n_6_13_3 35100.0001483644
R6671 n_6_13_3 n_7_13_3 4999.999978865324
R6672 n_6_13_3 n_6_14_3 5000.000021134669
R6673 n_6_13_3 n_6_13_4 466.6666686392232
R6674 n_6_13_4 n_7_13_4 151.5151508747068
R6675 n_6_13_4 n_6_14_4 151.51515215559598
R6676 n_6_13_15 n_7_13_15 9999.99995773056
R6677 n_6_13_15 n_6_14_15 10000.000042269246
R6678 n_6_14_0 n_7_14_0 142.8571422532951
R6679 n_6_14_0 n_6_15_0 142.85714346099064
R6680 n_6_14_0 n_6_14_1 16500.00006974395
R6681 n_6_14_1 n_7_14_1 199.99999915461314
R6682 n_6_14_1 n_6_15_1 200.0000008453869
R6683 n_6_14_1 n_6_14_2 37500.00015850898
R6684 n_6_14_2 n_7_14_2 357.1428556332378
R6685 n_6_14_2 n_6_15_2 357.14285865247666
R6686 n_6_14_2 n_6_14_3 35100.0001483644
R6687 n_6_14_3 n_7_14_3 4999.999978865324
R6688 n_6_14_3 n_6_15_3 5000.000021134669
R6689 n_6_14_3 n_6_14_4 466.6666686392232
R6690 n_6_14_4 n_7_14_4 151.5151508747068
R6691 n_6_14_4 n_6_15_4 151.51515215559598
R6692 n_6_14_15 n_7_14_15 9999.99995773056
R6693 n_6_14_15 n_6_15_15 10000.000042269246
R6694 n_6_15_0 n_7_15_0 142.8571422532951
R6695 n_6_15_0 n_6_16_0 4174.88608907548
R6696 n_6_15_0 n_6_15_1 16500.00006974395
R6697 n_6_15_1 n_7_15_1 199.99999915461314
R6698 n_6_15_1 n_6_16_1 5844.840524705671
R6699 n_6_15_1 n_6_15_2 37500.00015850898
R6700 n_6_15_2 n_7_15_2 357.1428556332378
R6701 n_6_15_2 n_6_16_2 10437.215222688701
R6702 n_6_15_2 n_6_15_3 35100.0001483644
R6703 n_6_15_3 n_7_15_3 4999.999978865324
R6704 n_6_15_3 n_6_16_3 146121.01311764168
R6705 n_6_15_3 n_6_15_4 466.6666686392232
R6706 n_6_15_4 n_7_15_4 151.5151508747068
R6707 n_6_15_4 n_6_16_4 4427.909488413384
R6708 n_6_15_15 n_7_15_15 9999.99995773056
R6709 n_6_15_15 n_6_16_15 292242.0262352807
R6710 n_6_16_0 n_7_16_0 2.4867033689324756
R6711 n_6_16_0 n_6_17_0 8206.915034689973
R6712 n_6_16_0 n_6_16_1 287.21424153976415
R6713 n_6_16_1 n_7_16_1 3.481384716505465
R6714 n_6_16_1 n_6_17_1 11489.681048565963
R6715 n_6_16_1 n_6_16_2 652.7596398631005
R6716 n_6_16_2 n_7_16_2 6.216758422331188
R6717 n_6_16_2 n_6_17_2 20517.28758672494
R6718 n_6_16_2 n_6_16_3 610.983022911862
R6719 n_6_16_3 n_7_16_3 87.03461791263655
R6720 n_6_16_3 n_6_17_3 287242.02621414885
R6721 n_6_16_3 n_6_16_4 8.123231073851922
R6722 n_6_16_4 n_7_16_4 2.637412664019289
R6723 n_6_16_4 n_6_17_4 8704.303824671177
R6724 n_6_16_15 n_7_16_15 174.06923582527156
R6725 n_6_16_15 n_6_17_15 574484.0524282925
R6726 n_6_17_0 n_7_17_0 2.486703368932472
R6727 n_6_17_0 n_6_18_0 8206.915034689979
R6728 n_6_17_0 n_6_17_1 287.2142415397638
R6729 n_6_17_1 n_7_17_1 3.481384716505461
R6730 n_6_17_1 n_6_18_1 11489.68104856597
R6731 n_6_17_1 n_6_17_2 652.7596398630996
R6732 n_6_17_2 n_7_17_2 6.21675842233118
R6733 n_6_17_2 n_6_18_2 20517.28758672495
R6734 n_6_17_2 n_6_17_3 610.9830229118612
R6735 n_6_17_3 n_7_17_3 87.03461791263645
R6736 n_6_17_3 n_6_18_3 287242.026214149
R6737 n_6_17_3 n_6_17_4 8.123231073851914
R6738 n_6_17_4 n_7_17_4 2.6374126640192865
R6739 n_6_17_4 n_6_18_4 8704.303824671182
R6740 n_6_17_15 n_7_17_15 174.06923582527136
R6741 n_6_17_15 n_6_18_15 574484.0524282928
R6742 n_6_18_0 n_7_18_0 2.486703368932472
R6743 n_6_18_0 n_6_19_0 8206.915034689973
R6744 n_6_18_0 n_6_18_1 287.2142415397638
R6745 n_6_18_1 n_7_18_1 3.481384716505461
R6746 n_6_18_1 n_6_19_1 11489.681048565963
R6747 n_6_18_1 n_6_18_2 652.7596398630996
R6748 n_6_18_2 n_7_18_2 6.21675842233118
R6749 n_6_18_2 n_6_19_2 20517.28758672494
R6750 n_6_18_2 n_6_18_3 610.9830229118612
R6751 n_6_18_3 n_7_18_3 87.03461791263645
R6752 n_6_18_3 n_6_19_3 287242.02621414885
R6753 n_6_18_3 n_6_18_4 8.123231073851914
R6754 n_6_18_4 n_7_18_4 2.6374126640192865
R6755 n_6_18_4 n_6_19_4 8704.303824671177
R6756 n_6_18_15 n_7_18_15 174.06923582527136
R6757 n_6_18_15 n_6_19_15 574484.0524282925
R6758 n_6_19_0 n_7_19_0 2.4867033689324756
R6759 n_6_19_0 n_6_20_0 4174.886102131099
R6760 n_6_19_0 n_6_19_1 287.21424153976415
R6761 n_6_19_1 n_7_19_1 3.481384716505465
R6762 n_6_19_1 n_6_20_1 5844.8405429835375
R6763 n_6_19_1 n_6_19_2 652.7596398631005
R6764 n_6_19_2 n_7_19_2 6.216758422331188
R6765 n_6_19_2 n_6_20_2 10437.215255327748
R6766 n_6_19_2 n_6_19_3 610.983022911862
R6767 n_6_19_3 n_7_19_3 87.03461791263655
R6768 n_6_19_3 n_6_20_3 146121.01357458835
R6769 n_6_19_3 n_6_19_4 8.123231073851922
R6770 n_6_19_4 n_7_19_4 2.637412664019289
R6771 n_6_19_4 n_6_20_4 4427.909502260252
R6772 n_6_19_15 n_7_19_15 174.06923582527156
R6773 n_6_19_15 n_6_20_15 292242.027149174
R6774 n_6_20_0 n_7_20_0 142.85711614206238
R6775 n_6_20_0 n_6_21_0 142.85716957222837
R6776 n_6_20_0 n_6_20_1 16499.997053896546
R6777 n_6_20_1 n_7_20_1 199.9999625988873
R6778 n_6_20_1 n_6_21_1 200.0000374011197
R6779 n_6_20_1 n_6_20_2 37499.99330431033
R6780 n_6_20_2 n_7_20_2 357.14279035515597
R6781 n_6_20_2 n_6_21_2 357.14292393057093
R6782 n_6_20_2 n_6_20_3 35099.99373283447
R6783 n_6_20_3 n_7_20_3 4999.999064972178
R6784 n_6_20_3 n_6_21_3 5000.000935027988
R6785 n_6_20_3 n_6_20_4 466.666583342529
R6786 n_6_20_4 n_7_20_4 151.5151231809751
R6787 n_6_20_4 n_6_21_4 151.51517984933295
R6788 n_6_20_15 n_7_20_15 9999.998129944266
R6789 n_6_20_15 n_6_21_15 10000.001870055885
R6790 n_6_21_0 n_7_21_0 142.85711614206238
R6791 n_6_21_0 n_6_22_0 142.8571695722233
R6792 n_6_21_0 n_6_21_1 16499.997053896546
R6793 n_6_21_1 n_7_21_1 199.9999625988873
R6794 n_6_21_1 n_6_22_1 200.0000374011126
R6795 n_6_21_1 n_6_21_2 37499.99330431033
R6796 n_6_21_2 n_7_21_2 357.14279035515597
R6797 n_6_21_2 n_6_22_2 357.14292393055825
R6798 n_6_21_2 n_6_21_3 35099.99373283447
R6799 n_6_21_3 n_7_21_3 4999.999064972178
R6800 n_6_21_3 n_6_22_3 5000.000935027811
R6801 n_6_21_3 n_6_21_4 466.666583342529
R6802 n_6_21_4 n_7_21_4 151.5151231809751
R6803 n_6_21_4 n_6_22_4 151.51517984932758
R6804 n_6_21_15 n_7_21_15 9999.998129944266
R6805 n_6_21_15 n_6_22_15 10000.00187005553
R6806 n_6_22_0 n_7_22_0 142.85711614207253
R6807 n_6_22_0 n_6_23_0 142.8571695722233
R6808 n_6_22_0 n_6_22_1 16499.997053897714
R6809 n_6_22_1 n_7_22_1 199.99996259890153
R6810 n_6_22_1 n_6_23_1 200.0000374011126
R6811 n_6_22_1 n_6_22_2 37499.993304312986
R6812 n_6_22_2 n_7_22_2 357.1427903551813
R6813 n_6_22_2 n_6_23_2 357.14292393055825
R6814 n_6_22_2 n_6_22_3 35099.993732836956
R6815 n_6_22_3 n_7_22_3 4999.999064972534
R6816 n_6_22_3 n_6_23_3 5000.000935027811
R6817 n_6_22_3 n_6_22_4 466.66658334256203
R6818 n_6_22_4 n_7_22_4 151.51512318098585
R6819 n_6_22_4 n_6_23_4 151.51517984932758
R6820 n_6_22_15 n_7_22_15 9999.998129944977
R6821 n_6_22_15 n_6_23_15 10000.00187005553
R6822 n_6_23_0 n_7_23_0 142.85711614206238
R6823 n_6_23_0 n_6_24_0 1646.6785783889536
R6824 n_6_23_0 n_6_23_1 16499.997053896546
R6825 n_6_23_1 n_7_23_1 199.9999625988873
R6826 n_6_23_1 n_6_24_1 2305.350009744535
R6827 n_6_23_1 n_6_23_2 37499.99330431033
R6828 n_6_23_2 n_7_23_2 357.14279035515597
R6829 n_6_23_2 n_6_24_2 4116.696445972384
R6830 n_6_23_2 n_6_23_3 35099.99373283447
R6831 n_6_23_3 n_7_23_3 4999.999064972178
R6832 n_6_23_3 n_6_24_3 57633.75024361332
R6833 n_6_23_3 n_6_23_4 466.666583342529
R6834 n_6_23_4 n_7_23_4 151.5151231809751
R6835 n_6_23_4 n_6_24_4 1746.4772801094944
R6836 n_6_23_15 n_7_23_15 9999.998129944266
R6837 n_6_23_15 n_6_24_15 115267.5004872256
R6838 n_6_24_0 n_7_24_0 6.477753800407742
R6839 n_6_24_0 n_6_25_0 3150.4999872056737
R6840 n_6_24_0 n_6_24_1 748.1805702720933
R6841 n_6_24_1 n_7_24_1 9.068855320570838
R6842 n_6_24_1 n_6_25_1 4410.699982087943
R6843 n_6_24_1 n_6_24_2 1700.4103869820299
R6844 n_6_24_2 n_7_24_2 16.194384501019357
R6845 n_6_24_2 n_6_25_2 7876.249968014185
R6846 n_6_24_2 n_6_24_3 1591.58412221518
R6847 n_6_24_3 n_7_24_3 226.72138301427077
R6848 n_6_24_3 n_6_25_3 110267.49955219848
R6849 n_6_24_3 n_6_24_4 21.16066259355417
R6850 n_6_24_4 n_7_24_4 6.870344939826387
R6851 n_6_24_4 n_6_25_4 3341.4393803696503
R6852 n_6_24_4 n_6_24_5 17.48993540895804
R6853 n_6_24_5 n_7_24_5 43.185025336051574
R6854 n_6_24_5 n_6_25_5 21003.333248037805
R6855 n_6_24_5 n_6_24_6 6.045903598158334
R6856 n_6_24_6 n_7_24_6 7.197504222675262
R6857 n_6_24_6 n_6_25_6 3500.5555413396346
R6858 n_6_24_6 n_6_24_7 8.205154883214872
R6859 n_6_24_7 n_7_24_7 12.338578667443345
R6860 n_6_24_7 n_6_25_7 6000.952356582249
R6861 n_6_24_7 n_6_24_8 6.045903598158315
R6862 n_6_24_8 n_7_24_8 12.338578667443345
R6863 n_6_24_8 n_6_25_8 6000.952356582249
R6864 n_6_24_8 n_6_24_9 6.045903598158315
R6865 n_6_24_9 n_7_24_9 12.338578667443345
R6866 n_6_24_9 n_6_25_9 6000.952356582249
R6867 n_6_24_9 n_6_24_10 6.045903598158315
R6868 n_6_24_10 n_7_24_10 12.338578667443345
R6869 n_6_24_10 n_6_25_10 6000.952356582249
R6870 n_6_24_10 n_6_24_11 6.045903598158276
R6871 n_6_24_11 n_7_24_11 12.338578667443501
R6872 n_6_24_11 n_6_25_11 6000.952356582326
R6873 n_6_24_11 n_6_24_12 6.045903598158256
R6874 n_6_24_12 n_7_24_12 12.338578667443425
R6875 n_6_24_12 n_6_25_12 6000.952356582287
R6876 n_6_24_12 n_6_24_13 6.045903598158315
R6877 n_6_24_13 n_7_24_13 12.338578667443267
R6878 n_6_24_13 n_6_25_13 6000.95235658221
R6879 n_6_24_13 n_6_24_14 30.22951799079165
R6880 n_6_24_14 n_7_24_14 1.3709531852714798
R6881 n_6_24_14 n_6_25_14 666.772484064693
R6882 n_6_24_14 n_6_24_15 934.0921059154706
R6883 n_6_24_15 n_7_24_15 453.44276602853745
R6884 n_6_24_15 n_6_25_15 220534.99910439496
R6885 n_6_25_0 n_7_25_0 6.477753800407763
R6886 n_6_25_0 n_6_26_0 3150.4999872056737
R6887 n_6_25_0 n_6_25_1 748.1805702720957
R6888 n_6_25_1 n_7_25_1 9.068855320570867
R6889 n_6_25_1 n_6_26_1 4410.699982087943
R6890 n_6_25_1 n_6_25_2 1700.4103869820356
R6891 n_6_25_2 n_7_25_2 16.194384501019407
R6892 n_6_25_2 n_6_26_2 7876.249968014185
R6893 n_6_25_2 n_6_25_3 1591.5841222151853
R6894 n_6_25_3 n_7_25_3 226.7213830142715
R6895 n_6_25_3 n_6_26_3 110267.49955219848
R6896 n_6_25_3 n_6_25_4 21.16066259355424
R6897 n_6_25_4 n_7_25_4 6.87034493982641
R6898 n_6_25_4 n_6_26_4 3341.4393803696503
R6899 n_6_25_4 n_6_25_5 17.489935408958093
R6900 n_6_25_5 n_7_25_5 43.18502533605171
R6901 n_6_25_5 n_6_26_5 21003.333248037805
R6902 n_6_25_5 n_6_25_6 6.045903598158354
R6903 n_6_25_6 n_7_25_6 7.197504222675286
R6904 n_6_25_6 n_6_26_6 3500.5555413396346
R6905 n_6_25_6 n_6_25_7 8.205154883214899
R6906 n_6_25_7 n_7_25_7 12.338578667443386
R6907 n_6_25_7 n_6_26_7 6000.952356582249
R6908 n_6_25_7 n_6_25_8 6.0459035981583344
R6909 n_6_25_8 n_7_25_8 12.338578667443386
R6910 n_6_25_8 n_6_26_8 6000.952356582249
R6911 n_6_25_8 n_6_25_9 6.0459035981583344
R6912 n_6_25_9 n_7_25_9 12.338578667443386
R6913 n_6_25_9 n_6_26_9 6000.952356582249
R6914 n_6_25_9 n_6_25_10 6.0459035981583344
R6915 n_6_25_10 n_7_25_10 12.338578667443386
R6916 n_6_25_10 n_6_26_10 6000.952356582249
R6917 n_6_25_10 n_6_25_11 6.045903598158295
R6918 n_6_25_11 n_7_25_11 12.338578667443542
R6919 n_6_25_11 n_6_26_11 6000.952356582326
R6920 n_6_25_11 n_6_25_12 6.045903598158276
R6921 n_6_25_12 n_7_25_12 12.33857866744346
R6922 n_6_25_12 n_6_26_12 6000.952356582287
R6923 n_6_25_12 n_6_25_13 6.0459035981583344
R6924 n_6_25_13 n_7_25_13 12.338578667443308
R6925 n_6_25_13 n_6_26_13 6000.95235658221
R6926 n_6_25_13 n_6_25_14 30.22951799079175
R6927 n_6_25_14 n_7_25_14 1.370953185271484
R6928 n_6_25_14 n_6_26_14 666.772484064693
R6929 n_6_25_14 n_6_25_15 934.0921059154737
R6930 n_6_25_15 n_7_25_15 453.4427660285389
R6931 n_6_25_15 n_6_26_15 220534.99910439496
R6932 n_6_26_0 n_7_26_0 6.477753800407742
R6933 n_6_26_0 n_6_27_0 3150.4999872056787
R6934 n_6_26_0 n_6_26_1 748.1805702720933
R6935 n_6_26_1 n_7_26_1 9.068855320570838
R6936 n_6_26_1 n_6_27_1 4410.69998208795
R6937 n_6_26_1 n_6_26_2 1700.4103869820299
R6938 n_6_26_2 n_7_26_2 16.194384501019357
R6939 n_6_26_2 n_6_27_2 7876.249968014196
R6940 n_6_26_2 n_6_26_3 1591.58412221518
R6941 n_6_26_3 n_7_26_3 226.72138301427077
R6942 n_6_26_3 n_6_27_3 110267.49955219866
R6943 n_6_26_3 n_6_26_4 21.16066259355417
R6944 n_6_26_4 n_7_26_4 6.870344939826387
R6945 n_6_26_4 n_6_27_4 3341.4393803696557
R6946 n_6_26_4 n_6_26_5 17.48993540895804
R6947 n_6_26_5 n_7_26_5 43.185025336051574
R6948 n_6_26_5 n_6_27_5 21003.333248037838
R6949 n_6_26_5 n_6_26_6 6.045903598158334
R6950 n_6_26_6 n_7_26_6 7.197504222675262
R6951 n_6_26_6 n_6_27_6 3500.55554133964
R6952 n_6_26_6 n_6_26_7 8.205154883214872
R6953 n_6_26_7 n_7_26_7 12.338578667443345
R6954 n_6_26_7 n_6_27_7 6000.952356582258
R6955 n_6_26_7 n_6_26_8 6.045903598158315
R6956 n_6_26_8 n_7_26_8 12.338578667443345
R6957 n_6_26_8 n_6_27_8 6000.952356582258
R6958 n_6_26_8 n_6_26_9 6.045903598158315
R6959 n_6_26_9 n_7_26_9 12.338578667443345
R6960 n_6_26_9 n_6_27_9 6000.952356582258
R6961 n_6_26_9 n_6_26_10 6.045903598158315
R6962 n_6_26_10 n_7_26_10 12.338578667443345
R6963 n_6_26_10 n_6_27_10 6000.952356582258
R6964 n_6_26_10 n_6_26_11 6.045903598158276
R6965 n_6_26_11 n_7_26_11 12.338578667443501
R6966 n_6_26_11 n_6_27_11 6000.952356582335
R6967 n_6_26_11 n_6_26_12 6.045903598158256
R6968 n_6_26_12 n_7_26_12 12.338578667443425
R6969 n_6_26_12 n_6_27_12 6000.952356582297
R6970 n_6_26_12 n_6_26_13 6.045903598158315
R6971 n_6_26_13 n_7_26_13 12.338578667443267
R6972 n_6_26_13 n_6_27_13 6000.952356582219
R6973 n_6_26_13 n_6_26_14 30.22951799079165
R6974 n_6_26_14 n_7_26_14 1.3709531852714798
R6975 n_6_26_14 n_6_27_14 666.772484064694
R6976 n_6_26_14 n_6_26_15 934.0921059154706
R6977 n_6_26_15 n_7_26_15 453.44276602853745
R6978 n_6_26_15 n_6_27_15 220534.9991043953
R6979 n_6_27_0 n_7_27_0 6.477753800407742
R6980 n_6_27_0 n_6_27_1 748.1805702720933
R6981 n_6_27_1 n_7_27_1 9.068855320570838
R6982 n_6_27_1 n_6_27_2 1700.4103869820299
R6983 n_6_27_2 n_7_27_2 16.194384501019357
R6984 n_6_27_2 n_6_27_3 1591.58412221518
R6985 n_6_27_3 n_7_27_3 226.72138301427077
R6986 n_6_27_3 n_6_27_4 21.16066259355417
R6987 n_6_27_4 n_7_27_4 6.870344939826387
R6988 n_6_27_4 n_6_27_5 17.48993540895804
R6989 n_6_27_5 n_7_27_5 43.185025336051574
R6990 n_6_27_5 n_6_27_6 6.045903598158334
R6991 n_6_27_6 n_7_27_6 7.197504222675262
R6992 n_6_27_6 n_6_27_7 8.205154883214872
R6993 n_6_27_7 n_7_27_7 12.338578667443345
R6994 n_6_27_7 n_6_27_8 6.045903598158315
R6995 n_6_27_8 n_7_27_8 12.338578667443345
R6996 n_6_27_8 n_6_27_9 6.045903598158315
R6997 n_6_27_9 n_7_27_9 12.338578667443345
R6998 n_6_27_9 n_6_27_10 6.045903598158315
R6999 n_6_27_10 n_7_27_10 12.338578667443345
R7000 n_6_27_10 n_6_27_11 6.045903598158276
R7001 n_6_27_11 n_7_27_11 12.338578667443501
R7002 n_6_27_11 n_6_27_12 6.045903598158256
R7003 n_6_27_12 n_7_27_12 12.338578667443425
R7004 n_6_27_12 n_6_27_13 6.045903598158315
R7005 n_6_27_13 n_7_27_13 12.338578667443267
R7006 n_6_27_13 n_6_27_14 30.22951799079165
R7007 n_6_27_14 n_7_27_14 1.3709531852714798
R7008 n_6_27_14 n_6_27_15 934.0921059154706
R7009 n_6_27_15 n_7_27_15 453.44276602853745
R7010 n_7_0_0 n_8_0_0 125.67181420979055
R7011 n_7_0_0 n_7_1_0 3150.5002585262537
R7012 n_7_0_0 n_7_0_1 748.180505838903
R7013 n_7_0_1 n_8_0_1 175.94053989370676
R7014 n_7_0_1 n_7_1_1 4410.700361936755
R7015 n_7_0_1 n_7_0_2 1700.4102405429612
R7016 n_7_0_2 n_8_0_2 314.17953552447636
R7017 n_7_0_2 n_7_1_2 7876.250646315634
R7018 n_7_0_2 n_7_0_3 1591.5839851482117
R7019 n_7_0_3 n_8_0_3 4398.513497342664
R7020 n_7_0_3 n_7_1_3 110267.50904841878
R7021 n_7_0_3 n_7_0_4 21.160660771201314
R7022 n_7_0_4 n_8_0_4 133.28828779826256
R7023 n_7_0_4 n_7_1_4 3341.439668133902
R7024 n_7_0_4 n_7_0_5 17.489933902727618
R7025 n_7_0_5 n_8_0_5 837.8120947319361
R7026 n_7_0_5 n_7_1_5 21003.33505684167
R7027 n_7_0_5 n_7_0_6 6.0459030774860905
R7028 n_7_0_6 n_8_0_6 139.63534912198935
R7029 n_7_0_6 n_7_1_6 3500.5558428069457
R7030 n_7_0_6 n_7_0_7 8.205154176588255
R7031 n_7_0_7 n_8_0_7 239.37488420912536
R7032 n_7_0_7 n_7_1_7 6000.952873383354
R7033 n_7_0_7 n_7_0_8 6.045903077486072
R7034 n_7_0_8 n_8_0_8 239.37488420912536
R7035 n_7_0_8 n_7_1_8 6000.952873383354
R7036 n_7_0_8 n_7_0_9 6.045903077486072
R7037 n_7_0_9 n_8_0_9 239.37488420912536
R7038 n_7_0_9 n_7_1_9 6000.952873383354
R7039 n_7_0_9 n_7_0_10 6.045903077486072
R7040 n_7_0_10 n_8_0_10 239.37488420912536
R7041 n_7_0_10 n_7_1_10 6000.952873383354
R7042 n_7_0_10 n_7_0_11 6.045903077486033
R7043 n_7_0_11 n_8_0_11 239.37488420912842
R7044 n_7_0_11 n_7_1_11 6000.9528733834295
R7045 n_7_0_11 n_7_0_12 6.045903077486013
R7046 n_7_0_12 n_8_0_12 239.37488420912698
R7047 n_7_0_12 n_7_1_12 6000.952873383392
R7048 n_7_0_12 n_7_0_13 6.045903077486072
R7049 n_7_0_13 n_8_0_13 239.37488420912388
R7050 n_7_0_13 n_7_1_13 6000.952873383315
R7051 n_7_0_13 n_7_0_14 30.229515387430432
R7052 n_7_0_14 n_8_0_14 26.59720935656943
R7053 n_7_0_14 n_7_1_14 666.772541487038
R7054 n_7_0_14 n_7_0_15 934.0920254716088
R7055 n_7_0_15 n_8_0_15 8797.026994685251
R7056 n_7_0_15 n_7_1_15 220535.01809683556
R7057 n_7_1_0 n_8_1_0 125.67181420979055
R7058 n_7_1_0 n_7_2_0 3150.5002585262537
R7059 n_7_1_0 n_7_1_1 748.180505838903
R7060 n_7_1_1 n_8_1_1 175.94053989370676
R7061 n_7_1_1 n_7_2_1 4410.700361936755
R7062 n_7_1_1 n_7_1_2 1700.4102405429612
R7063 n_7_1_2 n_8_1_2 314.17953552447636
R7064 n_7_1_2 n_7_2_2 7876.250646315634
R7065 n_7_1_2 n_7_1_3 1591.5839851482117
R7066 n_7_1_3 n_8_1_3 4398.513497342664
R7067 n_7_1_3 n_7_2_3 110267.50904841878
R7068 n_7_1_3 n_7_1_4 21.160660771201314
R7069 n_7_1_4 n_8_1_4 133.28828779826256
R7070 n_7_1_4 n_7_2_4 3341.439668133902
R7071 n_7_1_4 n_7_1_5 17.489933902727618
R7072 n_7_1_5 n_8_1_5 837.8120947319361
R7073 n_7_1_5 n_7_2_5 21003.33505684167
R7074 n_7_1_5 n_7_1_6 6.0459030774860905
R7075 n_7_1_6 n_8_1_6 139.63534912198935
R7076 n_7_1_6 n_7_2_6 3500.5558428069457
R7077 n_7_1_6 n_7_1_7 8.205154176588255
R7078 n_7_1_7 n_8_1_7 239.37488420912536
R7079 n_7_1_7 n_7_2_7 6000.952873383354
R7080 n_7_1_7 n_7_1_8 6.045903077486072
R7081 n_7_1_8 n_8_1_8 239.37488420912536
R7082 n_7_1_8 n_7_2_8 6000.952873383354
R7083 n_7_1_8 n_7_1_9 6.045903077486072
R7084 n_7_1_9 n_8_1_9 239.37488420912536
R7085 n_7_1_9 n_7_2_9 6000.952873383354
R7086 n_7_1_9 n_7_1_10 6.045903077486072
R7087 n_7_1_10 n_8_1_10 239.37488420912536
R7088 n_7_1_10 n_7_2_10 6000.952873383354
R7089 n_7_1_10 n_7_1_11 6.045903077486033
R7090 n_7_1_11 n_8_1_11 239.37488420912842
R7091 n_7_1_11 n_7_2_11 6000.9528733834295
R7092 n_7_1_11 n_7_1_12 6.045903077486013
R7093 n_7_1_12 n_8_1_12 239.37488420912698
R7094 n_7_1_12 n_7_2_12 6000.952873383392
R7095 n_7_1_12 n_7_1_13 6.045903077486072
R7096 n_7_1_13 n_8_1_13 239.37488420912388
R7097 n_7_1_13 n_7_2_13 6000.952873383315
R7098 n_7_1_13 n_7_1_14 30.229515387430432
R7099 n_7_1_14 n_8_1_14 26.59720935656943
R7100 n_7_1_14 n_7_2_14 666.772541487038
R7101 n_7_1_14 n_7_1_15 934.0920254716088
R7102 n_7_1_15 n_8_1_15 8797.026994685251
R7103 n_7_1_15 n_7_2_15 220535.01809683556
R7104 n_7_2_0 n_8_2_0 125.67181420979055
R7105 n_7_2_0 n_7_3_0 3150.5002585262537
R7106 n_7_2_0 n_7_2_1 748.180505838903
R7107 n_7_2_1 n_8_2_1 175.94053989370676
R7108 n_7_2_1 n_7_3_1 4410.700361936755
R7109 n_7_2_1 n_7_2_2 1700.4102405429612
R7110 n_7_2_2 n_8_2_2 314.17953552447636
R7111 n_7_2_2 n_7_3_2 7876.250646315634
R7112 n_7_2_2 n_7_2_3 1591.5839851482117
R7113 n_7_2_3 n_8_2_3 4398.513497342664
R7114 n_7_2_3 n_7_3_3 110267.50904841878
R7115 n_7_2_3 n_7_2_4 21.160660771201314
R7116 n_7_2_4 n_8_2_4 133.28828779826256
R7117 n_7_2_4 n_7_3_4 3341.439668133902
R7118 n_7_2_4 n_7_2_5 17.489933902727618
R7119 n_7_2_5 n_8_2_5 837.8120947319361
R7120 n_7_2_5 n_7_3_5 21003.33505684167
R7121 n_7_2_5 n_7_2_6 6.0459030774860905
R7122 n_7_2_6 n_8_2_6 139.63534912198935
R7123 n_7_2_6 n_7_3_6 3500.5558428069457
R7124 n_7_2_6 n_7_2_7 8.205154176588255
R7125 n_7_2_7 n_8_2_7 239.37488420912536
R7126 n_7_2_7 n_7_3_7 6000.952873383354
R7127 n_7_2_7 n_7_2_8 6.045903077486072
R7128 n_7_2_8 n_8_2_8 239.37488420912536
R7129 n_7_2_8 n_7_3_8 6000.952873383354
R7130 n_7_2_8 n_7_2_9 6.045903077486072
R7131 n_7_2_9 n_8_2_9 239.37488420912536
R7132 n_7_2_9 n_7_3_9 6000.952873383354
R7133 n_7_2_9 n_7_2_10 6.045903077486072
R7134 n_7_2_10 n_8_2_10 239.37488420912536
R7135 n_7_2_10 n_7_3_10 6000.952873383354
R7136 n_7_2_10 n_7_2_11 6.045903077486033
R7137 n_7_2_11 n_8_2_11 239.37488420912842
R7138 n_7_2_11 n_7_3_11 6000.9528733834295
R7139 n_7_2_11 n_7_2_12 6.045903077486013
R7140 n_7_2_12 n_8_2_12 239.37488420912698
R7141 n_7_2_12 n_7_3_12 6000.952873383392
R7142 n_7_2_12 n_7_2_13 6.045903077486072
R7143 n_7_2_13 n_8_2_13 239.37488420912388
R7144 n_7_2_13 n_7_3_13 6000.952873383315
R7145 n_7_2_13 n_7_2_14 30.229515387430432
R7146 n_7_2_14 n_8_2_14 26.59720935656943
R7147 n_7_2_14 n_7_3_14 666.772541487038
R7148 n_7_2_14 n_7_2_15 934.0920254716088
R7149 n_7_2_15 n_8_2_15 8797.026994685251
R7150 n_7_2_15 n_7_3_15 220535.01809683556
R7151 n_7_3_0 n_8_3_0 125.67181420979055
R7152 n_7_3_0 n_7_4_0 1646.6785783889497
R7153 n_7_3_0 n_7_3_1 748.180505838903
R7154 n_7_3_1 n_8_3_1 175.94053989370676
R7155 n_7_3_1 n_7_4_1 2305.35000974453
R7156 n_7_3_1 n_7_3_2 1700.4102405429612
R7157 n_7_3_2 n_8_3_2 314.17953552447636
R7158 n_7_3_2 n_7_4_2 4116.696445972375
R7159 n_7_3_2 n_7_3_3 1591.5839851482117
R7160 n_7_3_3 n_8_3_3 4398.513497342664
R7161 n_7_3_3 n_7_4_3 57633.75024361319
R7162 n_7_3_3 n_7_3_4 21.160660771201314
R7163 n_7_3_4 n_8_3_4 133.28828779826256
R7164 n_7_3_4 n_7_4_4 1746.4772801094905
R7165 n_7_3_4 n_7_3_5 17.489933902727618
R7166 n_7_3_5 n_8_3_5 837.8120947319361
R7167 n_7_3_5 n_7_3_6 6.0459030774860905
R7168 n_7_3_6 n_8_3_6 139.63534912198935
R7169 n_7_3_6 n_7_3_7 8.205154176588255
R7170 n_7_3_7 n_8_3_7 239.37488420912536
R7171 n_7_3_7 n_7_3_8 6.045903077486072
R7172 n_7_3_8 n_8_3_8 239.37488420912536
R7173 n_7_3_8 n_7_3_9 6.045903077486072
R7174 n_7_3_9 n_8_3_9 239.37488420912536
R7175 n_7_3_9 n_7_3_10 6.045903077486072
R7176 n_7_3_10 n_8_3_10 239.37488420912536
R7177 n_7_3_10 n_7_3_11 6.045903077486033
R7178 n_7_3_11 n_8_3_11 239.37488420912842
R7179 n_7_3_11 n_7_3_12 6.045903077486013
R7180 n_7_3_12 n_8_3_12 239.37488420912698
R7181 n_7_3_12 n_7_3_13 6.045903077486072
R7182 n_7_3_13 n_8_3_13 239.37488420912388
R7183 n_7_3_13 n_7_3_14 30.229515387430432
R7184 n_7_3_14 n_8_3_14 26.59720935656943
R7185 n_7_3_14 n_7_3_15 934.0920254716088
R7186 n_7_3_15 n_8_3_15 8797.026994685251
R7187 n_7_3_15 n_7_4_15 115267.50048722533
R7188 n_7_4_0 n_8_4_0 2771.5083275850593
R7189 n_7_4_0 n_7_5_0 142.85689825164724
R7190 n_7_4_0 n_7_4_1 16500.02839147187
R7191 n_7_4_1 n_8_4_1 3880.1116586190833
R7192 n_7_4_1 n_7_5_1 199.99965755230613
R7193 n_7_4_1 n_7_4_2 37500.06452607243
R7194 n_7_4_2 n_8_4_2 6928.770818962649
R7195 n_7_4_2 n_7_5_2 357.1422456291181
R7196 n_7_4_2 n_7_4_3 35100.060396403795
R7197 n_7_4_3 n_8_4_3 97002.791465477
R7198 n_7_4_3 n_7_5_3 4999.9914388076495
R7199 n_7_4_3 n_7_4_4 466.6674696577907
R7200 n_7_4_4 n_8_4_4 2939.478529256879
R7201 n_7_4_4 n_7_5_4 151.51489208508025
R7202 n_7_4_15 n_8_4_15 194005.58293095228
R7203 n_7_4_15 n_7_5_15 9999.982877615208
R7204 n_7_5_0 n_8_5_0 2771.508327585011
R7205 n_7_5_0 n_7_6_0 142.85689825164852
R7206 n_7_5_0 n_7_5_1 16500.028391471576
R7207 n_7_5_1 n_8_5_1 3880.111658619014
R7208 n_7_5_1 n_7_6_1 199.99965755230792
R7209 n_7_5_1 n_7_5_2 37500.064526071765
R7210 n_7_5_2 n_8_5_2 6928.7708189625255
R7211 n_7_5_2 n_7_6_2 357.1422456291213
R7212 n_7_5_2 n_7_5_3 35100.06039640317
R7213 n_7_5_3 n_8_5_3 97002.79146547527
R7214 n_7_5_3 n_7_6_3 4999.991438807694
R7215 n_7_5_3 n_7_5_4 466.6674696577824
R7216 n_7_5_4 n_8_5_4 2939.4785292568267
R7217 n_7_5_4 n_7_6_4 151.5148920850816
R7218 n_7_5_15 n_8_5_15 194005.58293094882
R7219 n_7_5_15 n_7_6_15 9999.982877615297
R7220 n_7_6_0 n_8_6_0 2771.508327585011
R7221 n_7_6_0 n_7_7_0 142.85689825164724
R7222 n_7_6_0 n_7_6_1 16500.028391471576
R7223 n_7_6_1 n_8_6_1 3880.111658619014
R7224 n_7_6_1 n_7_7_1 199.99965755230613
R7225 n_7_6_1 n_7_6_2 37500.064526071765
R7226 n_7_6_2 n_8_6_2 6928.7708189625255
R7227 n_7_6_2 n_7_7_2 357.1422456291181
R7228 n_7_6_2 n_7_6_3 35100.06039640317
R7229 n_7_6_3 n_8_6_3 97002.79146547527
R7230 n_7_6_3 n_7_7_3 4999.9914388076495
R7231 n_7_6_3 n_7_6_4 466.6674696577824
R7232 n_7_6_4 n_8_6_4 2939.4785292568267
R7233 n_7_6_4 n_7_7_4 151.51489208508025
R7234 n_7_6_15 n_8_6_15 194005.58293094882
R7235 n_7_6_15 n_7_7_15 9999.982877615208
R7236 n_7_7_0 n_8_7_0 2771.5083275850593
R7237 n_7_7_0 n_7_8_0 4174.885966470811
R7238 n_7_7_0 n_7_7_1 16500.02839147187
R7239 n_7_7_1 n_8_7_1 3880.1116586190833
R7240 n_7_7_1 n_7_8_1 5844.840353059133
R7241 n_7_7_1 n_7_7_2 37500.06452607243
R7242 n_7_7_2 n_8_7_2 6928.770818962649
R7243 n_7_7_2 n_7_8_2 10437.214916177025
R7244 n_7_7_2 n_7_7_3 35100.060396403795
R7245 n_7_7_3 n_8_7_3 97002.791465477
R7246 n_7_7_3 n_7_8_3 146121.00882647824
R7247 n_7_7_3 n_7_7_4 466.6674696577907
R7248 n_7_7_4 n_8_7_4 2939.478529256879
R7249 n_7_7_4 n_7_8_4 4427.909358378128
R7250 n_7_7_15 n_8_7_15 194005.58293095228
R7251 n_7_7_15 n_7_8_15 292242.0176529538
R7252 n_7_8_0 n_8_8_0 48.24335106234777
R7253 n_7_8_0 n_7_9_0 8206.915034689977
R7254 n_7_8_0 n_7_8_1 287.214241539764
R7255 n_7_8_1 n_8_8_1 67.54069148728686
R7256 n_7_8_1 n_7_9_1 11489.681048565966
R7257 n_7_8_1 n_7_8_2 652.7596398631
R7258 n_7_8_2 n_8_8_2 120.60837765586942
R7259 n_7_8_2 n_7_9_2 20517.287586724942
R7260 n_7_8_2 n_7_8_3 610.9830229118617
R7261 n_7_8_3 n_8_8_3 1688.51728718217
R7262 n_7_8_3 n_7_9_3 287242.02621414897
R7263 n_7_8_3 n_7_8_4 8.123231073851919
R7264 n_7_8_4 n_8_8_4 51.16719052067184
R7265 n_7_8_4 n_7_9_4 8704.30382467118
R7266 n_7_8_15 n_8_8_15 3377.0345743643106
R7267 n_7_8_15 n_7_9_15 574484.0524282926
R7268 n_7_9_0 n_8_9_0 48.24335106234773
R7269 n_7_9_0 n_7_10_0 8206.915034689977
R7270 n_7_9_0 n_7_9_1 287.2142415397638
R7271 n_7_9_1 n_8_9_1 67.54069148728684
R7272 n_7_9_1 n_7_10_1 11489.681048565966
R7273 n_7_9_1 n_7_9_2 652.7596398630996
R7274 n_7_9_2 n_8_9_2 120.60837765586933
R7275 n_7_9_2 n_7_10_2 20517.287586724942
R7276 n_7_9_2 n_7_9_3 610.9830229118612
R7277 n_7_9_3 n_8_9_3 1688.5172871821692
R7278 n_7_9_3 n_7_10_3 287242.02621414897
R7279 n_7_9_3 n_7_9_4 8.123231073851914
R7280 n_7_9_4 n_8_9_4 51.167190520671795
R7281 n_7_9_4 n_7_10_4 8704.30382467118
R7282 n_7_9_15 n_8_9_15 3377.034574364309
R7283 n_7_9_15 n_7_10_15 574484.0524282926
R7284 n_7_10_0 n_8_10_0 48.24335106234777
R7285 n_7_10_0 n_7_11_0 8206.915034689975
R7286 n_7_10_0 n_7_10_1 287.214241539764
R7287 n_7_10_1 n_8_10_1 67.54069148728686
R7288 n_7_10_1 n_7_11_1 11489.681048565963
R7289 n_7_10_1 n_7_10_2 652.7596398631
R7290 n_7_10_2 n_8_10_2 120.60837765586942
R7291 n_7_10_2 n_7_11_2 20517.287586724935
R7292 n_7_10_2 n_7_10_3 610.9830229118617
R7293 n_7_10_3 n_8_10_3 1688.51728718217
R7294 n_7_10_3 n_7_11_3 287242.02621414885
R7295 n_7_10_3 n_7_10_4 8.123231073851919
R7296 n_7_10_4 n_8_10_4 51.16719052067184
R7297 n_7_10_4 n_7_11_4 8704.303824671177
R7298 n_7_10_15 n_8_10_15 3377.0345743643106
R7299 n_7_10_15 n_7_11_15 574484.0524282925
R7300 n_7_11_0 n_8_11_0 48.24335106234777
R7301 n_7_11_0 n_7_12_0 4174.886089075483
R7302 n_7_11_0 n_7_11_1 287.214241539764
R7303 n_7_11_1 n_8_11_1 67.54069148728686
R7304 n_7_11_1 n_7_12_1 5844.840524705674
R7305 n_7_11_1 n_7_11_2 652.7596398631
R7306 n_7_11_2 n_8_11_2 120.60837765586942
R7307 n_7_11_2 n_7_12_2 10437.215222688706
R7308 n_7_11_2 n_7_11_3 610.9830229118617
R7309 n_7_11_3 n_8_11_3 1688.51728718217
R7310 n_7_11_3 n_7_12_3 146121.01311764176
R7311 n_7_11_3 n_7_11_4 8.123231073851919
R7312 n_7_11_4 n_8_11_4 51.16719052067184
R7313 n_7_11_4 n_7_12_4 4427.9094884133865
R7314 n_7_11_15 n_8_11_15 3377.0345743643106
R7315 n_7_11_15 n_7_12_15 292242.02623528085
R7316 n_7_12_0 n_8_12_0 2771.5035703868944
R7317 n_7_12_0 n_7_13_0 142.85714346099064
R7318 n_7_12_0 n_7_12_1 16500.00006974395
R7319 n_7_12_1 n_8_12_1 3880.104998541652
R7320 n_7_12_1 n_7_13_1 200.0000008453869
R7321 n_7_12_1 n_7_12_2 37500.00015850898
R7322 n_7_12_2 n_8_12_2 6928.758925967237
R7323 n_7_12_2 n_7_13_2 357.14285865247666
R7324 n_7_12_2 n_7_12_3 35100.0001483644
R7325 n_7_12_3 n_8_12_3 97002.62496354122
R7326 n_7_12_3 n_7_13_3 5000.000021134669
R7327 n_7_12_3 n_7_12_4 466.6666686392232
R7328 n_7_12_4 n_8_12_4 2939.4734837436736
R7329 n_7_12_4 n_7_13_4 151.51515215559598
R7330 n_7_12_15 n_8_12_15 194005.24992708076
R7331 n_7_12_15 n_7_13_15 10000.000042269246
R7332 n_7_13_0 n_8_13_0 2771.5035703868944
R7333 n_7_13_0 n_7_14_0 142.85714346099064
R7334 n_7_13_0 n_7_13_1 16500.00006974395
R7335 n_7_13_1 n_8_13_1 3880.104998541652
R7336 n_7_13_1 n_7_14_1 200.0000008453869
R7337 n_7_13_1 n_7_13_2 37500.00015850898
R7338 n_7_13_2 n_8_13_2 6928.758925967237
R7339 n_7_13_2 n_7_14_2 357.14285865247666
R7340 n_7_13_2 n_7_13_3 35100.0001483644
R7341 n_7_13_3 n_8_13_3 97002.62496354122
R7342 n_7_13_3 n_7_14_3 5000.000021134669
R7343 n_7_13_3 n_7_13_4 466.6666686392232
R7344 n_7_13_4 n_8_13_4 2939.4734837436736
R7345 n_7_13_4 n_7_14_4 151.51515215559598
R7346 n_7_13_15 n_8_13_15 194005.24992708076
R7347 n_7_13_15 n_7_14_15 10000.000042269246
R7348 n_7_14_0 n_8_14_0 2771.5035703868944
R7349 n_7_14_0 n_7_15_0 142.85714346099064
R7350 n_7_14_0 n_7_14_1 16500.00006974395
R7351 n_7_14_1 n_8_14_1 3880.104998541652
R7352 n_7_14_1 n_7_15_1 200.0000008453869
R7353 n_7_14_1 n_7_14_2 37500.00015850898
R7354 n_7_14_2 n_8_14_2 6928.758925967237
R7355 n_7_14_2 n_7_15_2 357.14285865247666
R7356 n_7_14_2 n_7_14_3 35100.0001483644
R7357 n_7_14_3 n_8_14_3 97002.62496354122
R7358 n_7_14_3 n_7_15_3 5000.000021134669
R7359 n_7_14_3 n_7_14_4 466.6666686392232
R7360 n_7_14_4 n_8_14_4 2939.4734837436736
R7361 n_7_14_4 n_7_15_4 151.51515215559598
R7362 n_7_14_15 n_8_14_15 194005.24992708076
R7363 n_7_14_15 n_7_15_15 10000.000042269246
R7364 n_7_15_0 n_8_15_0 2771.5035703868944
R7365 n_7_15_0 n_7_16_0 4174.88608907548
R7366 n_7_15_0 n_7_15_1 16500.00006974395
R7367 n_7_15_1 n_8_15_1 3880.104998541652
R7368 n_7_15_1 n_7_16_1 5844.840524705671
R7369 n_7_15_1 n_7_15_2 37500.00015850898
R7370 n_7_15_2 n_8_15_2 6928.758925967237
R7371 n_7_15_2 n_7_16_2 10437.215222688701
R7372 n_7_15_2 n_7_15_3 35100.0001483644
R7373 n_7_15_3 n_8_15_3 97002.62496354122
R7374 n_7_15_3 n_7_16_3 146121.01311764168
R7375 n_7_15_3 n_7_15_4 466.6666686392232
R7376 n_7_15_4 n_8_15_4 2939.4734837436736
R7377 n_7_15_4 n_7_16_4 4427.909488413384
R7378 n_7_15_15 n_8_15_15 194005.24992708076
R7379 n_7_15_15 n_7_16_15 292242.0262352807
R7380 n_7_16_0 n_8_16_0 48.243351062347806
R7381 n_7_16_0 n_7_17_0 8206.915034689973
R7382 n_7_16_0 n_7_16_1 287.21424153976415
R7383 n_7_16_1 n_8_16_1 67.5406914872869
R7384 n_7_16_1 n_7_17_1 11489.681048565963
R7385 n_7_16_1 n_7_16_2 652.7596398631005
R7386 n_7_16_2 n_8_16_2 120.60837765586949
R7387 n_7_16_2 n_7_17_2 20517.28758672494
R7388 n_7_16_2 n_7_16_3 610.983022911862
R7389 n_7_16_3 n_8_16_3 1688.517287182171
R7390 n_7_16_3 n_7_17_3 287242.02621414885
R7391 n_7_16_3 n_7_16_4 8.123231073851922
R7392 n_7_16_4 n_8_16_4 51.16719052067185
R7393 n_7_16_4 n_7_17_4 8704.303824671177
R7394 n_7_16_15 n_8_16_15 3377.0345743643124
R7395 n_7_16_15 n_7_17_15 574484.0524282925
R7396 n_7_17_0 n_8_17_0 48.24335106234773
R7397 n_7_17_0 n_7_18_0 8206.915034689979
R7398 n_7_17_0 n_7_17_1 287.2142415397638
R7399 n_7_17_1 n_8_17_1 67.54069148728684
R7400 n_7_17_1 n_7_18_1 11489.68104856597
R7401 n_7_17_1 n_7_17_2 652.7596398630996
R7402 n_7_17_2 n_8_17_2 120.60837765586933
R7403 n_7_17_2 n_7_18_2 20517.28758672495
R7404 n_7_17_2 n_7_17_3 610.9830229118612
R7405 n_7_17_3 n_8_17_3 1688.5172871821692
R7406 n_7_17_3 n_7_18_3 287242.026214149
R7407 n_7_17_3 n_7_17_4 8.123231073851914
R7408 n_7_17_4 n_8_17_4 51.167190520671795
R7409 n_7_17_4 n_7_18_4 8704.303824671182
R7410 n_7_17_15 n_8_17_15 3377.034574364309
R7411 n_7_17_15 n_7_18_15 574484.0524282928
R7412 n_7_18_0 n_8_18_0 48.24335106234773
R7413 n_7_18_0 n_7_19_0 8206.915034689973
R7414 n_7_18_0 n_7_18_1 287.2142415397638
R7415 n_7_18_1 n_8_18_1 67.54069148728684
R7416 n_7_18_1 n_7_19_1 11489.681048565963
R7417 n_7_18_1 n_7_18_2 652.7596398630996
R7418 n_7_18_2 n_8_18_2 120.60837765586933
R7419 n_7_18_2 n_7_19_2 20517.28758672494
R7420 n_7_18_2 n_7_18_3 610.9830229118612
R7421 n_7_18_3 n_8_18_3 1688.5172871821692
R7422 n_7_18_3 n_7_19_3 287242.02621414885
R7423 n_7_18_3 n_7_18_4 8.123231073851914
R7424 n_7_18_4 n_8_18_4 51.167190520671795
R7425 n_7_18_4 n_7_19_4 8704.303824671177
R7426 n_7_18_15 n_8_18_15 3377.034574364309
R7427 n_7_18_15 n_7_19_15 574484.0524282925
R7428 n_7_19_0 n_8_19_0 48.243351062347806
R7429 n_7_19_0 n_7_20_0 4174.886102131099
R7430 n_7_19_0 n_7_19_1 287.21424153976415
R7431 n_7_19_1 n_8_19_1 67.5406914872869
R7432 n_7_19_1 n_7_20_1 5844.8405429835375
R7433 n_7_19_1 n_7_19_2 652.7596398631005
R7434 n_7_19_2 n_8_19_2 120.60837765586949
R7435 n_7_19_2 n_7_20_2 10437.215255327748
R7436 n_7_19_2 n_7_19_3 610.983022911862
R7437 n_7_19_3 n_8_19_3 1688.517287182171
R7438 n_7_19_3 n_7_20_3 146121.01357458835
R7439 n_7_19_3 n_7_19_4 8.123231073851922
R7440 n_7_19_4 n_8_19_4 51.16719052067185
R7441 n_7_19_4 n_7_20_4 4427.909502260252
R7442 n_7_19_15 n_8_19_15 3377.0345743643124
R7443 n_7_19_15 n_7_20_15 292242.027149174
R7444 n_7_20_0 n_8_20_0 2771.5030638152693
R7445 n_7_20_0 n_7_21_0 142.85716957222837
R7446 n_7_20_0 n_7_20_1 16499.997053896546
R7447 n_7_20_1 n_8_20_1 3880.1042893413764
R7448 n_7_20_1 n_7_21_1 200.0000374011197
R7449 n_7_20_1 n_7_20_2 37499.99330431033
R7450 n_7_20_2 n_8_20_2 6928.757659538174
R7451 n_7_20_2 n_7_21_2 357.14292393057093
R7452 n_7_20_2 n_7_20_3 35099.99373283447
R7453 n_7_20_3 n_8_20_3 97002.60723353433
R7454 n_7_20_3 n_7_21_3 5000.000935027988
R7455 n_7_20_3 n_7_20_4 466.666583342529
R7456 n_7_20_4 n_8_20_4 2939.4729464707375
R7457 n_7_20_4 n_7_21_4 151.51517984933295
R7458 n_7_20_15 n_8_20_15 194005.21446706692
R7459 n_7_20_15 n_7_21_15 10000.001870055885
R7460 n_7_21_0 n_8_21_0 2771.5030638152693
R7461 n_7_21_0 n_7_22_0 142.8571695722233
R7462 n_7_21_0 n_7_21_1 16499.997053896546
R7463 n_7_21_1 n_8_21_1 3880.1042893413764
R7464 n_7_21_1 n_7_22_1 200.0000374011126
R7465 n_7_21_1 n_7_21_2 37499.99330431033
R7466 n_7_21_2 n_8_21_2 6928.757659538174
R7467 n_7_21_2 n_7_22_2 357.14292393055825
R7468 n_7_21_2 n_7_21_3 35099.99373283447
R7469 n_7_21_3 n_8_21_3 97002.60723353433
R7470 n_7_21_3 n_7_22_3 5000.000935027811
R7471 n_7_21_3 n_7_21_4 466.666583342529
R7472 n_7_21_4 n_8_21_4 2939.4729464707375
R7473 n_7_21_4 n_7_22_4 151.51517984932758
R7474 n_7_21_15 n_8_21_15 194005.21446706692
R7475 n_7_21_15 n_7_22_15 10000.00187005553
R7476 n_7_22_0 n_8_22_0 2771.503063815466
R7477 n_7_22_0 n_7_23_0 142.8571695722233
R7478 n_7_22_0 n_7_22_1 16499.997053897714
R7479 n_7_22_1 n_8_22_1 3880.1042893416525
R7480 n_7_22_1 n_7_23_1 200.0000374011126
R7481 n_7_22_1 n_7_22_2 37499.993304312986
R7482 n_7_22_2 n_8_22_2 6928.757659538665
R7483 n_7_22_2 n_7_23_2 357.14292393055825
R7484 n_7_22_2 n_7_22_3 35099.993732836956
R7485 n_7_22_3 n_8_22_3 97002.60723354123
R7486 n_7_22_3 n_7_23_3 5000.000935027811
R7487 n_7_22_3 n_7_22_4 466.66658334256203
R7488 n_7_22_4 n_8_22_4 2939.472946470946
R7489 n_7_22_4 n_7_23_4 151.51517984932758
R7490 n_7_22_15 n_8_22_15 194005.21446708072
R7491 n_7_22_15 n_7_23_15 10000.00187005553
R7492 n_7_23_0 n_8_23_0 2771.5030638152693
R7493 n_7_23_0 n_7_24_0 1646.6785783889536
R7494 n_7_23_0 n_7_23_1 16499.997053896546
R7495 n_7_23_1 n_8_23_1 3880.1042893413764
R7496 n_7_23_1 n_7_24_1 2305.350009744535
R7497 n_7_23_1 n_7_23_2 37499.99330431033
R7498 n_7_23_2 n_8_23_2 6928.757659538174
R7499 n_7_23_2 n_7_24_2 4116.696445972384
R7500 n_7_23_2 n_7_23_3 35099.99373283447
R7501 n_7_23_3 n_8_23_3 97002.60723353433
R7502 n_7_23_3 n_7_24_3 57633.75024361332
R7503 n_7_23_3 n_7_23_4 466.666583342529
R7504 n_7_23_4 n_8_23_4 2939.4729464707375
R7505 n_7_23_4 n_7_24_4 1746.4772801094944
R7506 n_7_23_15 n_8_23_15 194005.21446706692
R7507 n_7_23_15 n_7_24_15 115267.5004872256
R7508 n_7_24_0 n_8_24_0 125.67182503262788
R7509 n_7_24_0 n_7_25_0 3150.4999872056737
R7510 n_7_24_0 n_7_24_1 748.1805702720933
R7511 n_7_24_1 n_8_24_1 175.940555045679
R7512 n_7_24_1 n_7_25_1 4410.699982087943
R7513 n_7_24_1 n_7_24_2 1700.4103869820299
R7514 n_7_24_2 n_8_24_2 314.1795625815697
R7515 n_7_24_2 n_7_25_2 7876.249968014185
R7516 n_7_24_2 n_7_24_3 1591.58412221518
R7517 n_7_24_3 n_8_24_3 4398.513876141971
R7518 n_7_24_3 n_7_25_3 110267.49955219848
R7519 n_7_24_3 n_7_24_4 21.16066259355417
R7520 n_7_24_4 n_8_24_4 133.28829927702944
R7521 n_7_24_4 n_7_25_4 3341.4393803696503
R7522 n_7_24_4 n_7_24_5 17.48993540895804
R7523 n_7_24_5 n_8_24_5 837.8121668841851
R7524 n_7_24_5 n_7_25_5 21003.333248037805
R7525 n_7_24_5 n_7_24_6 6.045903598158334
R7526 n_7_24_6 n_8_24_6 139.63536114736416
R7527 n_7_24_6 n_7_25_6 3500.5555413396346
R7528 n_7_24_6 n_7_24_7 8.205154883214872
R7529 n_7_24_7 n_8_24_7 239.3749048240536
R7530 n_7_24_7 n_7_25_7 6000.952356582249
R7531 n_7_24_7 n_7_24_8 6.045903598158315
R7532 n_7_24_8 n_8_24_8 239.3749048240536
R7533 n_7_24_8 n_7_25_8 6000.952356582249
R7534 n_7_24_8 n_7_24_9 6.045903598158315
R7535 n_7_24_9 n_8_24_9 239.3749048240536
R7536 n_7_24_9 n_7_25_9 6000.952356582249
R7537 n_7_24_9 n_7_24_10 6.045903598158315
R7538 n_7_24_10 n_8_24_10 239.3749048240536
R7539 n_7_24_10 n_7_25_10 6000.952356582249
R7540 n_7_24_10 n_7_24_11 6.045903598158276
R7541 n_7_24_11 n_8_24_11 239.37490482405667
R7542 n_7_24_11 n_7_25_11 6000.952356582326
R7543 n_7_24_11 n_7_24_12 6.045903598158256
R7544 n_7_24_12 n_8_24_12 239.37490482405514
R7545 n_7_24_12 n_7_25_12 6000.952356582287
R7546 n_7_24_12 n_7_24_13 6.045903598158315
R7547 n_7_24_13 n_8_24_13 239.3749048240521
R7548 n_7_24_13 n_7_25_13 6000.95235658221
R7549 n_7_24_13 n_7_24_14 30.22951799079165
R7550 n_7_24_14 n_8_24_14 26.59721164711701
R7551 n_7_24_14 n_7_25_14 666.772484064693
R7552 n_7_24_14 n_7_24_15 934.0921059154706
R7553 n_7_24_15 n_8_24_15 8797.027752283864
R7554 n_7_24_15 n_7_25_15 220534.99910439496
R7555 n_7_25_0 n_8_25_0 125.67182503262828
R7556 n_7_25_0 n_7_26_0 3150.4999872056737
R7557 n_7_25_0 n_7_25_1 748.1805702720957
R7558 n_7_25_1 n_8_25_1 175.9405550456796
R7559 n_7_25_1 n_7_26_1 4410.699982087943
R7560 n_7_25_1 n_7_25_2 1700.4103869820356
R7561 n_7_25_2 n_8_25_2 314.1795625815707
R7562 n_7_25_2 n_7_26_2 7876.249968014185
R7563 n_7_25_2 n_7_25_3 1591.5841222151853
R7564 n_7_25_3 n_8_25_3 4398.513876141986
R7565 n_7_25_3 n_7_26_3 110267.49955219848
R7566 n_7_25_3 n_7_25_4 21.16066259355424
R7567 n_7_25_4 n_8_25_4 133.28829927702986
R7568 n_7_25_4 n_7_26_4 3341.4393803696503
R7569 n_7_25_4 n_7_25_5 17.489935408958093
R7570 n_7_25_5 n_8_25_5 837.8121668841877
R7571 n_7_25_5 n_7_26_5 21003.333248037805
R7572 n_7_25_5 n_7_25_6 6.045903598158354
R7573 n_7_25_6 n_8_25_6 139.63536114736462
R7574 n_7_25_6 n_7_26_6 3500.5555413396346
R7575 n_7_25_6 n_7_25_7 8.205154883214899
R7576 n_7_25_7 n_8_25_7 239.3749048240544
R7577 n_7_25_7 n_7_26_7 6000.952356582249
R7578 n_7_25_7 n_7_25_8 6.0459035981583344
R7579 n_7_25_8 n_8_25_8 239.3749048240544
R7580 n_7_25_8 n_7_26_8 6000.952356582249
R7581 n_7_25_8 n_7_25_9 6.0459035981583344
R7582 n_7_25_9 n_8_25_9 239.3749048240544
R7583 n_7_25_9 n_7_26_9 6000.952356582249
R7584 n_7_25_9 n_7_25_10 6.0459035981583344
R7585 n_7_25_10 n_8_25_10 239.3749048240544
R7586 n_7_25_10 n_7_26_10 6000.952356582249
R7587 n_7_25_10 n_7_25_11 6.045903598158295
R7588 n_7_25_11 n_8_25_11 239.37490482405744
R7589 n_7_25_11 n_7_26_11 6000.952356582326
R7590 n_7_25_11 n_7_25_12 6.045903598158276
R7591 n_7_25_12 n_8_25_12 239.37490482405585
R7592 n_7_25_12 n_7_26_12 6000.952356582287
R7593 n_7_25_12 n_7_25_13 6.0459035981583344
R7594 n_7_25_13 n_8_25_13 239.3749048240529
R7595 n_7_25_13 n_7_26_13 6000.95235658221
R7596 n_7_25_13 n_7_25_14 30.22951799079175
R7597 n_7_25_14 n_8_25_14 26.597211647117092
R7598 n_7_25_14 n_7_26_14 666.772484064693
R7599 n_7_25_14 n_7_25_15 934.0921059154737
R7600 n_7_25_15 n_8_25_15 8797.027752283893
R7601 n_7_25_15 n_7_26_15 220534.99910439496
R7602 n_7_26_0 n_8_26_0 125.67182503262788
R7603 n_7_26_0 n_7_27_0 3150.4999872056787
R7604 n_7_26_0 n_7_26_1 748.1805702720933
R7605 n_7_26_1 n_8_26_1 175.940555045679
R7606 n_7_26_1 n_7_27_1 4410.69998208795
R7607 n_7_26_1 n_7_26_2 1700.4103869820299
R7608 n_7_26_2 n_8_26_2 314.1795625815697
R7609 n_7_26_2 n_7_27_2 7876.249968014196
R7610 n_7_26_2 n_7_26_3 1591.58412221518
R7611 n_7_26_3 n_8_26_3 4398.513876141971
R7612 n_7_26_3 n_7_27_3 110267.49955219866
R7613 n_7_26_3 n_7_26_4 21.16066259355417
R7614 n_7_26_4 n_8_26_4 133.28829927702944
R7615 n_7_26_4 n_7_27_4 3341.4393803696557
R7616 n_7_26_4 n_7_26_5 17.48993540895804
R7617 n_7_26_5 n_8_26_5 837.8121668841851
R7618 n_7_26_5 n_7_27_5 21003.333248037838
R7619 n_7_26_5 n_7_26_6 6.045903598158334
R7620 n_7_26_6 n_8_26_6 139.63536114736416
R7621 n_7_26_6 n_7_27_6 3500.55554133964
R7622 n_7_26_6 n_7_26_7 8.205154883214872
R7623 n_7_26_7 n_8_26_7 239.3749048240536
R7624 n_7_26_7 n_7_27_7 6000.952356582258
R7625 n_7_26_7 n_7_26_8 6.045903598158315
R7626 n_7_26_8 n_8_26_8 239.3749048240536
R7627 n_7_26_8 n_7_27_8 6000.952356582258
R7628 n_7_26_8 n_7_26_9 6.045903598158315
R7629 n_7_26_9 n_8_26_9 239.3749048240536
R7630 n_7_26_9 n_7_27_9 6000.952356582258
R7631 n_7_26_9 n_7_26_10 6.045903598158315
R7632 n_7_26_10 n_8_26_10 239.3749048240536
R7633 n_7_26_10 n_7_27_10 6000.952356582258
R7634 n_7_26_10 n_7_26_11 6.045903598158276
R7635 n_7_26_11 n_8_26_11 239.37490482405667
R7636 n_7_26_11 n_7_27_11 6000.952356582335
R7637 n_7_26_11 n_7_26_12 6.045903598158256
R7638 n_7_26_12 n_8_26_12 239.37490482405514
R7639 n_7_26_12 n_7_27_12 6000.952356582297
R7640 n_7_26_12 n_7_26_13 6.045903598158315
R7641 n_7_26_13 n_8_26_13 239.3749048240521
R7642 n_7_26_13 n_7_27_13 6000.952356582219
R7643 n_7_26_13 n_7_26_14 30.22951799079165
R7644 n_7_26_14 n_8_26_14 26.59721164711701
R7645 n_7_26_14 n_7_27_14 666.772484064694
R7646 n_7_26_14 n_7_26_15 934.0921059154706
R7647 n_7_26_15 n_8_26_15 8797.027752283864
R7648 n_7_26_15 n_7_27_15 220534.9991043953
R7649 n_7_27_0 n_8_27_0 125.67182503262788
R7650 n_7_27_0 n_7_27_1 748.1805702720933
R7651 n_7_27_1 n_8_27_1 175.940555045679
R7652 n_7_27_1 n_7_27_2 1700.4103869820299
R7653 n_7_27_2 n_8_27_2 314.1795625815697
R7654 n_7_27_2 n_7_27_3 1591.58412221518
R7655 n_7_27_3 n_8_27_3 4398.513876141971
R7656 n_7_27_3 n_7_27_4 21.16066259355417
R7657 n_7_27_4 n_8_27_4 133.28829927702944
R7658 n_7_27_4 n_7_27_5 17.48993540895804
R7659 n_7_27_5 n_8_27_5 837.8121668841851
R7660 n_7_27_5 n_7_27_6 6.045903598158334
R7661 n_7_27_6 n_8_27_6 139.63536114736416
R7662 n_7_27_6 n_7_27_7 8.205154883214872
R7663 n_7_27_7 n_8_27_7 239.3749048240536
R7664 n_7_27_7 n_7_27_8 6.045903598158315
R7665 n_7_27_8 n_8_27_8 239.3749048240536
R7666 n_7_27_8 n_7_27_9 6.045903598158315
R7667 n_7_27_9 n_8_27_9 239.3749048240536
R7668 n_7_27_9 n_7_27_10 6.045903598158315
R7669 n_7_27_10 n_8_27_10 239.3749048240536
R7670 n_7_27_10 n_7_27_11 6.045903598158276
R7671 n_7_27_11 n_8_27_11 239.37490482405667
R7672 n_7_27_11 n_7_27_12 6.045903598158256
R7673 n_7_27_12 n_8_27_12 239.37490482405514
R7674 n_7_27_12 n_7_27_13 6.045903598158315
R7675 n_7_27_13 n_8_27_13 239.3749048240521
R7676 n_7_27_13 n_7_27_14 30.22951799079165
R7677 n_7_27_14 n_8_27_14 26.59721164711701
R7678 n_7_27_14 n_7_27_15 934.0921059154706
R7679 n_7_27_15 n_8_27_15 8797.027752283864
R7680 n_8_0_0 n_9_0_0 244.86587517703646
R7681 n_8_0_0 n_8_1_0 83.3442522382964
R7682 n_8_0_0 n_8_0_1 19.792585202828388
R7683 n_8_0_1 n_9_0_1 342.81222524785096
R7684 n_8_0_1 n_8_1_1 116.68195313361497
R7685 n_8_0_1 n_8_0_2 44.98314818824633
R7686 n_8_0_2 n_9_0_2 612.1646879425912
R7687 n_8_0_2 n_8_1_2 208.36063059574101
R7688 n_8_0_2 n_8_0_3 42.10422670419857
R7689 n_8_0_3 n_9_0_3 8570.305631196266
R7690 n_8_0_3 n_8_1_3 2917.0488283403706
R7691 n_8_0_3 n_8_0_4 0.5597902885648438
R7692 n_8_0_4 n_9_0_4 259.70623124837175
R7693 n_8_0_4 n_8_1_4 88.3954190406173
R7694 n_8_0_4 n_8_0_5 0.46268380993624847
R7695 n_8_0_5 n_9_0_5 1632.4391678469078
R7696 n_8_0_5 n_8_1_5 555.6283482553088
R7697 n_8_0_5 n_8_0_6 0.1599400824470982
R7698 n_8_0_6 n_9_0_6 272.07319464115136
R7699 n_8_0_6 n_8_1_6 92.60472470921815
R7700 n_8_0_6 n_8_0_7 0.21706154046391873
R7701 n_8_0_7 n_9_0_7 466.4111908134038
R7702 n_8_0_7 n_8_1_7 158.75095664437444
R7703 n_8_0_7 n_8_0_8 0.1599400824470977
R7704 n_8_0_8 n_9_0_8 466.4111908134038
R7705 n_8_0_8 n_8_1_8 158.75095664437444
R7706 n_8_0_8 n_8_0_9 0.1599400824470977
R7707 n_8_0_9 n_9_0_9 466.4111908134038
R7708 n_8_0_9 n_8_1_9 158.75095664437444
R7709 n_8_0_9 n_8_0_10 0.1599400824470977
R7710 n_8_0_10 n_9_0_10 466.4111908134038
R7711 n_8_0_10 n_8_1_10 158.75095664437444
R7712 n_8_0_10 n_8_0_11 0.15994008244709668
R7713 n_8_0_11 n_9_0_11 466.4111908134097
R7714 n_8_0_11 n_8_1_11 158.75095664437646
R7715 n_8_0_11 n_8_0_12 0.15994008244709618
R7716 n_8_0_12 n_9_0_12 466.41119081340685
R7717 n_8_0_12 n_8_1_12 158.75095664437546
R7718 n_8_0_12 n_8_0_13 0.15994008244709768
R7719 n_8_0_13 n_9_0_13 466.4111908134008
R7720 n_8_0_13 n_8_1_13 158.75095664437345
R7721 n_8_0_13 n_8_0_14 0.7997004122354905
R7722 n_8_0_14 n_9_0_14 51.82346564593364
R7723 n_8_0_14 n_8_1_14 17.638995182708236
R7724 n_8_0_14 n_8_0_15 24.710742738076885
R7725 n_8_0_15 n_9_0_15 17140.611262392384
R7726 n_8_0_15 n_8_1_15 5834.097656680691
R7727 n_8_1_0 n_9_1_0 244.86587517703646
R7728 n_8_1_0 n_8_2_0 83.3442522382964
R7729 n_8_1_0 n_8_1_1 19.792585202828388
R7730 n_8_1_1 n_9_1_1 342.81222524785096
R7731 n_8_1_1 n_8_2_1 116.68195313361497
R7732 n_8_1_1 n_8_1_2 44.98314818824633
R7733 n_8_1_2 n_9_1_2 612.1646879425912
R7734 n_8_1_2 n_8_2_2 208.36063059574101
R7735 n_8_1_2 n_8_1_3 42.10422670419857
R7736 n_8_1_3 n_9_1_3 8570.305631196266
R7737 n_8_1_3 n_8_2_3 2917.0488283403706
R7738 n_8_1_3 n_8_1_4 0.5597902885648438
R7739 n_8_1_4 n_9_1_4 259.70623124837175
R7740 n_8_1_4 n_8_2_4 88.3954190406173
R7741 n_8_1_4 n_8_1_5 0.46268380993624847
R7742 n_8_1_5 n_9_1_5 1632.4391678469078
R7743 n_8_1_5 n_8_2_5 555.6283482553088
R7744 n_8_1_5 n_8_1_6 0.1599400824470982
R7745 n_8_1_6 n_9_1_6 272.07319464115136
R7746 n_8_1_6 n_8_2_6 92.60472470921815
R7747 n_8_1_6 n_8_1_7 0.21706154046391873
R7748 n_8_1_7 n_9_1_7 466.4111908134038
R7749 n_8_1_7 n_8_2_7 158.75095664437444
R7750 n_8_1_7 n_8_1_8 0.1599400824470977
R7751 n_8_1_8 n_9_1_8 466.4111908134038
R7752 n_8_1_8 n_8_2_8 158.75095664437444
R7753 n_8_1_8 n_8_1_9 0.1599400824470977
R7754 n_8_1_9 n_9_1_9 466.4111908134038
R7755 n_8_1_9 n_8_2_9 158.75095664437444
R7756 n_8_1_9 n_8_1_10 0.1599400824470977
R7757 n_8_1_10 n_9_1_10 466.4111908134038
R7758 n_8_1_10 n_8_2_10 158.75095664437444
R7759 n_8_1_10 n_8_1_11 0.15994008244709668
R7760 n_8_1_11 n_9_1_11 466.4111908134097
R7761 n_8_1_11 n_8_2_11 158.75095664437646
R7762 n_8_1_11 n_8_1_12 0.15994008244709618
R7763 n_8_1_12 n_9_1_12 466.41119081340685
R7764 n_8_1_12 n_8_2_12 158.75095664437546
R7765 n_8_1_12 n_8_1_13 0.15994008244709768
R7766 n_8_1_13 n_9_1_13 466.4111908134008
R7767 n_8_1_13 n_8_2_13 158.75095664437345
R7768 n_8_1_13 n_8_1_14 0.7997004122354905
R7769 n_8_1_14 n_9_1_14 51.82346564593364
R7770 n_8_1_14 n_8_2_14 17.638995182708236
R7771 n_8_1_14 n_8_1_15 24.710742738076885
R7772 n_8_1_15 n_9_1_15 17140.611262392384
R7773 n_8_1_15 n_8_2_15 5834.097656680691
R7774 n_8_2_0 n_9_2_0 244.86587517703646
R7775 n_8_2_0 n_8_3_0 83.3442522382964
R7776 n_8_2_0 n_8_2_1 19.792585202828388
R7777 n_8_2_1 n_9_2_1 342.81222524785096
R7778 n_8_2_1 n_8_3_1 116.68195313361497
R7779 n_8_2_1 n_8_2_2 44.98314818824633
R7780 n_8_2_2 n_9_2_2 612.1646879425912
R7781 n_8_2_2 n_8_3_2 208.36063059574101
R7782 n_8_2_2 n_8_2_3 42.10422670419857
R7783 n_8_2_3 n_9_2_3 8570.305631196266
R7784 n_8_2_3 n_8_3_3 2917.0488283403706
R7785 n_8_2_3 n_8_2_4 0.5597902885648438
R7786 n_8_2_4 n_9_2_4 259.70623124837175
R7787 n_8_2_4 n_8_3_4 88.3954190406173
R7788 n_8_2_4 n_8_2_5 0.46268380993624847
R7789 n_8_2_5 n_9_2_5 1632.4391678469078
R7790 n_8_2_5 n_8_3_5 555.6283482553088
R7791 n_8_2_5 n_8_2_6 0.1599400824470982
R7792 n_8_2_6 n_9_2_6 272.07319464115136
R7793 n_8_2_6 n_8_3_6 92.60472470921815
R7794 n_8_2_6 n_8_2_7 0.21706154046391873
R7795 n_8_2_7 n_9_2_7 466.4111908134038
R7796 n_8_2_7 n_8_3_7 158.75095664437444
R7797 n_8_2_7 n_8_2_8 0.1599400824470977
R7798 n_8_2_8 n_9_2_8 466.4111908134038
R7799 n_8_2_8 n_8_3_8 158.75095664437444
R7800 n_8_2_8 n_8_2_9 0.1599400824470977
R7801 n_8_2_9 n_9_2_9 466.4111908134038
R7802 n_8_2_9 n_8_3_9 158.75095664437444
R7803 n_8_2_9 n_8_2_10 0.1599400824470977
R7804 n_8_2_10 n_9_2_10 466.4111908134038
R7805 n_8_2_10 n_8_3_10 158.75095664437444
R7806 n_8_2_10 n_8_2_11 0.15994008244709668
R7807 n_8_2_11 n_9_2_11 466.4111908134097
R7808 n_8_2_11 n_8_3_11 158.75095664437646
R7809 n_8_2_11 n_8_2_12 0.15994008244709618
R7810 n_8_2_12 n_9_2_12 466.41119081340685
R7811 n_8_2_12 n_8_3_12 158.75095664437546
R7812 n_8_2_12 n_8_2_13 0.15994008244709768
R7813 n_8_2_13 n_9_2_13 466.4111908134008
R7814 n_8_2_13 n_8_3_13 158.75095664437345
R7815 n_8_2_13 n_8_2_14 0.7997004122354905
R7816 n_8_2_14 n_9_2_14 51.82346564593364
R7817 n_8_2_14 n_8_3_14 17.638995182708236
R7818 n_8_2_14 n_8_2_15 24.710742738076885
R7819 n_8_2_15 n_9_2_15 17140.611262392384
R7820 n_8_2_15 n_8_3_15 5834.097656680691
R7821 n_8_3_0 n_9_3_0 244.86587517703646
R7822 n_8_3_0 n_8_4_0 43.56171513435993
R7823 n_8_3_0 n_8_3_1 19.792585202828388
R7824 n_8_3_1 n_9_3_1 342.81222524785096
R7825 n_8_3_1 n_8_4_1 60.9864011881039
R7826 n_8_3_1 n_8_3_2 44.98314818824633
R7827 n_8_3_2 n_9_3_2 612.1646879425912
R7828 n_8_3_2 n_8_4_2 108.90428783589982
R7829 n_8_3_2 n_8_3_3 42.10422670419857
R7830 n_8_3_3 n_9_3_3 8570.305631196266
R7831 n_8_3_3 n_8_4_3 1524.6600297025957
R7832 n_8_3_3 n_8_3_4 0.5597902885648438
R7833 n_8_3_4 n_9_3_4 259.70623124837175
R7834 n_8_3_4 n_8_4_4 46.20181908189684
R7835 n_8_3_4 n_8_3_5 0.46268380993624847
R7836 n_8_3_5 n_9_3_5 1632.4391678469078
R7837 n_8_3_5 n_8_3_6 0.1599400824470982
R7838 n_8_3_6 n_9_3_6 272.07319464115136
R7839 n_8_3_6 n_8_3_7 0.21706154046391873
R7840 n_8_3_7 n_9_3_7 466.4111908134038
R7841 n_8_3_7 n_8_3_8 0.1599400824470977
R7842 n_8_3_8 n_9_3_8 466.4111908134038
R7843 n_8_3_8 n_8_3_9 0.1599400824470977
R7844 n_8_3_9 n_9_3_9 466.4111908134038
R7845 n_8_3_9 n_8_3_10 0.1599400824470977
R7846 n_8_3_10 n_9_3_10 466.4111908134038
R7847 n_8_3_10 n_8_3_11 0.15994008244709668
R7848 n_8_3_11 n_9_3_11 466.4111908134097
R7849 n_8_3_11 n_8_3_12 0.15994008244709618
R7850 n_8_3_12 n_9_3_12 466.41119081340685
R7851 n_8_3_12 n_8_3_13 0.15994008244709768
R7852 n_8_3_13 n_9_3_13 466.4111908134008
R7853 n_8_3_13 n_8_3_14 0.7997004122354905
R7854 n_8_3_14 n_9_3_14 51.82346564593364
R7855 n_8_3_14 n_8_3_15 24.710742738076885
R7856 n_8_3_15 n_9_3_15 17140.611262392384
R7857 n_8_3_15 n_8_4_15 3049.320059405165
R7858 n_8_4_0 n_9_4_0 5400.15926770706
R7859 n_8_4_0 n_8_5_0 3.7791780304234868
R7860 n_8_4_0 n_8_4_1 436.4965609751033
R7861 n_8_4_1 n_9_4_1 7560.222974789884
R7862 n_8_4_1 n_8_5_1 5.2908492425928815
R7863 n_8_4_1 n_8_4_2 992.0376385797803
R7864 n_8_4_2 n_9_4_2 13500.39816926765
R7865 n_8_4_2 n_8_5_2 9.447945076058717
R7866 n_8_4_2 n_8_4_3 928.5472297106744
R7867 n_8_4_3 n_9_4_3 189005.57436974696
R7868 n_8_4_3 n_8_5_3 132.2712310648219
R7869 n_8_4_3 n_8_4_4 12.345357280103944
R7870 n_8_4_4 n_9_4_4 5727.44164756809
R7871 n_8_4_4 n_8_5_4 4.0082191231764215
R7872 n_8_4_15 n_9_4_15 378011.14873949054
R7873 n_8_4_15 n_8_5_15 264.5424621296415
R7874 n_8_5_0 n_9_5_0 5400.159267706966
R7875 n_8_5_0 n_8_6_0 3.7791780304235205
R7876 n_8_5_0 n_8_5_1 436.4965609750956
R7877 n_8_5_1 n_9_5_1 7560.222974789749
R7878 n_8_5_1 n_8_6_1 5.2908492425929285
R7879 n_8_5_1 n_8_5_2 992.0376385797626
R7880 n_8_5_2 n_9_5_2 13500.39816926741
R7881 n_8_5_2 n_8_6_2 9.4479450760588
R7882 n_8_5_2 n_8_5_3 928.5472297106578
R7883 n_8_5_3 n_9_5_3 189005.57436974358
R7884 n_8_5_3 n_8_6_3 132.27123106482307
R7885 n_8_5_3 n_8_5_4 12.345357280103725
R7886 n_8_5_4 n_9_5_4 5727.441647567988
R7887 n_8_5_4 n_8_6_4 4.008219123176457
R7888 n_8_5_15 n_9_5_15 378011.1487394838
R7889 n_8_5_15 n_8_6_15 264.5424621296438
R7890 n_8_6_0 n_9_6_0 5400.159267706966
R7891 n_8_6_0 n_8_7_0 3.7791780304234868
R7892 n_8_6_0 n_8_6_1 436.4965609750956
R7893 n_8_6_1 n_9_6_1 7560.222974789749
R7894 n_8_6_1 n_8_7_1 5.2908492425928815
R7895 n_8_6_1 n_8_6_2 992.0376385797626
R7896 n_8_6_2 n_9_6_2 13500.39816926741
R7897 n_8_6_2 n_8_7_2 9.447945076058717
R7898 n_8_6_2 n_8_6_3 928.5472297106578
R7899 n_8_6_3 n_9_6_3 189005.57436974358
R7900 n_8_6_3 n_8_7_3 132.2712310648219
R7901 n_8_6_3 n_8_6_4 12.345357280103725
R7902 n_8_6_4 n_9_6_4 5727.441647567988
R7903 n_8_6_4 n_8_7_4 4.0082191231764215
R7904 n_8_6_15 n_9_6_15 378011.1487394838
R7905 n_8_6_15 n_8_7_15 264.5424621296415
R7906 n_8_7_0 n_9_7_0 5400.15926770706
R7907 n_8_7_0 n_8_8_0 110.44365037393553
R7908 n_8_7_0 n_8_7_1 436.4965609751033
R7909 n_8_7_1 n_9_7_1 7560.222974789884
R7910 n_8_7_1 n_8_8_1 154.62111052350974
R7911 n_8_7_1 n_8_7_2 992.0376385797803
R7912 n_8_7_2 n_9_7_2 13500.39816926765
R7913 n_8_7_2 n_8_8_2 276.10912593483886
R7914 n_8_7_2 n_8_7_3 928.5472297106744
R7915 n_8_7_3 n_9_7_3 189005.57436974696
R7916 n_8_7_3 n_8_8_3 3865.527763087739
R7917 n_8_7_3 n_8_7_4 12.345357280103944
R7918 n_8_7_4 n_9_7_4 5727.44164756809
R7919 n_8_7_4 n_8_8_4 117.13720494205272
R7920 n_8_7_15 n_9_7_15 378011.14873949054
R7921 n_8_7_15 n_8_8_15 7731.055526175411
R7922 n_8_8_0 n_9_8_0 93.99999875576307
R7923 n_8_8_0 n_8_9_0 217.10812271744766
R7924 n_8_8_0 n_8_8_1 7.598049271235
R7925 n_8_8_1 n_9_8_1 131.59999825806827
R7926 n_8_8_1 n_8_9_1 303.95137180442674
R7927 n_8_8_1 n_8_8_2 17.26829379826136
R7928 n_8_8_2 n_9_8_2 234.9999968894076
R7929 n_8_8_2 n_8_9_2 542.7703067936193
R7930 n_8_8_2 n_8_8_3 16.163122995172635
R7931 n_8_8_3 n_9_8_3 3289.999956451704
R7932 n_8_8_3 n_8_9_3 7598.7842951106595
R7933 n_8_8_3 n_8_8_4 0.21489432282280826
R7934 n_8_8_4 n_9_8_4 99.69696837732437
R7935 n_8_8_4 n_8_9_4 230.2661907609291
R7936 n_8_8_4 n_8_8_5 0.21489432282280826
R7937 n_8_8_5 n_9_8_5 3289.999956451704
R7938 n_8_8_5 n_8_9_5 7598.7842951106595
R7939 n_8_8_5 n_8_8_6 0.41443905115827306
R7940 n_8_8_6 n_9_8_6 731.1111014337118
R7941 n_8_8_6 n_8_9_6 1688.6187322468136
R7942 n_8_8_6 n_8_8_7 0.5832845905190503
R7943 n_8_8_7 n_9_8_7 1253.3333167435103
R7944 n_8_8_7 n_8_9_7 2894.7749695659754
R7945 n_8_8_7 n_8_8_8 0.4297886456456152
R7946 n_8_8_8 n_9_8_8 1253.3333167435103
R7947 n_8_8_8 n_8_9_8 2894.7749695659754
R7948 n_8_8_8 n_8_8_9 0.4297886456456152
R7949 n_8_8_9 n_9_8_9 1253.3333167435103
R7950 n_8_8_9 n_8_9_9 2894.7749695659754
R7951 n_8_8_9 n_8_8_10 0.4297886456456152
R7952 n_8_8_10 n_9_8_10 1253.3333167435103
R7953 n_8_8_10 n_8_9_10 2894.7749695659754
R7954 n_8_8_10 n_8_8_11 0.4297886456456125
R7955 n_8_8_11 n_9_8_11 1253.3333167435262
R7956 n_8_8_11 n_8_9_11 2894.774969566012
R7957 n_8_8_11 n_8_8_12 0.42978864564561103
R7958 n_8_8_12 n_9_8_12 1253.333316743518
R7959 n_8_8_12 n_8_9_12 2894.774969565993
R7960 n_8_8_12 n_8_8_13 0.42978864564561514
R7961 n_8_8_13 n_9_8_13 1253.3333167435023
R7962 n_8_8_13 n_8_9_13 2894.7749695659577
R7963 n_8_8_13 n_8_8_14 2.1489432282280814
R7964 n_8_8_14 n_9_8_14 139.25925741594529
R7965 n_8_8_14 n_8_9_14 321.6416632851077
R7966 n_8_8_14 n_8_8_15 11.143805597811422
R7967 n_8_8_15 n_9_8_15 6579.9999129033495
R7968 n_8_8_15 n_8_9_15 15197.568590221188
R7969 n_8_9_0 n_9_9_0 93.99999875576299
R7970 n_8_9_0 n_8_10_0 217.10812271744766
R7971 n_8_9_0 n_8_9_1 7.598049271234997
R7972 n_8_9_1 n_9_9_1 131.59999825806818
R7973 n_8_9_1 n_8_10_1 303.95137180442674
R7974 n_8_9_1 n_8_9_2 17.268293798261354
R7975 n_8_9_2 n_9_9_2 234.9999968894075
R7976 n_8_9_2 n_8_10_2 542.7703067936193
R7977 n_8_9_2 n_8_9_3 16.16312299517263
R7978 n_8_9_3 n_9_9_3 3289.999956451702
R7979 n_8_9_3 n_8_10_3 7598.7842951106595
R7980 n_8_9_3 n_8_9_4 0.21489432282280818
R7981 n_8_9_4 n_9_9_4 99.69696837732431
R7982 n_8_9_4 n_8_10_4 230.2661907609291
R7983 n_8_9_4 n_8_9_5 0.21489432282280818
R7984 n_8_9_5 n_9_9_5 3289.999956451702
R7985 n_8_9_5 n_8_10_5 7598.7842951106595
R7986 n_8_9_5 n_8_9_6 0.41443905115827295
R7987 n_8_9_6 n_9_9_6 731.1111014337114
R7988 n_8_9_6 n_8_10_6 1688.6187322468136
R7989 n_8_9_6 n_8_9_7 0.5832845905190501
R7990 n_8_9_7 n_9_9_7 1253.3333167435092
R7991 n_8_9_7 n_8_10_7 2894.7749695659754
R7992 n_8_9_7 n_8_9_8 0.42978864564561503
R7993 n_8_9_8 n_9_9_8 1253.3333167435092
R7994 n_8_9_8 n_8_10_8 2894.7749695659754
R7995 n_8_9_8 n_8_9_9 0.42978864564561503
R7996 n_8_9_9 n_9_9_9 1253.3333167435092
R7997 n_8_9_9 n_8_10_9 2894.7749695659754
R7998 n_8_9_9 n_8_9_10 0.42978864564561503
R7999 n_8_9_10 n_9_9_10 1253.3333167435092
R8000 n_8_9_10 n_8_10_10 2894.7749695659754
R8001 n_8_9_10 n_8_9_11 0.42978864564561226
R8002 n_8_9_11 n_9_9_11 1253.3333167435253
R8003 n_8_9_11 n_8_10_11 2894.774969566012
R8004 n_8_9_11 n_8_9_12 0.4297886456456109
R8005 n_8_9_12 n_9_9_12 1253.3333167435176
R8006 n_8_9_12 n_8_10_12 2894.774969565993
R8007 n_8_9_12 n_8_9_13 0.42978864564561503
R8008 n_8_9_13 n_9_9_13 1253.3333167435012
R8009 n_8_9_13 n_8_10_13 2894.7749695659577
R8010 n_8_9_13 n_8_9_14 2.1489432282280805
R8011 n_8_9_14 n_9_9_14 139.25925741594517
R8012 n_8_9_14 n_8_10_14 321.6416632851077
R8013 n_8_9_14 n_8_9_15 11.143805597811417
R8014 n_8_9_15 n_9_9_15 6579.999912903346
R8015 n_8_9_15 n_8_10_15 15197.568590221188
R8016 n_8_10_0 n_9_10_0 93.99999875576307
R8017 n_8_10_0 n_8_11_0 217.1081227174476
R8018 n_8_10_0 n_8_10_1 7.598049271235
R8019 n_8_10_1 n_9_10_1 131.59999825806827
R8020 n_8_10_1 n_8_11_1 303.9513718044266
R8021 n_8_10_1 n_8_10_2 17.26829379826136
R8022 n_8_10_2 n_9_10_2 234.9999968894076
R8023 n_8_10_2 n_8_11_2 542.770306793619
R8024 n_8_10_2 n_8_10_3 16.163122995172635
R8025 n_8_10_3 n_9_10_3 3289.999956451704
R8026 n_8_10_3 n_8_11_3 7598.784295110658
R8027 n_8_10_3 n_8_10_4 0.21489432282280826
R8028 n_8_10_4 n_9_10_4 99.69696837732437
R8029 n_8_10_4 n_8_11_4 230.26619076092905
R8030 n_8_10_4 n_8_10_5 0.21489432282280826
R8031 n_8_10_5 n_9_10_5 3289.999956451704
R8032 n_8_10_5 n_8_11_5 7598.784295110658
R8033 n_8_10_5 n_8_10_6 0.41443905115827306
R8034 n_8_10_6 n_9_10_6 731.1111014337118
R8035 n_8_10_6 n_8_11_6 1688.6187322468131
R8036 n_8_10_6 n_8_10_7 0.5832845905190503
R8037 n_8_10_7 n_9_10_7 1253.3333167435103
R8038 n_8_10_7 n_8_11_7 2894.7749695659745
R8039 n_8_10_7 n_8_10_8 0.4297886456456152
R8040 n_8_10_8 n_9_10_8 1253.3333167435103
R8041 n_8_10_8 n_8_11_8 2894.7749695659745
R8042 n_8_10_8 n_8_10_9 0.4297886456456152
R8043 n_8_10_9 n_9_10_9 1253.3333167435103
R8044 n_8_10_9 n_8_11_9 2894.7749695659745
R8045 n_8_10_9 n_8_10_10 0.4297886456456152
R8046 n_8_10_10 n_9_10_10 1253.3333167435103
R8047 n_8_10_10 n_8_11_10 2894.7749695659745
R8048 n_8_10_10 n_8_10_11 0.4297886456456125
R8049 n_8_10_11 n_9_10_11 1253.3333167435262
R8050 n_8_10_11 n_8_11_11 2894.774969566011
R8051 n_8_10_11 n_8_10_12 0.42978864564561103
R8052 n_8_10_12 n_9_10_12 1253.333316743518
R8053 n_8_10_12 n_8_11_12 2894.7749695659923
R8054 n_8_10_12 n_8_10_13 0.42978864564561514
R8055 n_8_10_13 n_9_10_13 1253.3333167435023
R8056 n_8_10_13 n_8_11_13 2894.774969565957
R8057 n_8_10_13 n_8_10_14 2.1489432282280814
R8058 n_8_10_14 n_9_10_14 139.25925741594529
R8059 n_8_10_14 n_8_11_14 321.6416632851076
R8060 n_8_10_14 n_8_10_15 11.143805597811422
R8061 n_8_10_15 n_9_10_15 6579.9999129033495
R8062 n_8_10_15 n_8_11_15 15197.568590221183
R8063 n_8_11_0 n_9_11_0 93.99999875576307
R8064 n_8_11_0 n_8_12_0 110.44365361735527
R8065 n_8_11_0 n_8_11_1 7.598049271235
R8066 n_8_11_1 n_9_11_1 131.59999825806827
R8067 n_8_11_1 n_8_12_1 154.62111506429738
R8068 n_8_11_1 n_8_11_2 17.26829379826136
R8069 n_8_11_2 n_9_11_2 234.9999968894076
R8070 n_8_11_2 n_8_12_2 276.1091340433882
R8071 n_8_11_2 n_8_11_3 16.163122995172635
R8072 n_8_11_3 n_9_11_3 3289.999956451704
R8073 n_8_11_3 n_8_12_3 3865.5278766074302
R8074 n_8_11_3 n_8_11_4 0.21489432282280826
R8075 n_8_11_4 n_9_11_4 99.69696837732437
R8076 n_8_11_4 n_8_12_4 117.13720838204335
R8077 n_8_11_4 n_8_11_5 0.21489432282280826
R8078 n_8_11_5 n_9_11_5 3289.999956451704
R8079 n_8_11_5 n_8_11_6 0.41443905115827306
R8080 n_8_11_6 n_9_11_6 731.1111014337118
R8081 n_8_11_6 n_8_11_7 0.5832845905190503
R8082 n_8_11_7 n_9_11_7 1253.3333167435103
R8083 n_8_11_7 n_8_11_8 0.4297886456456152
R8084 n_8_11_8 n_9_11_8 1253.3333167435103
R8085 n_8_11_8 n_8_11_9 0.4297886456456152
R8086 n_8_11_9 n_9_11_9 1253.3333167435103
R8087 n_8_11_9 n_8_11_10 0.4297886456456152
R8088 n_8_11_10 n_9_11_10 1253.3333167435103
R8089 n_8_11_10 n_8_11_11 0.4297886456456125
R8090 n_8_11_11 n_9_11_11 1253.3333167435262
R8091 n_8_11_11 n_8_11_12 0.42978864564561103
R8092 n_8_11_12 n_9_11_12 1253.333316743518
R8093 n_8_11_12 n_8_11_13 0.42978864564561514
R8094 n_8_11_13 n_9_11_13 1253.3333167435023
R8095 n_8_11_13 n_8_11_14 2.1489432282280814
R8096 n_8_11_14 n_9_11_14 139.25925741594529
R8097 n_8_11_14 n_8_11_15 11.143805597811422
R8098 n_8_11_15 n_9_11_15 6579.9999129033495
R8099 n_8_11_15 n_8_12_15 7731.055753214793
R8100 n_8_12_0 n_9_12_0 5400.149998520494
R8101 n_8_12_0 n_8_13_0 3.7791845172629377
R8102 n_8_12_0 n_8_12_1 436.49581174385685
R8103 n_8_12_1 n_9_12_1 7560.20999792869
R8104 n_8_12_1 n_8_13_1 5.290858324168113
R8105 n_8_12_1 n_8_12_2 992.0359357814928
R8106 n_8_12_2 n_9_12_2 13500.374996301234
R8107 n_8_12_2 n_8_13_2 9.447961293157345
R8108 n_8_12_2 n_8_12_3 928.5456358914772
R8109 n_8_12_3 n_9_12_3 189005.24994821713
R8110 n_8_12_3 n_8_13_3 132.27145810420268
R8111 n_8_12_3 n_8_12_4 12.345336089725256
R8112 n_8_12_4 n_9_12_4 5727.4318166126395
R8113 n_8_12_4 n_8_13_4 4.008226003157657
R8114 n_8_12_15 n_9_12_15 378010.4998964309
R8115 n_8_12_15 n_8_13_15 264.542916208403
R8116 n_8_13_0 n_9_13_0 5400.149998520494
R8117 n_8_13_0 n_8_14_0 3.7791845172629377
R8118 n_8_13_0 n_8_13_1 436.49581174385685
R8119 n_8_13_1 n_9_13_1 7560.20999792869
R8120 n_8_13_1 n_8_14_1 5.290858324168113
R8121 n_8_13_1 n_8_13_2 992.0359357814928
R8122 n_8_13_2 n_9_13_2 13500.374996301234
R8123 n_8_13_2 n_8_14_2 9.447961293157345
R8124 n_8_13_2 n_8_13_3 928.5456358914772
R8125 n_8_13_3 n_9_13_3 189005.24994821713
R8126 n_8_13_3 n_8_14_3 132.27145810420268
R8127 n_8_13_3 n_8_13_4 12.345336089725256
R8128 n_8_13_4 n_9_13_4 5727.4318166126395
R8129 n_8_13_4 n_8_14_4 4.008226003157657
R8130 n_8_13_15 n_9_13_15 378010.4998964309
R8131 n_8_13_15 n_8_14_15 264.542916208403
R8132 n_8_14_0 n_9_14_0 5400.149998520494
R8133 n_8_14_0 n_8_15_0 3.7791845172629377
R8134 n_8_14_0 n_8_14_1 436.49581174385685
R8135 n_8_14_1 n_9_14_1 7560.20999792869
R8136 n_8_14_1 n_8_15_1 5.290858324168113
R8137 n_8_14_1 n_8_14_2 992.0359357814928
R8138 n_8_14_2 n_9_14_2 13500.374996301234
R8139 n_8_14_2 n_8_15_2 9.447961293157345
R8140 n_8_14_2 n_8_14_3 928.5456358914772
R8141 n_8_14_3 n_9_14_3 189005.24994821713
R8142 n_8_14_3 n_8_15_3 132.27145810420268
R8143 n_8_14_3 n_8_14_4 12.345336089725256
R8144 n_8_14_4 n_9_14_4 5727.4318166126395
R8145 n_8_14_4 n_8_15_4 4.008226003157657
R8146 n_8_14_15 n_9_14_15 378010.4998964309
R8147 n_8_14_15 n_8_15_15 264.542916208403
R8148 n_8_15_0 n_9_15_0 5400.149998520494
R8149 n_8_15_0 n_8_16_0 110.44365361735521
R8150 n_8_15_0 n_8_15_1 436.49581174385685
R8151 n_8_15_1 n_9_15_1 7560.20999792869
R8152 n_8_15_1 n_8_16_1 154.62111506429727
R8153 n_8_15_1 n_8_15_2 992.0359357814928
R8154 n_8_15_2 n_9_15_2 13500.374996301234
R8155 n_8_15_2 n_8_16_2 276.10913404338805
R8156 n_8_15_2 n_8_15_3 928.5456358914772
R8157 n_8_15_3 n_9_15_3 189005.24994821713
R8158 n_8_15_3 n_8_16_3 3865.527876607428
R8159 n_8_15_3 n_8_15_4 12.345336089725256
R8160 n_8_15_4 n_9_15_4 5727.4318166126395
R8161 n_8_15_4 n_8_16_4 117.13720838204328
R8162 n_8_15_15 n_9_15_15 378010.4998964309
R8163 n_8_15_15 n_8_16_15 7731.055753214789
R8164 n_8_16_0 n_9_16_0 93.99999875576313
R8165 n_8_16_0 n_8_17_0 217.1081227174476
R8166 n_8_16_0 n_8_16_1 7.598049271235005
R8167 n_8_16_1 n_9_16_1 131.59999825806835
R8168 n_8_16_1 n_8_17_1 303.9513718044267
R8169 n_8_16_1 n_8_16_2 17.268293798261375
R8170 n_8_16_2 n_9_16_2 234.99999688940778
R8171 n_8_16_2 n_8_17_2 542.770306793619
R8172 n_8_16_2 n_8_16_3 16.163122995172646
R8173 n_8_16_3 n_9_16_3 3289.9999564517057
R8174 n_8_16_3 n_8_17_3 7598.784295110658
R8175 n_8_16_3 n_8_16_4 0.2148943228228084
R8176 n_8_16_4 n_9_16_4 99.6969683773244
R8177 n_8_16_4 n_8_17_4 230.26619076092902
R8178 n_8_16_4 n_8_16_5 0.2148943228228084
R8179 n_8_16_5 n_9_16_5 3289.9999564517057
R8180 n_8_16_5 n_8_17_5 7598.784295110658
R8181 n_8_16_5 n_8_16_6 0.4144390511582734
R8182 n_8_16_6 n_9_16_6 731.1111014337124
R8183 n_8_16_6 n_8_17_6 1688.6187322468131
R8184 n_8_16_6 n_8_16_7 0.5832845905190507
R8185 n_8_16_7 n_9_16_7 1253.333316743511
R8186 n_8_16_7 n_8_17_7 2894.7749695659745
R8187 n_8_16_7 n_8_16_8 0.4297886456456155
R8188 n_8_16_8 n_9_16_8 1253.333316743511
R8189 n_8_16_8 n_8_17_8 2894.7749695659745
R8190 n_8_16_8 n_8_16_9 0.4297886456456155
R8191 n_8_16_9 n_9_16_9 1253.333316743511
R8192 n_8_16_9 n_8_17_9 2894.7749695659745
R8193 n_8_16_9 n_8_16_10 0.4297886456456155
R8194 n_8_16_10 n_9_16_10 1253.333316743511
R8195 n_8_16_10 n_8_17_10 2894.7749695659745
R8196 n_8_16_10 n_8_16_11 0.4297886456456127
R8197 n_8_16_11 n_9_16_11 1253.3333167435267
R8198 n_8_16_11 n_8_17_11 2894.774969566011
R8199 n_8_16_11 n_8_16_12 0.42978864564561137
R8200 n_8_16_12 n_9_16_12 1253.333316743519
R8201 n_8_16_12 n_8_17_12 2894.7749695659923
R8202 n_8_16_12 n_8_16_13 0.4297886456456155
R8203 n_8_16_13 n_9_16_13 1253.333316743503
R8204 n_8_16_13 n_8_17_13 2894.774969565957
R8205 n_8_16_13 n_8_16_14 2.1489432282280827
R8206 n_8_16_14 n_9_16_14 139.25925741594534
R8207 n_8_16_14 n_8_17_14 321.6416632851076
R8208 n_8_16_14 n_8_16_15 11.14380559781143
R8209 n_8_16_15 n_9_16_15 6579.999912903353
R8210 n_8_16_15 n_8_17_15 15197.568590221183
R8211 n_8_17_0 n_9_17_0 93.99999875576299
R8212 n_8_17_0 n_8_18_0 217.10812271744774
R8213 n_8_17_0 n_8_17_1 7.598049271234997
R8214 n_8_17_1 n_9_17_1 131.59999825806818
R8215 n_8_17_1 n_8_18_1 303.95137180442686
R8216 n_8_17_1 n_8_17_2 17.268293798261354
R8217 n_8_17_2 n_9_17_2 234.9999968894075
R8218 n_8_17_2 n_8_18_2 542.7703067936194
R8219 n_8_17_2 n_8_17_3 16.16312299517263
R8220 n_8_17_3 n_9_17_3 3289.999956451702
R8221 n_8_17_3 n_8_18_3 7598.784295110662
R8222 n_8_17_3 n_8_17_4 0.21489432282280818
R8223 n_8_17_4 n_9_17_4 99.69696837732431
R8224 n_8_17_4 n_8_18_4 230.26619076092916
R8225 n_8_17_4 n_8_17_5 0.21489432282280818
R8226 n_8_17_5 n_9_17_5 3289.999956451702
R8227 n_8_17_5 n_8_18_5 7598.784295110662
R8228 n_8_17_5 n_8_17_6 0.41443905115827295
R8229 n_8_17_6 n_9_17_6 731.1111014337114
R8230 n_8_17_6 n_8_18_6 1688.6187322468143
R8231 n_8_17_6 n_8_17_7 0.5832845905190501
R8232 n_8_17_7 n_9_17_7 1253.3333167435092
R8233 n_8_17_7 n_8_18_7 2894.7749695659763
R8234 n_8_17_7 n_8_17_8 0.42978864564561503
R8235 n_8_17_8 n_9_17_8 1253.3333167435092
R8236 n_8_17_8 n_8_18_8 2894.7749695659763
R8237 n_8_17_8 n_8_17_9 0.42978864564561503
R8238 n_8_17_9 n_9_17_9 1253.3333167435092
R8239 n_8_17_9 n_8_18_9 2894.7749695659763
R8240 n_8_17_9 n_8_17_10 0.42978864564561503
R8241 n_8_17_10 n_9_17_10 1253.3333167435092
R8242 n_8_17_10 n_8_18_10 2894.7749695659763
R8243 n_8_17_10 n_8_17_11 0.42978864564561226
R8244 n_8_17_11 n_9_17_11 1253.3333167435253
R8245 n_8_17_11 n_8_18_11 2894.7749695660127
R8246 n_8_17_11 n_8_17_12 0.4297886456456109
R8247 n_8_17_12 n_9_17_12 1253.3333167435176
R8248 n_8_17_12 n_8_18_12 2894.774969565994
R8249 n_8_17_12 n_8_17_13 0.42978864564561503
R8250 n_8_17_13 n_9_17_13 1253.3333167435012
R8251 n_8_17_13 n_8_18_13 2894.774969565958
R8252 n_8_17_13 n_8_17_14 2.1489432282280805
R8253 n_8_17_14 n_9_17_14 139.25925741594517
R8254 n_8_17_14 n_8_18_14 321.6416632851078
R8255 n_8_17_14 n_8_17_15 11.143805597811417
R8256 n_8_17_15 n_9_17_15 6579.999912903346
R8257 n_8_17_15 n_8_18_15 15197.568590221192
R8258 n_8_18_0 n_9_18_0 93.99999875576299
R8259 n_8_18_0 n_8_19_0 217.1081227174476
R8260 n_8_18_0 n_8_18_1 7.598049271234997
R8261 n_8_18_1 n_9_18_1 131.59999825806818
R8262 n_8_18_1 n_8_19_1 303.9513718044267
R8263 n_8_18_1 n_8_18_2 17.268293798261354
R8264 n_8_18_2 n_9_18_2 234.9999968894075
R8265 n_8_18_2 n_8_19_2 542.770306793619
R8266 n_8_18_2 n_8_18_3 16.16312299517263
R8267 n_8_18_3 n_9_18_3 3289.999956451702
R8268 n_8_18_3 n_8_19_3 7598.784295110658
R8269 n_8_18_3 n_8_18_4 0.21489432282280818
R8270 n_8_18_4 n_9_18_4 99.69696837732431
R8271 n_8_18_4 n_8_19_4 230.26619076092902
R8272 n_8_18_4 n_8_18_5 0.21489432282280818
R8273 n_8_18_5 n_9_18_5 3289.999956451702
R8274 n_8_18_5 n_8_19_5 7598.784295110658
R8275 n_8_18_5 n_8_18_6 0.41443905115827295
R8276 n_8_18_6 n_9_18_6 731.1111014337114
R8277 n_8_18_6 n_8_19_6 1688.6187322468131
R8278 n_8_18_6 n_8_18_7 0.5832845905190501
R8279 n_8_18_7 n_9_18_7 1253.3333167435092
R8280 n_8_18_7 n_8_19_7 2894.7749695659745
R8281 n_8_18_7 n_8_18_8 0.42978864564561503
R8282 n_8_18_8 n_9_18_8 1253.3333167435092
R8283 n_8_18_8 n_8_19_8 2894.7749695659745
R8284 n_8_18_8 n_8_18_9 0.42978864564561503
R8285 n_8_18_9 n_9_18_9 1253.3333167435092
R8286 n_8_18_9 n_8_19_9 2894.7749695659745
R8287 n_8_18_9 n_8_18_10 0.42978864564561503
R8288 n_8_18_10 n_9_18_10 1253.3333167435092
R8289 n_8_18_10 n_8_19_10 2894.7749695659745
R8290 n_8_18_10 n_8_18_11 0.42978864564561226
R8291 n_8_18_11 n_9_18_11 1253.3333167435253
R8292 n_8_18_11 n_8_19_11 2894.774969566011
R8293 n_8_18_11 n_8_18_12 0.4297886456456109
R8294 n_8_18_12 n_9_18_12 1253.3333167435176
R8295 n_8_18_12 n_8_19_12 2894.7749695659923
R8296 n_8_18_12 n_8_18_13 0.42978864564561503
R8297 n_8_18_13 n_9_18_13 1253.3333167435012
R8298 n_8_18_13 n_8_19_13 2894.774969565957
R8299 n_8_18_13 n_8_18_14 2.1489432282280805
R8300 n_8_18_14 n_9_18_14 139.25925741594517
R8301 n_8_18_14 n_8_19_14 321.6416632851076
R8302 n_8_18_14 n_8_18_15 11.143805597811417
R8303 n_8_18_15 n_9_18_15 6579.999912903346
R8304 n_8_18_15 n_8_19_15 15197.568590221183
R8305 n_8_19_0 n_9_19_0 93.99999875576313
R8306 n_8_19_0 n_8_20_0 110.44365396273236
R8307 n_8_19_0 n_8_19_1 7.598049271235005
R8308 n_8_19_1 n_9_19_1 131.59999825806835
R8309 n_8_19_1 n_8_20_1 154.6211155478253
R8310 n_8_19_1 n_8_19_2 17.268293798261375
R8311 n_8_19_2 n_9_19_2 234.99999688940778
R8312 n_8_19_2 n_8_20_2 276.1091349068309
R8313 n_8_19_2 n_8_19_3 16.163122995172646
R8314 n_8_19_3 n_9_19_3 3289.9999564517057
R8315 n_8_19_3 n_8_20_3 3865.527888695628
R8316 n_8_19_3 n_8_19_4 0.2148943228228084
R8317 n_8_19_4 n_9_19_4 99.6969683773244
R8318 n_8_19_4 n_8_20_4 117.13720874835238
R8319 n_8_19_4 n_8_19_5 0.2148943228228084
R8320 n_8_19_5 n_9_19_5 3289.9999564517057
R8321 n_8_19_5 n_8_19_6 0.4144390511582734
R8322 n_8_19_6 n_9_19_6 731.1111014337124
R8323 n_8_19_6 n_8_19_7 0.5832845905190507
R8324 n_8_19_7 n_9_19_7 1253.333316743511
R8325 n_8_19_7 n_8_19_8 0.4297886456456155
R8326 n_8_19_8 n_9_19_8 1253.333316743511
R8327 n_8_19_8 n_8_19_9 0.4297886456456155
R8328 n_8_19_9 n_9_19_9 1253.333316743511
R8329 n_8_19_9 n_8_19_10 0.4297886456456155
R8330 n_8_19_10 n_9_19_10 1253.333316743511
R8331 n_8_19_10 n_8_19_11 0.4297886456456127
R8332 n_8_19_11 n_9_19_11 1253.3333167435267
R8333 n_8_19_11 n_8_19_12 0.42978864564561137
R8334 n_8_19_12 n_9_19_12 1253.333316743519
R8335 n_8_19_12 n_8_19_13 0.4297886456456155
R8336 n_8_19_13 n_9_19_13 1253.333316743503
R8337 n_8_19_13 n_8_19_14 2.1489432282280827
R8338 n_8_19_14 n_9_19_14 139.25925741594534
R8339 n_8_19_14 n_8_19_15 11.14380559781143
R8340 n_8_19_15 n_9_19_15 6579.999912903353
R8341 n_8_19_15 n_8_20_15 7731.055777391189
R8342 n_8_20_0 n_9_20_0 5400.149011488476
R8343 n_8_20_0 n_8_21_0 3.779185208017232
R8344 n_8_20_0 n_8_20_1 436.49573196175044
R8345 n_8_20_1 n_9_20_1 7560.208616083864
R8346 n_8_20_1 n_8_21_1 5.290859291224125
R8347 n_8_20_1 n_8_20_2 992.0357544585238
R8348 n_8_20_2 n_9_20_2 13500.372528721193
R8349 n_8_20_2 n_8_21_2 9.44796302004308
R8350 n_8_20_2 n_8_20_3 928.5454661731783
R8351 n_8_20_3 n_9_20_3 189005.21540209645
R8352 n_8_20_3 n_8_21_3 132.27148228060295
R8353 n_8_20_3 n_8_20_4 12.34533383326164
R8354 n_8_20_4 n_9_20_4 5727.4307697605
R8355 n_8_20_4 n_8_21_4 4.008226735775848
R8356 n_8_20_15 n_9_20_15 378010.4308041895
R8357 n_8_20_15 n_8_21_15 264.54296456120363
R8358 n_8_21_0 n_9_21_0 5400.149011488476
R8359 n_8_21_0 n_8_22_0 3.779185208017098
R8360 n_8_21_0 n_8_21_1 436.49573196175044
R8361 n_8_21_1 n_9_21_1 7560.208616083864
R8362 n_8_21_1 n_8_22_1 5.290859291223937
R8363 n_8_21_1 n_8_21_2 992.0357544585238
R8364 n_8_21_2 n_9_21_2 13500.372528721193
R8365 n_8_21_2 n_8_22_2 9.447963020042746
R8366 n_8_21_2 n_8_21_3 928.5454661731783
R8367 n_8_21_3 n_9_21_3 189005.21540209645
R8368 n_8_21_3 n_8_22_3 132.27148228059826
R8369 n_8_21_3 n_8_21_4 12.34533383326164
R8370 n_8_21_4 n_9_21_4 5727.4307697605
R8371 n_8_21_4 n_8_22_4 4.008226735775706
R8372 n_8_21_15 n_9_21_15 378010.4308041895
R8373 n_8_21_15 n_8_22_15 264.54296456119425
R8374 n_8_22_0 n_9_22_0 5400.149011488859
R8375 n_8_22_0 n_8_23_0 3.779185208017098
R8376 n_8_22_0 n_8_22_1 436.4957319617814
R8377 n_8_22_1 n_9_22_1 7560.208616084403
R8378 n_8_22_1 n_8_23_1 5.290859291223937
R8379 n_8_22_1 n_8_22_2 992.035754458594
R8380 n_8_22_2 n_9_22_2 13500.37252872215
R8381 n_8_22_2 n_8_23_2 9.447963020042746
R8382 n_8_22_2 n_8_22_3 928.5454661732441
R8383 n_8_22_3 n_9_22_3 189005.2154021099
R8384 n_8_22_3 n_8_23_3 132.27148228059826
R8385 n_8_22_3 n_8_22_4 12.345333833262517
R8386 n_8_22_4 n_9_22_4 5727.430769760906
R8387 n_8_22_4 n_8_23_4 4.008226735775706
R8388 n_8_22_15 n_9_22_15 378010.4308042164
R8389 n_8_22_15 n_8_23_15 264.54296456119425
R8390 n_8_23_0 n_9_23_0 5400.149011488476
R8391 n_8_23_0 n_8_24_0 43.56171513436003
R8392 n_8_23_0 n_8_23_1 436.49573196175044
R8393 n_8_23_1 n_9_23_1 7560.208616083864
R8394 n_8_23_1 n_8_24_1 60.98640118810403
R8395 n_8_23_1 n_8_23_2 992.0357544585238
R8396 n_8_23_2 n_9_23_2 13500.372528721193
R8397 n_8_23_2 n_8_24_2 108.90428783590008
R8398 n_8_23_2 n_8_23_3 928.5454661731783
R8399 n_8_23_3 n_9_23_3 189005.21540209645
R8400 n_8_23_3 n_8_24_3 1524.660029702599
R8401 n_8_23_3 n_8_23_4 12.34533383326164
R8402 n_8_23_4 n_9_23_4 5727.4307697605
R8403 n_8_23_4 n_8_24_4 46.20181908189695
R8404 n_8_23_15 n_9_23_15 378010.4308041895
R8405 n_8_23_15 n_8_24_15 3049.320059405172
R8406 n_8_24_0 n_9_24_0 244.865896264848
R8407 n_8_24_0 n_8_25_0 83.34424506070269
R8408 n_8_24_0 n_8_24_1 19.79258690736278
R8409 n_8_24_1 n_9_24_1 342.81225477078715
R8410 n_8_24_1 n_8_25_1 116.68194308498376
R8411 n_8_24_1 n_8_24_2 44.98315206218814
R8412 n_8_24_2 n_9_24_2 612.16474066212
R8413 n_8_24_2 n_8_25_2 208.36061265175675
R8414 n_8_24_2 n_8_24_3 42.104230330208104
R8415 n_8_24_3 n_9_24_3 8570.306369269672
R8416 n_8_24_3 n_8_25_3 2917.048577124591
R8417 n_8_24_3 n_8_24_4 0.5597903367738973
R8418 n_8_24_4 n_9_24_4 259.7062536142324
R8419 n_8_24_4 n_8_25_4 88.39541142801791
R8420 n_8_24_4 n_8_24_5 0.462683849782507
R8421 n_8_24_5 n_9_24_5 1632.4393084323187
R8422 n_8_24_5 n_8_25_5 555.6283004046841
R8423 n_8_24_5 n_8_24_6 0.15994009622111352
R8424 n_8_24_6 n_9_24_6 272.07321807205307
R8425 n_8_24_6 n_8_25_6 92.60471673411402
R8426 n_8_24_6 n_8_24_7 0.21706155915722525
R8427 n_8_24_7 n_9_24_7 466.41123098066385
R8428 n_8_24_7 n_8_25_7 158.75094297276735
R8429 n_8_24_7 n_8_24_8 0.15994009622111302
R8430 n_8_24_8 n_9_24_8 466.41123098066385
R8431 n_8_24_8 n_8_25_8 158.75094297276735
R8432 n_8_24_8 n_8_24_9 0.15994009622111302
R8433 n_8_24_9 n_9_24_9 466.41123098066385
R8434 n_8_24_9 n_8_25_9 158.75094297276735
R8435 n_8_24_9 n_8_24_10 0.15994009622111302
R8436 n_8_24_10 n_9_24_10 466.41123098066385
R8437 n_8_24_10 n_8_25_10 158.75094297276735
R8438 n_8_24_10 n_8_24_11 0.159940096221112
R8439 n_8_24_11 n_9_24_11 466.41123098066976
R8440 n_8_24_11 n_8_25_11 158.7509429727694
R8441 n_8_24_11 n_8_24_12 0.1599400962211115
R8442 n_8_24_12 n_9_24_12 466.4112309806668
R8443 n_8_24_12 n_8_25_12 158.75094297276837
R8444 n_8_24_12 n_8_24_13 0.15994009622111302
R8445 n_8_24_13 n_9_24_13 466.4112309806609
R8446 n_8_24_13 n_8_25_13 158.75094297276638
R8447 n_8_24_13 n_8_24_14 0.799700481105567
R8448 n_8_24_14 n_9_24_14 51.82347010896254
R8449 n_8_24_14 n_8_25_14 17.638993663640782
R8450 n_8_24_14 n_8_24_15 24.710744866162255
R8451 n_8_24_15 n_9_24_15 17140.61273853919
R8452 n_8_24_15 n_8_25_15 5834.097154249131
R8453 n_8_25_0 n_9_25_0 244.8658962648488
R8454 n_8_25_0 n_8_26_0 83.34424506070269
R8455 n_8_25_0 n_8_25_1 19.792586907362846
R8456 n_8_25_1 n_9_25_1 342.8122547707883
R8457 n_8_25_1 n_8_26_1 116.68194308498376
R8458 n_8_25_1 n_8_25_2 44.98315206218829
R8459 n_8_25_2 n_9_25_2 612.1647406621219
R8460 n_8_25_2 n_8_26_2 208.36061265175675
R8461 n_8_25_2 n_8_25_3 42.10423033020824
R8462 n_8_25_3 n_9_25_3 8570.3063692697
R8463 n_8_25_3 n_8_26_3 2917.048577124591
R8464 n_8_25_3 n_8_25_4 0.5597903367738992
R8465 n_8_25_4 n_9_25_4 259.70625361423333
R8466 n_8_25_4 n_8_26_4 88.39541142801791
R8467 n_8_25_4 n_8_25_5 0.46268384978250854
R8468 n_8_25_5 n_9_25_5 1632.4393084323237
R8469 n_8_25_5 n_8_26_5 555.6283004046841
R8470 n_8_25_5 n_8_25_6 0.15994009622111405
R8471 n_8_25_6 n_9_25_6 272.0732180720539
R8472 n_8_25_6 n_8_26_6 92.60471673411402
R8473 n_8_25_6 n_8_25_7 0.21706155915722597
R8474 n_8_25_7 n_9_25_7 466.41123098066544
R8475 n_8_25_7 n_8_26_7 158.75094297276735
R8476 n_8_25_7 n_8_25_8 0.15994009622111355
R8477 n_8_25_8 n_9_25_8 466.41123098066544
R8478 n_8_25_8 n_8_26_8 158.75094297276735
R8479 n_8_25_8 n_8_25_9 0.15994009622111355
R8480 n_8_25_9 n_9_25_9 466.41123098066544
R8481 n_8_25_9 n_8_26_9 158.75094297276735
R8482 n_8_25_9 n_8_25_10 0.15994009622111355
R8483 n_8_25_10 n_9_25_10 466.41123098066544
R8484 n_8_25_10 n_8_26_10 158.75094297276735
R8485 n_8_25_10 n_8_25_11 0.15994009622111255
R8486 n_8_25_11 n_9_25_11 466.41123098067135
R8487 n_8_25_11 n_8_26_11 158.7509429727694
R8488 n_8_25_11 n_8_25_12 0.15994009622111202
R8489 n_8_25_12 n_9_25_12 466.41123098066817
R8490 n_8_25_12 n_8_26_12 158.75094297276837
R8491 n_8_25_12 n_8_25_13 0.15994009622111355
R8492 n_8_25_13 n_9_25_13 466.4112309806625
R8493 n_8_25_13 n_8_26_13 158.75094297276638
R8494 n_8_25_13 n_8_25_14 0.7997004811055698
R8495 n_8_25_14 n_9_25_14 51.823470108962695
R8496 n_8_25_14 n_8_26_14 17.638993663640782
R8497 n_8_25_14 n_8_25_15 24.710744866162337
R8498 n_8_25_15 n_9_25_15 17140.612738539246
R8499 n_8_25_15 n_8_26_15 5834.097154249131
R8500 n_8_26_0 n_9_26_0 244.865896264848
R8501 n_8_26_0 n_8_27_0 83.34424506070282
R8502 n_8_26_0 n_8_26_1 19.79258690736278
R8503 n_8_26_1 n_9_26_1 342.81225477078715
R8504 n_8_26_1 n_8_27_1 116.68194308498394
R8505 n_8_26_1 n_8_26_2 44.98315206218814
R8506 n_8_26_2 n_9_26_2 612.16474066212
R8507 n_8_26_2 n_8_27_2 208.36061265175707
R8508 n_8_26_2 n_8_26_3 42.104230330208104
R8509 n_8_26_3 n_9_26_3 8570.306369269672
R8510 n_8_26_3 n_8_27_3 2917.0485771245953
R8511 n_8_26_3 n_8_26_4 0.5597903367738973
R8512 n_8_26_4 n_9_26_4 259.7062536142324
R8513 n_8_26_4 n_8_27_4 88.39541142801805
R8514 n_8_26_4 n_8_26_5 0.462683849782507
R8515 n_8_26_5 n_9_26_5 1632.4393084323187
R8516 n_8_26_5 n_8_27_5 555.6283004046849
R8517 n_8_26_5 n_8_26_6 0.15994009622111352
R8518 n_8_26_6 n_9_26_6 272.07321807205307
R8519 n_8_26_6 n_8_27_6 92.60471673411416
R8520 n_8_26_6 n_8_26_7 0.21706155915722525
R8521 n_8_26_7 n_9_26_7 466.41123098066385
R8522 n_8_26_7 n_8_27_7 158.7509429727676
R8523 n_8_26_7 n_8_26_8 0.15994009622111302
R8524 n_8_26_8 n_9_26_8 466.41123098066385
R8525 n_8_26_8 n_8_27_8 158.7509429727676
R8526 n_8_26_8 n_8_26_9 0.15994009622111302
R8527 n_8_26_9 n_9_26_9 466.41123098066385
R8528 n_8_26_9 n_8_27_9 158.7509429727676
R8529 n_8_26_9 n_8_26_10 0.15994009622111302
R8530 n_8_26_10 n_9_26_10 466.41123098066385
R8531 n_8_26_10 n_8_27_10 158.7509429727676
R8532 n_8_26_10 n_8_26_11 0.159940096221112
R8533 n_8_26_11 n_9_26_11 466.41123098066976
R8534 n_8_26_11 n_8_27_11 158.75094297276962
R8535 n_8_26_11 n_8_26_12 0.1599400962211115
R8536 n_8_26_12 n_9_26_12 466.4112309806668
R8537 n_8_26_12 n_8_27_12 158.75094297276863
R8538 n_8_26_12 n_8_26_13 0.15994009622111302
R8539 n_8_26_13 n_9_26_13 466.4112309806609
R8540 n_8_26_13 n_8_27_13 158.75094297276664
R8541 n_8_26_13 n_8_26_14 0.799700481105567
R8542 n_8_26_14 n_9_26_14 51.82347010896254
R8543 n_8_26_14 n_8_27_14 17.63899366364081
R8544 n_8_26_14 n_8_26_15 24.710744866162255
R8545 n_8_26_15 n_9_26_15 17140.61273853919
R8546 n_8_26_15 n_8_27_15 5834.09715424914
R8547 n_8_27_0 n_9_27_0 244.865896264848
R8548 n_8_27_0 n_8_27_1 19.79258690736278
R8549 n_8_27_1 n_9_27_1 342.81225477078715
R8550 n_8_27_1 n_8_27_2 44.98315206218814
R8551 n_8_27_2 n_9_27_2 612.16474066212
R8552 n_8_27_2 n_8_27_3 42.104230330208104
R8553 n_8_27_3 n_9_27_3 8570.306369269672
R8554 n_8_27_3 n_8_27_4 0.5597903367738973
R8555 n_8_27_4 n_9_27_4 259.7062536142324
R8556 n_8_27_4 n_8_27_5 0.462683849782507
R8557 n_8_27_5 n_9_27_5 1632.4393084323187
R8558 n_8_27_5 n_8_27_6 0.15994009622111352
R8559 n_8_27_6 n_9_27_6 272.07321807205307
R8560 n_8_27_6 n_8_27_7 0.21706155915722525
R8561 n_8_27_7 n_9_27_7 466.41123098066385
R8562 n_8_27_7 n_8_27_8 0.15994009622111302
R8563 n_8_27_8 n_9_27_8 466.41123098066385
R8564 n_8_27_8 n_8_27_9 0.15994009622111302
R8565 n_8_27_9 n_9_27_9 466.41123098066385
R8566 n_8_27_9 n_8_27_10 0.15994009622111302
R8567 n_8_27_10 n_9_27_10 466.41123098066385
R8568 n_8_27_10 n_8_27_11 0.159940096221112
R8569 n_8_27_11 n_9_27_11 466.41123098066976
R8570 n_8_27_11 n_8_27_12 0.1599400962211115
R8571 n_8_27_12 n_9_27_12 466.4112309806668
R8572 n_8_27_12 n_8_27_13 0.15994009622111302
R8573 n_8_27_13 n_9_27_13 466.4112309806609
R8574 n_8_27_13 n_8_27_14 0.799700481105567
R8575 n_8_27_14 n_9_27_14 51.82347010896254
R8576 n_8_27_14 n_8_27_15 24.710744866162255
R8577 n_8_27_15 n_9_27_15 17140.61273853919
R8578 n_9_0_0 n_10_0_0 244.86587517703651
R8579 n_9_0_0 n_9_1_0 83.34425223829642
R8580 n_9_0_0 n_9_0_1 19.792585202828388
R8581 n_9_0_1 n_10_0_1 342.8122252478511
R8582 n_9_0_1 n_9_1_1 116.68195313361498
R8583 n_9_0_1 n_9_0_2 44.98314818824633
R8584 n_9_0_2 n_10_0_2 612.1646879425912
R8585 n_9_0_2 n_9_1_2 208.36063059574104
R8586 n_9_0_2 n_9_0_3 42.10422670419857
R8587 n_9_0_3 n_10_0_3 8570.305631196268
R8588 n_9_0_3 n_9_1_3 2917.048828340372
R8589 n_9_0_3 n_9_0_4 0.5597902885648438
R8590 n_9_0_4 n_10_0_4 259.7062312483718
R8591 n_9_0_4 n_9_1_4 88.39541904061731
R8592 n_9_0_4 n_9_0_5 0.46268380993624847
R8593 n_9_0_5 n_10_0_5 1632.4391678469083
R8594 n_9_0_5 n_9_1_5 555.6283482553089
R8595 n_9_0_5 n_9_0_6 0.1599400824470982
R8596 n_9_0_6 n_10_0_6 272.0731946411514
R8597 n_9_0_6 n_9_1_6 92.60472470921815
R8598 n_9_0_6 n_9_0_7 0.21706154046391873
R8599 n_9_0_7 n_10_0_7 466.41119081340383
R8600 n_9_0_7 n_9_1_7 158.75095664437444
R8601 n_9_0_7 n_9_0_8 0.1599400824470977
R8602 n_9_0_8 n_10_0_8 466.41119081340383
R8603 n_9_0_8 n_9_1_8 158.75095664437444
R8604 n_9_0_8 n_9_0_9 0.1599400824470977
R8605 n_9_0_9 n_10_0_9 466.41119081340383
R8606 n_9_0_9 n_9_1_9 158.75095664437444
R8607 n_9_0_9 n_9_0_10 0.1599400824470977
R8608 n_9_0_10 n_10_0_10 466.41119081340383
R8609 n_9_0_10 n_9_1_10 158.75095664437444
R8610 n_9_0_10 n_9_0_11 0.15994008244709668
R8611 n_9_0_11 n_10_0_11 466.4111908134098
R8612 n_9_0_11 n_9_1_11 158.7509566443765
R8613 n_9_0_11 n_9_0_12 0.15994008244709618
R8614 n_9_0_12 n_10_0_12 466.41119081340696
R8615 n_9_0_12 n_9_1_12 158.7509566443755
R8616 n_9_0_12 n_9_0_13 0.15994008244709768
R8617 n_9_0_13 n_10_0_13 466.41119081340094
R8618 n_9_0_13 n_9_1_13 158.75095664437345
R8619 n_9_0_13 n_9_0_14 0.7997004122354905
R8620 n_9_0_14 n_10_0_14 51.82346564593365
R8621 n_9_0_14 n_9_1_14 17.638995182708236
R8622 n_9_0_14 n_9_0_15 24.710742738076885
R8623 n_9_0_15 n_10_0_15 17140.611262392384
R8624 n_9_0_15 n_9_1_15 5834.097656680692
R8625 n_9_1_0 n_10_1_0 244.86587517703651
R8626 n_9_1_0 n_9_2_0 83.34425223829642
R8627 n_9_1_0 n_9_1_1 19.792585202828388
R8628 n_9_1_1 n_10_1_1 342.8122252478511
R8629 n_9_1_1 n_9_2_1 116.68195313361498
R8630 n_9_1_1 n_9_1_2 44.98314818824633
R8631 n_9_1_2 n_10_1_2 612.1646879425912
R8632 n_9_1_2 n_9_2_2 208.36063059574104
R8633 n_9_1_2 n_9_1_3 42.10422670419857
R8634 n_9_1_3 n_10_1_3 8570.305631196268
R8635 n_9_1_3 n_9_2_3 2917.048828340372
R8636 n_9_1_3 n_9_1_4 0.5597902885648438
R8637 n_9_1_4 n_10_1_4 259.7062312483718
R8638 n_9_1_4 n_9_2_4 88.39541904061731
R8639 n_9_1_4 n_9_1_5 0.46268380993624847
R8640 n_9_1_5 n_10_1_5 1632.4391678469083
R8641 n_9_1_5 n_9_2_5 555.6283482553089
R8642 n_9_1_5 n_9_1_6 0.1599400824470982
R8643 n_9_1_6 n_10_1_6 272.0731946411514
R8644 n_9_1_6 n_9_2_6 92.60472470921815
R8645 n_9_1_6 n_9_1_7 0.21706154046391873
R8646 n_9_1_7 n_10_1_7 466.41119081340383
R8647 n_9_1_7 n_9_2_7 158.75095664437444
R8648 n_9_1_7 n_9_1_8 0.1599400824470977
R8649 n_9_1_8 n_10_1_8 466.41119081340383
R8650 n_9_1_8 n_9_2_8 158.75095664437444
R8651 n_9_1_8 n_9_1_9 0.1599400824470977
R8652 n_9_1_9 n_10_1_9 466.41119081340383
R8653 n_9_1_9 n_9_2_9 158.75095664437444
R8654 n_9_1_9 n_9_1_10 0.1599400824470977
R8655 n_9_1_10 n_10_1_10 466.41119081340383
R8656 n_9_1_10 n_9_2_10 158.75095664437444
R8657 n_9_1_10 n_9_1_11 0.15994008244709668
R8658 n_9_1_11 n_10_1_11 466.4111908134098
R8659 n_9_1_11 n_9_2_11 158.7509566443765
R8660 n_9_1_11 n_9_1_12 0.15994008244709618
R8661 n_9_1_12 n_10_1_12 466.41119081340696
R8662 n_9_1_12 n_9_2_12 158.7509566443755
R8663 n_9_1_12 n_9_1_13 0.15994008244709768
R8664 n_9_1_13 n_10_1_13 466.41119081340094
R8665 n_9_1_13 n_9_2_13 158.75095664437345
R8666 n_9_1_13 n_9_1_14 0.7997004122354905
R8667 n_9_1_14 n_10_1_14 51.82346564593365
R8668 n_9_1_14 n_9_2_14 17.638995182708236
R8669 n_9_1_14 n_9_1_15 24.710742738076885
R8670 n_9_1_15 n_10_1_15 17140.611262392384
R8671 n_9_1_15 n_9_2_15 5834.097656680692
R8672 n_9_2_0 n_10_2_0 244.86587517703651
R8673 n_9_2_0 n_9_3_0 83.34425223829642
R8674 n_9_2_0 n_9_2_1 19.792585202828388
R8675 n_9_2_1 n_10_2_1 342.8122252478511
R8676 n_9_2_1 n_9_3_1 116.68195313361498
R8677 n_9_2_1 n_9_2_2 44.98314818824633
R8678 n_9_2_2 n_10_2_2 612.1646879425912
R8679 n_9_2_2 n_9_3_2 208.36063059574104
R8680 n_9_2_2 n_9_2_3 42.10422670419857
R8681 n_9_2_3 n_10_2_3 8570.305631196268
R8682 n_9_2_3 n_9_3_3 2917.048828340372
R8683 n_9_2_3 n_9_2_4 0.5597902885648438
R8684 n_9_2_4 n_10_2_4 259.7062312483718
R8685 n_9_2_4 n_9_3_4 88.39541904061731
R8686 n_9_2_4 n_9_2_5 0.46268380993624847
R8687 n_9_2_5 n_10_2_5 1632.4391678469083
R8688 n_9_2_5 n_9_3_5 555.6283482553089
R8689 n_9_2_5 n_9_2_6 0.1599400824470982
R8690 n_9_2_6 n_10_2_6 272.0731946411514
R8691 n_9_2_6 n_9_3_6 92.60472470921815
R8692 n_9_2_6 n_9_2_7 0.21706154046391873
R8693 n_9_2_7 n_10_2_7 466.41119081340383
R8694 n_9_2_7 n_9_3_7 158.75095664437444
R8695 n_9_2_7 n_9_2_8 0.1599400824470977
R8696 n_9_2_8 n_10_2_8 466.41119081340383
R8697 n_9_2_8 n_9_3_8 158.75095664437444
R8698 n_9_2_8 n_9_2_9 0.1599400824470977
R8699 n_9_2_9 n_10_2_9 466.41119081340383
R8700 n_9_2_9 n_9_3_9 158.75095664437444
R8701 n_9_2_9 n_9_2_10 0.1599400824470977
R8702 n_9_2_10 n_10_2_10 466.41119081340383
R8703 n_9_2_10 n_9_3_10 158.75095664437444
R8704 n_9_2_10 n_9_2_11 0.15994008244709668
R8705 n_9_2_11 n_10_2_11 466.4111908134098
R8706 n_9_2_11 n_9_3_11 158.7509566443765
R8707 n_9_2_11 n_9_2_12 0.15994008244709618
R8708 n_9_2_12 n_10_2_12 466.41119081340696
R8709 n_9_2_12 n_9_3_12 158.7509566443755
R8710 n_9_2_12 n_9_2_13 0.15994008244709768
R8711 n_9_2_13 n_10_2_13 466.41119081340094
R8712 n_9_2_13 n_9_3_13 158.75095664437345
R8713 n_9_2_13 n_9_2_14 0.7997004122354905
R8714 n_9_2_14 n_10_2_14 51.82346564593365
R8715 n_9_2_14 n_9_3_14 17.638995182708236
R8716 n_9_2_14 n_9_2_15 24.710742738076885
R8717 n_9_2_15 n_10_2_15 17140.611262392384
R8718 n_9_2_15 n_9_3_15 5834.097656680692
R8719 n_9_3_0 n_10_3_0 244.86587517703651
R8720 n_9_3_0 n_9_4_0 43.561715134359936
R8721 n_9_3_0 n_9_3_1 19.792585202828388
R8722 n_9_3_1 n_10_3_1 342.8122252478511
R8723 n_9_3_1 n_9_4_1 60.98640118810391
R8724 n_9_3_1 n_9_3_2 44.98314818824633
R8725 n_9_3_2 n_10_3_2 612.1646879425912
R8726 n_9_3_2 n_9_4_2 108.90428783589984
R8727 n_9_3_2 n_9_3_3 42.10422670419857
R8728 n_9_3_3 n_10_3_3 8570.305631196268
R8729 n_9_3_3 n_9_4_3 1524.6600297025964
R8730 n_9_3_3 n_9_3_4 0.5597902885648438
R8731 n_9_3_4 n_10_3_4 259.7062312483718
R8732 n_9_3_4 n_9_4_4 46.20181908189685
R8733 n_9_3_4 n_9_3_5 0.46268380993624847
R8734 n_9_3_5 n_10_3_5 1632.4391678469083
R8735 n_9_3_5 n_9_3_6 0.1599400824470982
R8736 n_9_3_6 n_10_3_6 272.0731946411514
R8737 n_9_3_6 n_9_3_7 0.21706154046391873
R8738 n_9_3_7 n_10_3_7 466.41119081340383
R8739 n_9_3_7 n_9_3_8 0.1599400824470977
R8740 n_9_3_8 n_10_3_8 466.41119081340383
R8741 n_9_3_8 n_9_3_9 0.1599400824470977
R8742 n_9_3_9 n_10_3_9 466.41119081340383
R8743 n_9_3_9 n_9_3_10 0.1599400824470977
R8744 n_9_3_10 n_10_3_10 466.41119081340383
R8745 n_9_3_10 n_9_3_11 0.15994008244709668
R8746 n_9_3_11 n_10_3_11 466.4111908134098
R8747 n_9_3_11 n_9_3_12 0.15994008244709618
R8748 n_9_3_12 n_10_3_12 466.41119081340696
R8749 n_9_3_12 n_9_3_13 0.15994008244709768
R8750 n_9_3_13 n_10_3_13 466.41119081340094
R8751 n_9_3_13 n_9_3_14 0.7997004122354905
R8752 n_9_3_14 n_10_3_14 51.82346564593365
R8753 n_9_3_14 n_9_3_15 24.710742738076885
R8754 n_9_3_15 n_10_3_15 17140.611262392384
R8755 n_9_3_15 n_9_4_15 3049.3200594051655
R8756 n_9_4_0 n_10_4_0 5400.15926770706
R8757 n_9_4_0 n_9_5_0 3.7791780304234877
R8758 n_9_4_0 n_9_4_1 436.4965609751034
R8759 n_9_4_1 n_10_4_1 7560.2229747898855
R8760 n_9_4_1 n_9_5_1 5.290849242592882
R8761 n_9_4_1 n_9_4_2 992.0376385797804
R8762 n_9_4_2 n_10_4_2 13500.398169267653
R8763 n_9_4_2 n_9_5_2 9.44794507605872
R8764 n_9_4_2 n_9_4_3 928.5472297106745
R8765 n_9_4_3 n_10_4_3 189005.57436974702
R8766 n_9_4_3 n_9_5_3 132.27123106482196
R8767 n_9_4_3 n_9_4_4 12.345357280103947
R8768 n_9_4_4 n_10_4_4 5727.44164756809
R8769 n_9_4_4 n_9_5_4 4.0082191231764215
R8770 n_9_4_15 n_10_4_15 378011.14873949066
R8771 n_9_4_15 n_9_5_15 264.54246212964154
R8772 n_9_5_0 n_10_5_0 5400.159267706966
R8773 n_9_5_0 n_9_6_0 3.779178030423521
R8774 n_9_5_0 n_9_5_1 436.49656097509563
R8775 n_9_5_1 n_10_5_1 7560.222974789751
R8776 n_9_5_1 n_9_6_1 5.290849242592929
R8777 n_9_5_1 n_9_5_2 992.0376385797628
R8778 n_9_5_2 n_10_5_2 13500.398169267413
R8779 n_9_5_2 n_9_6_2 9.447945076058803
R8780 n_9_5_2 n_9_5_3 928.5472297106579
R8781 n_9_5_3 n_10_5_3 189005.57436974364
R8782 n_9_5_3 n_9_6_3 132.27123106482313
R8783 n_9_5_3 n_9_5_4 12.345357280103725
R8784 n_9_5_4 n_10_5_4 5727.441647567988
R8785 n_9_5_4 n_9_6_4 4.008219123176457
R8786 n_9_5_15 n_10_5_15 378011.1487394839
R8787 n_9_5_15 n_9_6_15 264.54246212964387
R8788 n_9_6_0 n_10_6_0 5400.159267706966
R8789 n_9_6_0 n_9_7_0 3.7791780304234877
R8790 n_9_6_0 n_9_6_1 436.49656097509563
R8791 n_9_6_1 n_10_6_1 7560.222974789751
R8792 n_9_6_1 n_9_7_1 5.290849242592882
R8793 n_9_6_1 n_9_6_2 992.0376385797628
R8794 n_9_6_2 n_10_6_2 13500.398169267413
R8795 n_9_6_2 n_9_7_2 9.44794507605872
R8796 n_9_6_2 n_9_6_3 928.5472297106579
R8797 n_9_6_3 n_10_6_3 189005.57436974364
R8798 n_9_6_3 n_9_7_3 132.27123106482196
R8799 n_9_6_3 n_9_6_4 12.345357280103725
R8800 n_9_6_4 n_10_6_4 5727.441647567988
R8801 n_9_6_4 n_9_7_4 4.0082191231764215
R8802 n_9_6_15 n_10_6_15 378011.1487394839
R8803 n_9_6_15 n_9_7_15 264.54246212964154
R8804 n_9_7_0 n_10_7_0 5400.15926770706
R8805 n_9_7_0 n_9_8_0 110.44365037393554
R8806 n_9_7_0 n_9_7_1 436.4965609751034
R8807 n_9_7_1 n_10_7_1 7560.2229747898855
R8808 n_9_7_1 n_9_8_1 154.62111052350977
R8809 n_9_7_1 n_9_7_2 992.0376385797804
R8810 n_9_7_2 n_10_7_2 13500.398169267653
R8811 n_9_7_2 n_9_8_2 276.1091259348389
R8812 n_9_7_2 n_9_7_3 928.5472297106745
R8813 n_9_7_3 n_10_7_3 189005.57436974702
R8814 n_9_7_3 n_9_8_3 3865.527763087741
R8815 n_9_7_3 n_9_7_4 12.345357280103947
R8816 n_9_7_4 n_10_7_4 5727.44164756809
R8817 n_9_7_4 n_9_8_4 117.13720494205273
R8818 n_9_7_15 n_10_7_15 378011.14873949066
R8819 n_9_7_15 n_9_8_15 7731.055526175412
R8820 n_9_8_0 n_10_8_0 93.99999875576307
R8821 n_9_8_0 n_9_9_0 217.1081227174477
R8822 n_9_8_0 n_9_8_1 7.598049271235001
R8823 n_9_8_1 n_10_8_1 131.5999982580683
R8824 n_9_8_1 n_9_9_1 303.9513718044268
R8825 n_9_8_1 n_9_8_2 17.268293798261368
R8826 n_9_8_2 n_10_8_2 234.99999688940767
R8827 n_9_8_2 n_9_9_2 542.7703067936193
R8828 n_9_8_2 n_9_8_3 16.16312299517264
R8829 n_9_8_3 n_10_8_3 3289.9999564517047
R8830 n_9_8_3 n_9_9_3 7598.784295110663
R8831 n_9_8_3 n_9_8_4 0.2148943228228083
R8832 n_9_8_4 n_10_8_4 99.6969683773244
R8833 n_9_8_4 n_9_9_4 230.26619076092913
R8834 n_9_8_4 n_9_8_5 0.2148943228228083
R8835 n_9_8_5 n_10_8_5 3289.9999564517047
R8836 n_9_8_5 n_9_9_5 7598.784295110663
R8837 n_9_8_5 n_9_8_6 0.4144390511582731
R8838 n_9_8_6 n_10_8_6 731.1111014337121
R8839 n_9_8_6 n_9_9_6 1688.6187322468138
R8840 n_9_8_6 n_9_8_7 0.5832845905190505
R8841 n_9_8_7 n_10_8_7 1253.3333167435103
R8842 n_9_8_7 n_9_9_7 2894.7749695659754
R8843 n_9_8_7 n_9_8_8 0.42978864564561525
R8844 n_9_8_8 n_10_8_8 1253.3333167435103
R8845 n_9_8_8 n_9_9_8 2894.7749695659754
R8846 n_9_8_8 n_9_8_9 0.42978864564561525
R8847 n_9_8_9 n_10_8_9 1253.3333167435103
R8848 n_9_8_9 n_9_9_9 2894.7749695659754
R8849 n_9_8_9 n_9_8_10 0.42978864564561525
R8850 n_9_8_10 n_10_8_10 1253.3333167435103
R8851 n_9_8_10 n_9_9_10 2894.7749695659754
R8852 n_9_8_10 n_9_8_11 0.4297886456456125
R8853 n_9_8_11 n_10_8_11 1253.3333167435262
R8854 n_9_8_11 n_9_9_11 2894.7749695660123
R8855 n_9_8_11 n_9_8_12 0.42978864564561114
R8856 n_9_8_12 n_10_8_12 1253.3333167435185
R8857 n_9_8_12 n_9_9_12 2894.774969565994
R8858 n_9_8_12 n_9_8_13 0.42978864564561525
R8859 n_9_8_13 n_10_8_13 1253.3333167435026
R8860 n_9_8_13 n_9_9_13 2894.7749695659577
R8861 n_9_8_13 n_9_8_14 2.148943228228082
R8862 n_9_8_14 n_10_8_14 139.25925741594529
R8863 n_9_8_14 n_9_9_14 321.6416632851078
R8864 n_9_8_14 n_9_8_15 11.143805597811426
R8865 n_9_8_15 n_10_8_15 6579.999912903351
R8866 n_9_8_15 n_9_9_15 15197.56859022119
R8867 n_9_9_0 n_10_9_0 93.99999875576299
R8868 n_9_9_0 n_9_10_0 217.1081227174477
R8869 n_9_9_0 n_9_9_1 7.598049271234997
R8870 n_9_9_1 n_10_9_1 131.5999982580682
R8871 n_9_9_1 n_9_10_1 303.9513718044268
R8872 n_9_9_1 n_9_9_2 17.268293798261354
R8873 n_9_9_2 n_10_9_2 234.99999688940753
R8874 n_9_9_2 n_9_10_2 542.7703067936193
R8875 n_9_9_2 n_9_9_3 16.16312299517263
R8876 n_9_9_3 n_10_9_3 3289.999956451703
R8877 n_9_9_3 n_9_10_3 7598.784295110663
R8878 n_9_9_3 n_9_9_4 0.21489432282280818
R8879 n_9_9_4 n_10_9_4 99.69696837732431
R8880 n_9_9_4 n_9_10_4 230.26619076092913
R8881 n_9_9_4 n_9_9_5 0.21489432282280818
R8882 n_9_9_5 n_10_9_5 3289.999956451703
R8883 n_9_9_5 n_9_10_5 7598.784295110663
R8884 n_9_9_5 n_9_9_6 0.41443905115827295
R8885 n_9_9_6 n_10_9_6 731.1111014337116
R8886 n_9_9_6 n_9_10_6 1688.6187322468138
R8887 n_9_9_6 n_9_9_7 0.5832845905190501
R8888 n_9_9_7 n_10_9_7 1253.3333167435094
R8889 n_9_9_7 n_9_10_7 2894.7749695659754
R8890 n_9_9_7 n_9_9_8 0.42978864564561503
R8891 n_9_9_8 n_10_9_8 1253.3333167435094
R8892 n_9_9_8 n_9_10_8 2894.7749695659754
R8893 n_9_9_8 n_9_9_9 0.42978864564561503
R8894 n_9_9_9 n_10_9_9 1253.3333167435094
R8895 n_9_9_9 n_9_10_9 2894.7749695659754
R8896 n_9_9_9 n_9_9_10 0.42978864564561503
R8897 n_9_9_10 n_10_9_10 1253.3333167435094
R8898 n_9_9_10 n_9_10_10 2894.7749695659754
R8899 n_9_9_10 n_9_9_11 0.42978864564561226
R8900 n_9_9_11 n_10_9_11 1253.3333167435258
R8901 n_9_9_11 n_9_10_11 2894.7749695660123
R8902 n_9_9_11 n_9_9_12 0.4297886456456109
R8903 n_9_9_12 n_10_9_12 1253.3333167435176
R8904 n_9_9_12 n_9_10_12 2894.774969565994
R8905 n_9_9_12 n_9_9_13 0.42978864564561503
R8906 n_9_9_13 n_10_9_13 1253.3333167435017
R8907 n_9_9_13 n_9_10_13 2894.7749695659577
R8908 n_9_9_13 n_9_9_14 2.1489432282280805
R8909 n_9_9_14 n_10_9_14 139.25925741594523
R8910 n_9_9_14 n_9_10_14 321.6416632851078
R8911 n_9_9_14 n_9_9_15 11.143805597811417
R8912 n_9_9_15 n_10_9_15 6579.999912903348
R8913 n_9_9_15 n_9_10_15 15197.56859022119
R8914 n_9_10_0 n_10_10_0 93.99999875576307
R8915 n_9_10_0 n_9_11_0 217.10812271744763
R8916 n_9_10_0 n_9_10_1 7.598049271235001
R8917 n_9_10_1 n_10_10_1 131.5999982580683
R8918 n_9_10_1 n_9_11_1 303.9513718044267
R8919 n_9_10_1 n_9_10_2 17.268293798261368
R8920 n_9_10_2 n_10_10_2 234.99999688940767
R8921 n_9_10_2 n_9_11_2 542.7703067936192
R8922 n_9_10_2 n_9_10_3 16.16312299517264
R8923 n_9_10_3 n_10_10_3 3289.9999564517047
R8924 n_9_10_3 n_9_11_3 7598.78429511066
R8925 n_9_10_3 n_9_10_4 0.2148943228228083
R8926 n_9_10_4 n_10_10_4 99.6969683773244
R8927 n_9_10_4 n_9_11_4 230.26619076092908
R8928 n_9_10_4 n_9_10_5 0.2148943228228083
R8929 n_9_10_5 n_10_10_5 3289.9999564517047
R8930 n_9_10_5 n_9_11_5 7598.78429511066
R8931 n_9_10_5 n_9_10_6 0.4144390511582731
R8932 n_9_10_6 n_10_10_6 731.1111014337121
R8933 n_9_10_6 n_9_11_6 1688.6187322468134
R8934 n_9_10_6 n_9_10_7 0.5832845905190505
R8935 n_9_10_7 n_10_10_7 1253.3333167435103
R8936 n_9_10_7 n_9_11_7 2894.7749695659745
R8937 n_9_10_7 n_9_10_8 0.42978864564561525
R8938 n_9_10_8 n_10_10_8 1253.3333167435103
R8939 n_9_10_8 n_9_11_8 2894.7749695659745
R8940 n_9_10_8 n_9_10_9 0.42978864564561525
R8941 n_9_10_9 n_10_10_9 1253.3333167435103
R8942 n_9_10_9 n_9_11_9 2894.7749695659745
R8943 n_9_10_9 n_9_10_10 0.42978864564561525
R8944 n_9_10_10 n_10_10_10 1253.3333167435103
R8945 n_9_10_10 n_9_11_10 2894.7749695659745
R8946 n_9_10_10 n_9_10_11 0.4297886456456125
R8947 n_9_10_11 n_10_10_11 1253.3333167435262
R8948 n_9_10_11 n_9_11_11 2894.774969566012
R8949 n_9_10_11 n_9_10_12 0.42978864564561114
R8950 n_9_10_12 n_10_10_12 1253.3333167435185
R8951 n_9_10_12 n_9_11_12 2894.774969565993
R8952 n_9_10_12 n_9_10_13 0.42978864564561525
R8953 n_9_10_13 n_10_10_13 1253.3333167435026
R8954 n_9_10_13 n_9_11_13 2894.774969565957
R8955 n_9_10_13 n_9_10_14 2.148943228228082
R8956 n_9_10_14 n_10_10_14 139.25925741594529
R8957 n_9_10_14 n_9_11_14 321.6416632851077
R8958 n_9_10_14 n_9_10_15 11.143805597811426
R8959 n_9_10_15 n_10_10_15 6579.999912903351
R8960 n_9_10_15 n_9_11_15 15197.568590221184
R8961 n_9_11_0 n_10_11_0 93.99999875576307
R8962 n_9_11_0 n_9_12_0 110.44365361735528
R8963 n_9_11_0 n_9_11_1 7.598049271235001
R8964 n_9_11_1 n_10_11_1 131.5999982580683
R8965 n_9_11_1 n_9_12_1 154.6211150642974
R8966 n_9_11_1 n_9_11_2 17.268293798261368
R8967 n_9_11_2 n_10_11_2 234.99999688940767
R8968 n_9_11_2 n_9_12_2 276.1091340433883
R8969 n_9_11_2 n_9_11_3 16.16312299517264
R8970 n_9_11_3 n_10_11_3 3289.9999564517047
R8971 n_9_11_3 n_9_12_3 3865.5278766074316
R8972 n_9_11_3 n_9_11_4 0.2148943228228083
R8973 n_9_11_4 n_10_11_4 99.6969683773244
R8974 n_9_11_4 n_9_12_4 117.13720838204337
R8975 n_9_11_4 n_9_11_5 0.2148943228228083
R8976 n_9_11_5 n_10_11_5 3289.9999564517047
R8977 n_9_11_5 n_9_11_6 0.4144390511582731
R8978 n_9_11_6 n_10_11_6 731.1111014337121
R8979 n_9_11_6 n_9_11_7 0.5832845905190505
R8980 n_9_11_7 n_10_11_7 1253.3333167435103
R8981 n_9_11_7 n_9_11_8 0.42978864564561525
R8982 n_9_11_8 n_10_11_8 1253.3333167435103
R8983 n_9_11_8 n_9_11_9 0.42978864564561525
R8984 n_9_11_9 n_10_11_9 1253.3333167435103
R8985 n_9_11_9 n_9_11_10 0.42978864564561525
R8986 n_9_11_10 n_10_11_10 1253.3333167435103
R8987 n_9_11_10 n_9_11_11 0.4297886456456125
R8988 n_9_11_11 n_10_11_11 1253.3333167435262
R8989 n_9_11_11 n_9_11_12 0.42978864564561114
R8990 n_9_11_12 n_10_11_12 1253.3333167435185
R8991 n_9_11_12 n_9_11_13 0.42978864564561525
R8992 n_9_11_13 n_10_11_13 1253.3333167435026
R8993 n_9_11_13 n_9_11_14 2.148943228228082
R8994 n_9_11_14 n_10_11_14 139.25925741594529
R8995 n_9_11_14 n_9_11_15 11.143805597811426
R8996 n_9_11_15 n_10_11_15 6579.999912903351
R8997 n_9_11_15 n_9_12_15 7731.055753214794
R8998 n_9_12_0 n_10_12_0 5400.149998520495
R8999 n_9_12_0 n_9_13_0 3.779184517262938
R9000 n_9_12_0 n_9_12_1 436.49581174385685
R9001 n_9_12_1 n_10_12_1 7560.209997928692
R9002 n_9_12_1 n_9_13_1 5.290858324168114
R9003 n_9_12_1 n_9_12_2 992.035935781493
R9004 n_9_12_2 n_10_12_2 13500.374996301238
R9005 n_9_12_2 n_9_13_2 9.447961293157347
R9006 n_9_12_2 n_9_12_3 928.5456358914773
R9007 n_9_12_3 n_10_12_3 189005.24994821713
R9008 n_9_12_3 n_9_13_3 132.27145810420274
R9009 n_9_12_3 n_9_12_4 12.345336089725256
R9010 n_9_12_4 n_10_12_4 5727.431816612641
R9011 n_9_12_4 n_9_13_4 4.008226003157658
R9012 n_9_12_15 n_10_12_15 378010.499896431
R9013 n_9_12_15 n_9_13_15 264.5429162084031
R9014 n_9_13_0 n_10_13_0 5400.149998520495
R9015 n_9_13_0 n_9_14_0 3.779184517262938
R9016 n_9_13_0 n_9_13_1 436.49581174385685
R9017 n_9_13_1 n_10_13_1 7560.209997928692
R9018 n_9_13_1 n_9_14_1 5.290858324168114
R9019 n_9_13_1 n_9_13_2 992.035935781493
R9020 n_9_13_2 n_10_13_2 13500.374996301238
R9021 n_9_13_2 n_9_14_2 9.447961293157347
R9022 n_9_13_2 n_9_13_3 928.5456358914773
R9023 n_9_13_3 n_10_13_3 189005.24994821713
R9024 n_9_13_3 n_9_14_3 132.27145810420274
R9025 n_9_13_3 n_9_13_4 12.345336089725256
R9026 n_9_13_4 n_10_13_4 5727.431816612641
R9027 n_9_13_4 n_9_14_4 4.008226003157658
R9028 n_9_13_15 n_10_13_15 378010.499896431
R9029 n_9_13_15 n_9_14_15 264.5429162084031
R9030 n_9_14_0 n_10_14_0 5400.149998520495
R9031 n_9_14_0 n_9_15_0 3.779184517262938
R9032 n_9_14_0 n_9_14_1 436.49581174385685
R9033 n_9_14_1 n_10_14_1 7560.209997928692
R9034 n_9_14_1 n_9_15_1 5.290858324168114
R9035 n_9_14_1 n_9_14_2 992.035935781493
R9036 n_9_14_2 n_10_14_2 13500.374996301238
R9037 n_9_14_2 n_9_15_2 9.447961293157347
R9038 n_9_14_2 n_9_14_3 928.5456358914773
R9039 n_9_14_3 n_10_14_3 189005.24994821713
R9040 n_9_14_3 n_9_15_3 132.27145810420274
R9041 n_9_14_3 n_9_14_4 12.345336089725256
R9042 n_9_14_4 n_10_14_4 5727.431816612641
R9043 n_9_14_4 n_9_15_4 4.008226003157658
R9044 n_9_14_15 n_10_14_15 378010.499896431
R9045 n_9_14_15 n_9_15_15 264.5429162084031
R9046 n_9_15_0 n_10_15_0 5400.149998520495
R9047 n_9_15_0 n_9_16_0 110.44365361735522
R9048 n_9_15_0 n_9_15_1 436.49581174385685
R9049 n_9_15_1 n_10_15_1 7560.209997928692
R9050 n_9_15_1 n_9_16_1 154.62111506429733
R9051 n_9_15_1 n_9_15_2 992.035935781493
R9052 n_9_15_2 n_10_15_2 13500.374996301238
R9053 n_9_15_2 n_9_16_2 276.1091340433881
R9054 n_9_15_2 n_9_15_3 928.5456358914773
R9055 n_9_15_3 n_10_15_3 189005.24994821713
R9056 n_9_15_3 n_9_16_3 3865.5278766074293
R9057 n_9_15_3 n_9_15_4 12.345336089725256
R9058 n_9_15_4 n_10_15_4 5727.431816612641
R9059 n_9_15_4 n_9_16_4 117.1372083820433
R9060 n_9_15_15 n_10_15_15 378010.499896431
R9061 n_9_15_15 n_9_16_15 7731.05575321479
R9062 n_9_16_0 n_10_16_0 93.99999875576313
R9063 n_9_16_0 n_9_17_0 217.10812271744766
R9064 n_9_16_0 n_9_16_1 7.5980492712350065
R9065 n_9_16_1 n_10_16_1 131.59999825806835
R9066 n_9_16_1 n_9_17_1 303.9513718044267
R9067 n_9_16_1 n_9_16_2 17.26829379826138
R9068 n_9_16_2 n_10_16_2 234.9999968894078
R9069 n_9_16_2 n_9_17_2 542.770306793619
R9070 n_9_16_2 n_9_16_3 16.16312299517265
R9071 n_9_16_3 n_10_16_3 3289.9999564517066
R9072 n_9_16_3 n_9_17_3 7598.78429511066
R9073 n_9_16_3 n_9_16_4 0.21489432282280846
R9074 n_9_16_4 n_10_16_4 99.69696837732442
R9075 n_9_16_4 n_9_17_4 230.26619076092908
R9076 n_9_16_4 n_9_16_5 0.21489432282280846
R9077 n_9_16_5 n_10_16_5 3289.9999564517066
R9078 n_9_16_5 n_9_17_5 7598.78429511066
R9079 n_9_16_5 n_9_16_6 0.41443905115827345
R9080 n_9_16_6 n_10_16_6 731.1111014337125
R9081 n_9_16_6 n_9_17_6 1688.6187322468131
R9082 n_9_16_6 n_9_16_7 0.5832845905190508
R9083 n_9_16_7 n_10_16_7 1253.3333167435112
R9084 n_9_16_7 n_9_17_7 2894.7749695659745
R9085 n_9_16_7 n_9_16_8 0.42978864564561553
R9086 n_9_16_8 n_10_16_8 1253.3333167435112
R9087 n_9_16_8 n_9_17_8 2894.7749695659745
R9088 n_9_16_8 n_9_16_9 0.42978864564561553
R9089 n_9_16_9 n_10_16_9 1253.3333167435112
R9090 n_9_16_9 n_9_17_9 2894.7749695659745
R9091 n_9_16_9 n_9_16_10 0.42978864564561553
R9092 n_9_16_10 n_10_16_10 1253.3333167435112
R9093 n_9_16_10 n_9_17_10 2894.7749695659745
R9094 n_9_16_10 n_9_16_11 0.4297886456456128
R9095 n_9_16_11 n_10_16_11 1253.3333167435271
R9096 n_9_16_11 n_9_17_11 2894.7749695660114
R9097 n_9_16_11 n_9_16_12 0.4297886456456114
R9098 n_9_16_12 n_10_16_12 1253.333316743519
R9099 n_9_16_12 n_9_17_12 2894.774969565993
R9100 n_9_16_12 n_9_16_13 0.4297886456456156
R9101 n_9_16_13 n_10_16_13 1253.3333167435032
R9102 n_9_16_13 n_9_17_13 2894.774969565957
R9103 n_9_16_13 n_9_16_14 2.148943228228083
R9104 n_9_16_14 n_10_16_14 139.2592574159454
R9105 n_9_16_14 n_9_17_14 321.6416632851077
R9106 n_9_16_14 n_9_16_15 11.143805597811433
R9107 n_9_16_15 n_10_16_15 6579.999912903355
R9108 n_9_16_15 n_9_17_15 15197.568590221184
R9109 n_9_17_0 n_10_17_0 93.99999875576299
R9110 n_9_17_0 n_9_18_0 217.10812271744777
R9111 n_9_17_0 n_9_17_1 7.598049271234997
R9112 n_9_17_1 n_10_17_1 131.5999982580682
R9113 n_9_17_1 n_9_18_1 303.9513718044269
R9114 n_9_17_1 n_9_17_2 17.268293798261354
R9115 n_9_17_2 n_10_17_2 234.99999688940753
R9116 n_9_17_2 n_9_18_2 542.7703067936194
R9117 n_9_17_2 n_9_17_3 16.16312299517263
R9118 n_9_17_3 n_10_17_3 3289.999956451703
R9119 n_9_17_3 n_9_18_3 7598.784295110665
R9120 n_9_17_3 n_9_17_4 0.21489432282280818
R9121 n_9_17_4 n_10_17_4 99.69696837732431
R9122 n_9_17_4 n_9_18_4 230.26619076092922
R9123 n_9_17_4 n_9_17_5 0.21489432282280818
R9124 n_9_17_5 n_10_17_5 3289.999956451703
R9125 n_9_17_5 n_9_18_5 7598.784295110665
R9126 n_9_17_5 n_9_17_6 0.41443905115827295
R9127 n_9_17_6 n_10_17_6 731.1111014337116
R9128 n_9_17_6 n_9_18_6 1688.6187322468143
R9129 n_9_17_6 n_9_17_7 0.5832845905190501
R9130 n_9_17_7 n_10_17_7 1253.3333167435094
R9131 n_9_17_7 n_9_18_7 2894.7749695659763
R9132 n_9_17_7 n_9_17_8 0.42978864564561503
R9133 n_9_17_8 n_10_17_8 1253.3333167435094
R9134 n_9_17_8 n_9_18_8 2894.7749695659763
R9135 n_9_17_8 n_9_17_9 0.42978864564561503
R9136 n_9_17_9 n_10_17_9 1253.3333167435094
R9137 n_9_17_9 n_9_18_9 2894.7749695659763
R9138 n_9_17_9 n_9_17_10 0.42978864564561503
R9139 n_9_17_10 n_10_17_10 1253.3333167435094
R9140 n_9_17_10 n_9_18_10 2894.7749695659763
R9141 n_9_17_10 n_9_17_11 0.42978864564561226
R9142 n_9_17_11 n_10_17_11 1253.3333167435258
R9143 n_9_17_11 n_9_18_11 2894.774969566013
R9144 n_9_17_11 n_9_17_12 0.4297886456456109
R9145 n_9_17_12 n_10_17_12 1253.3333167435176
R9146 n_9_17_12 n_9_18_12 2894.774969565995
R9147 n_9_17_12 n_9_17_13 0.42978864564561503
R9148 n_9_17_13 n_10_17_13 1253.3333167435017
R9149 n_9_17_13 n_9_18_13 2894.774969565958
R9150 n_9_17_13 n_9_17_14 2.1489432282280805
R9151 n_9_17_14 n_10_17_14 139.25925741594523
R9152 n_9_17_14 n_9_18_14 321.6416632851079
R9153 n_9_17_14 n_9_17_15 11.143805597811417
R9154 n_9_17_15 n_10_17_15 6579.999912903348
R9155 n_9_17_15 n_9_18_15 15197.568590221195
R9156 n_9_18_0 n_10_18_0 93.99999875576299
R9157 n_9_18_0 n_9_19_0 217.10812271744766
R9158 n_9_18_0 n_9_18_1 7.598049271234997
R9159 n_9_18_1 n_10_18_1 131.5999982580682
R9160 n_9_18_1 n_9_19_1 303.9513718044267
R9161 n_9_18_1 n_9_18_2 17.268293798261354
R9162 n_9_18_2 n_10_18_2 234.99999688940753
R9163 n_9_18_2 n_9_19_2 542.770306793619
R9164 n_9_18_2 n_9_18_3 16.16312299517263
R9165 n_9_18_3 n_10_18_3 3289.999956451703
R9166 n_9_18_3 n_9_19_3 7598.78429511066
R9167 n_9_18_3 n_9_18_4 0.21489432282280818
R9168 n_9_18_4 n_10_18_4 99.69696837732431
R9169 n_9_18_4 n_9_19_4 230.26619076092908
R9170 n_9_18_4 n_9_18_5 0.21489432282280818
R9171 n_9_18_5 n_10_18_5 3289.999956451703
R9172 n_9_18_5 n_9_19_5 7598.78429511066
R9173 n_9_18_5 n_9_18_6 0.41443905115827295
R9174 n_9_18_6 n_10_18_6 731.1111014337116
R9175 n_9_18_6 n_9_19_6 1688.6187322468131
R9176 n_9_18_6 n_9_18_7 0.5832845905190501
R9177 n_9_18_7 n_10_18_7 1253.3333167435094
R9178 n_9_18_7 n_9_19_7 2894.7749695659745
R9179 n_9_18_7 n_9_18_8 0.42978864564561503
R9180 n_9_18_8 n_10_18_8 1253.3333167435094
R9181 n_9_18_8 n_9_19_8 2894.7749695659745
R9182 n_9_18_8 n_9_18_9 0.42978864564561503
R9183 n_9_18_9 n_10_18_9 1253.3333167435094
R9184 n_9_18_9 n_9_19_9 2894.7749695659745
R9185 n_9_18_9 n_9_18_10 0.42978864564561503
R9186 n_9_18_10 n_10_18_10 1253.3333167435094
R9187 n_9_18_10 n_9_19_10 2894.7749695659745
R9188 n_9_18_10 n_9_18_11 0.42978864564561226
R9189 n_9_18_11 n_10_18_11 1253.3333167435258
R9190 n_9_18_11 n_9_19_11 2894.7749695660114
R9191 n_9_18_11 n_9_18_12 0.4297886456456109
R9192 n_9_18_12 n_10_18_12 1253.3333167435176
R9193 n_9_18_12 n_9_19_12 2894.774969565993
R9194 n_9_18_12 n_9_18_13 0.42978864564561503
R9195 n_9_18_13 n_10_18_13 1253.3333167435017
R9196 n_9_18_13 n_9_19_13 2894.774969565957
R9197 n_9_18_13 n_9_18_14 2.1489432282280805
R9198 n_9_18_14 n_10_18_14 139.25925741594523
R9199 n_9_18_14 n_9_19_14 321.6416632851077
R9200 n_9_18_14 n_9_18_15 11.143805597811417
R9201 n_9_18_15 n_10_18_15 6579.999912903348
R9202 n_9_18_15 n_9_19_15 15197.568590221184
R9203 n_9_19_0 n_10_19_0 93.99999875576313
R9204 n_9_19_0 n_9_20_0 110.44365396273237
R9205 n_9_19_0 n_9_19_1 7.5980492712350065
R9206 n_9_19_1 n_10_19_1 131.59999825806835
R9207 n_9_19_1 n_9_20_1 154.62111554782533
R9208 n_9_19_1 n_9_19_2 17.26829379826138
R9209 n_9_19_2 n_10_19_2 234.9999968894078
R9210 n_9_19_2 n_9_20_2 276.10913490683095
R9211 n_9_19_2 n_9_19_3 16.16312299517265
R9212 n_9_19_3 n_10_19_3 3289.9999564517066
R9213 n_9_19_3 n_9_20_3 3865.5278886956294
R9214 n_9_19_3 n_9_19_4 0.21489432282280846
R9215 n_9_19_4 n_10_19_4 99.69696837732442
R9216 n_9_19_4 n_9_20_4 117.13720874835239
R9217 n_9_19_4 n_9_19_5 0.21489432282280846
R9218 n_9_19_5 n_10_19_5 3289.9999564517066
R9219 n_9_19_5 n_9_19_6 0.41443905115827345
R9220 n_9_19_6 n_10_19_6 731.1111014337125
R9221 n_9_19_6 n_9_19_7 0.5832845905190508
R9222 n_9_19_7 n_10_19_7 1253.3333167435112
R9223 n_9_19_7 n_9_19_8 0.42978864564561553
R9224 n_9_19_8 n_10_19_8 1253.3333167435112
R9225 n_9_19_8 n_9_19_9 0.42978864564561553
R9226 n_9_19_9 n_10_19_9 1253.3333167435112
R9227 n_9_19_9 n_9_19_10 0.42978864564561553
R9228 n_9_19_10 n_10_19_10 1253.3333167435112
R9229 n_9_19_10 n_9_19_11 0.4297886456456128
R9230 n_9_19_11 n_10_19_11 1253.3333167435271
R9231 n_9_19_11 n_9_19_12 0.4297886456456114
R9232 n_9_19_12 n_10_19_12 1253.333316743519
R9233 n_9_19_12 n_9_19_13 0.4297886456456156
R9234 n_9_19_13 n_10_19_13 1253.3333167435032
R9235 n_9_19_13 n_9_19_14 2.148943228228083
R9236 n_9_19_14 n_10_19_14 139.2592574159454
R9237 n_9_19_14 n_9_19_15 11.143805597811433
R9238 n_9_19_15 n_10_19_15 6579.999912903355
R9239 n_9_19_15 n_9_20_15 7731.05577739119
R9240 n_9_20_0 n_10_20_0 5400.149011488476
R9241 n_9_20_0 n_9_21_0 3.7791852080172323
R9242 n_9_20_0 n_9_20_1 436.49573196175044
R9243 n_9_20_1 n_10_20_1 7560.208616083866
R9244 n_9_20_1 n_9_21_1 5.290859291224126
R9245 n_9_20_1 n_9_20_2 992.0357544585238
R9246 n_9_20_2 n_10_20_2 13500.372528721193
R9247 n_9_20_2 n_9_21_2 9.447963020043082
R9248 n_9_20_2 n_9_20_3 928.5454661731783
R9249 n_9_20_3 n_10_20_3 189005.2154020965
R9250 n_9_20_3 n_9_21_3 132.271482280603
R9251 n_9_20_3 n_9_20_4 12.34533383326164
R9252 n_9_20_4 n_10_20_4 5727.430769760502
R9253 n_9_20_4 n_9_21_4 4.008226735775849
R9254 n_9_20_15 n_10_20_15 378010.43080418964
R9255 n_9_20_15 n_9_21_15 264.5429645612037
R9256 n_9_21_0 n_10_21_0 5400.149011488476
R9257 n_9_21_0 n_9_22_0 3.7791852080170982
R9258 n_9_21_0 n_9_21_1 436.49573196175044
R9259 n_9_21_1 n_10_21_1 7560.208616083866
R9260 n_9_21_1 n_9_22_1 5.2908592912239385
R9261 n_9_21_1 n_9_21_2 992.0357544585238
R9262 n_9_21_2 n_10_21_2 13500.372528721193
R9263 n_9_21_2 n_9_22_2 9.447963020042746
R9264 n_9_21_2 n_9_21_3 928.5454661731783
R9265 n_9_21_3 n_10_21_3 189005.2154020965
R9266 n_9_21_3 n_9_22_3 132.27148228059832
R9267 n_9_21_3 n_9_21_4 12.34533383326164
R9268 n_9_21_4 n_10_21_4 5727.430769760502
R9269 n_9_21_4 n_9_22_4 4.008226735775706
R9270 n_9_21_15 n_10_21_15 378010.43080418964
R9271 n_9_21_15 n_9_22_15 264.54296456119425
R9272 n_9_22_0 n_10_22_0 5400.14901148886
R9273 n_9_22_0 n_9_23_0 3.7791852080170982
R9274 n_9_22_0 n_9_22_1 436.4957319617814
R9275 n_9_22_1 n_10_22_1 7560.208616084405
R9276 n_9_22_1 n_9_23_1 5.2908592912239385
R9277 n_9_22_1 n_9_22_2 992.0357544585942
R9278 n_9_22_2 n_10_22_2 13500.372528722151
R9279 n_9_22_2 n_9_23_2 9.447963020042746
R9280 n_9_22_2 n_9_22_3 928.5454661732442
R9281 n_9_22_3 n_10_22_3 189005.21540210996
R9282 n_9_22_3 n_9_23_3 132.27148228059832
R9283 n_9_22_3 n_9_22_4 12.345333833262517
R9284 n_9_22_4 n_10_22_4 5727.430769760907
R9285 n_9_22_4 n_9_23_4 4.008226735775706
R9286 n_9_22_15 n_10_22_15 378010.43080421654
R9287 n_9_22_15 n_9_23_15 264.54296456119425
R9288 n_9_23_0 n_10_23_0 5400.149011488476
R9289 n_9_23_0 n_9_24_0 43.561715134360036
R9290 n_9_23_0 n_9_23_1 436.49573196175044
R9291 n_9_23_1 n_10_23_1 7560.208616083866
R9292 n_9_23_1 n_9_24_1 60.98640118810405
R9293 n_9_23_1 n_9_23_2 992.0357544585238
R9294 n_9_23_2 n_10_23_2 13500.372528721193
R9295 n_9_23_2 n_9_24_2 108.90428783590009
R9296 n_9_23_2 n_9_23_3 928.5454661731783
R9297 n_9_23_3 n_10_23_3 189005.2154020965
R9298 n_9_23_3 n_9_24_3 1524.6600297025998
R9299 n_9_23_3 n_9_23_4 12.34533383326164
R9300 n_9_23_4 n_10_23_4 5727.430769760502
R9301 n_9_23_4 n_9_24_4 46.20181908189696
R9302 n_9_23_15 n_10_23_15 378010.43080418964
R9303 n_9_23_15 n_9_24_15 3049.3200594051723
R9304 n_9_24_0 n_10_24_0 244.86589626484803
R9305 n_9_24_0 n_9_25_0 83.34424506070269
R9306 n_9_24_0 n_9_24_1 19.79258690736278
R9307 n_9_24_1 n_10_24_1 342.81225477078726
R9308 n_9_24_1 n_9_25_1 116.68194308498379
R9309 n_9_24_1 n_9_24_2 44.98315206218814
R9310 n_9_24_2 n_10_24_2 612.1647406621202
R9311 n_9_24_2 n_9_25_2 208.36061265175675
R9312 n_9_24_2 n_9_24_3 42.104230330208104
R9313 n_9_24_3 n_10_24_3 8570.306369269674
R9314 n_9_24_3 n_9_25_3 2917.048577124592
R9315 n_9_24_3 n_9_24_4 0.5597903367738973
R9316 n_9_24_4 n_10_24_4 259.70625361423254
R9317 n_9_24_4 n_9_25_4 88.39541142801792
R9318 n_9_24_4 n_9_24_5 0.462683849782507
R9319 n_9_24_5 n_10_24_5 1632.4393084323187
R9320 n_9_24_5 n_9_25_5 555.6283004046841
R9321 n_9_24_5 n_9_24_6 0.15994009622111352
R9322 n_9_24_6 n_10_24_6 272.0732180720531
R9323 n_9_24_6 n_9_25_6 92.60471673411402
R9324 n_9_24_6 n_9_24_7 0.21706155915722525
R9325 n_9_24_7 n_10_24_7 466.4112309806639
R9326 n_9_24_7 n_9_25_7 158.75094297276735
R9327 n_9_24_7 n_9_24_8 0.15994009622111302
R9328 n_9_24_8 n_10_24_8 466.4112309806639
R9329 n_9_24_8 n_9_25_8 158.75094297276735
R9330 n_9_24_8 n_9_24_9 0.15994009622111302
R9331 n_9_24_9 n_10_24_9 466.4112309806639
R9332 n_9_24_9 n_9_25_9 158.75094297276735
R9333 n_9_24_9 n_9_24_10 0.15994009622111302
R9334 n_9_24_10 n_10_24_10 466.4112309806639
R9335 n_9_24_10 n_9_25_10 158.75094297276735
R9336 n_9_24_10 n_9_24_11 0.159940096221112
R9337 n_9_24_11 n_10_24_11 466.41123098066987
R9338 n_9_24_11 n_9_25_11 158.7509429727694
R9339 n_9_24_11 n_9_24_12 0.1599400962211115
R9340 n_9_24_12 n_10_24_12 466.4112309806669
R9341 n_9_24_12 n_9_25_12 158.75094297276843
R9342 n_9_24_12 n_9_24_13 0.15994009622111302
R9343 n_9_24_13 n_10_24_13 466.411230980661
R9344 n_9_24_13 n_9_25_13 158.75094297276638
R9345 n_9_24_13 n_9_24_14 0.799700481105567
R9346 n_9_24_14 n_10_24_14 51.823470108962546
R9347 n_9_24_14 n_9_25_14 17.638993663640782
R9348 n_9_24_14 n_9_24_15 24.710744866162255
R9349 n_9_24_15 n_10_24_15 17140.612738539192
R9350 n_9_24_15 n_9_25_15 5834.097154249132
R9351 n_9_25_0 n_10_25_0 244.86589626484883
R9352 n_9_25_0 n_9_26_0 83.34424506070269
R9353 n_9_25_0 n_9_25_1 19.792586907362846
R9354 n_9_25_1 n_10_25_1 342.8122547707883
R9355 n_9_25_1 n_9_26_1 116.68194308498379
R9356 n_9_25_1 n_9_25_2 44.98315206218829
R9357 n_9_25_2 n_10_25_2 612.1647406621221
R9358 n_9_25_2 n_9_26_2 208.36061265175675
R9359 n_9_25_2 n_9_25_3 42.10423033020824
R9360 n_9_25_3 n_10_25_3 8570.306369269701
R9361 n_9_25_3 n_9_26_3 2917.048577124592
R9362 n_9_25_3 n_9_25_4 0.5597903367738992
R9363 n_9_25_4 n_10_25_4 259.7062536142334
R9364 n_9_25_4 n_9_26_4 88.39541142801792
R9365 n_9_25_4 n_9_25_5 0.46268384978250854
R9366 n_9_25_5 n_10_25_5 1632.4393084323237
R9367 n_9_25_5 n_9_26_5 555.6283004046841
R9368 n_9_25_5 n_9_25_6 0.15994009622111405
R9369 n_9_25_6 n_10_25_6 272.07321807205403
R9370 n_9_25_6 n_9_26_6 92.60471673411402
R9371 n_9_25_6 n_9_25_7 0.21706155915722597
R9372 n_9_25_7 n_10_25_7 466.4112309806655
R9373 n_9_25_7 n_9_26_7 158.75094297276735
R9374 n_9_25_7 n_9_25_8 0.15994009622111355
R9375 n_9_25_8 n_10_25_8 466.4112309806655
R9376 n_9_25_8 n_9_26_8 158.75094297276735
R9377 n_9_25_8 n_9_25_9 0.15994009622111355
R9378 n_9_25_9 n_10_25_9 466.4112309806655
R9379 n_9_25_9 n_9_26_9 158.75094297276735
R9380 n_9_25_9 n_9_25_10 0.15994009622111355
R9381 n_9_25_10 n_10_25_10 466.4112309806655
R9382 n_9_25_10 n_9_26_10 158.75094297276735
R9383 n_9_25_10 n_9_25_11 0.15994009622111255
R9384 n_9_25_11 n_10_25_11 466.4112309806714
R9385 n_9_25_11 n_9_26_11 158.7509429727694
R9386 n_9_25_11 n_9_25_12 0.15994009622111202
R9387 n_9_25_12 n_10_25_12 466.4112309806683
R9388 n_9_25_12 n_9_26_12 158.75094297276843
R9389 n_9_25_12 n_9_25_13 0.15994009622111355
R9390 n_9_25_13 n_10_25_13 466.41123098066254
R9391 n_9_25_13 n_9_26_13 158.75094297276638
R9392 n_9_25_13 n_9_25_14 0.7997004811055698
R9393 n_9_25_14 n_10_25_14 51.82347010896271
R9394 n_9_25_14 n_9_26_14 17.638993663640782
R9395 n_9_25_14 n_9_25_15 24.710744866162337
R9396 n_9_25_15 n_10_25_15 17140.612738539246
R9397 n_9_25_15 n_9_26_15 5834.097154249132
R9398 n_9_26_0 n_10_26_0 244.86589626484803
R9399 n_9_26_0 n_9_27_0 83.34424506070283
R9400 n_9_26_0 n_9_26_1 19.79258690736278
R9401 n_9_26_1 n_10_26_1 342.81225477078726
R9402 n_9_26_1 n_9_27_1 116.68194308498397
R9403 n_9_26_1 n_9_26_2 44.98315206218814
R9404 n_9_26_2 n_10_26_2 612.1647406621202
R9405 n_9_26_2 n_9_27_2 208.3606126517571
R9406 n_9_26_2 n_9_26_3 42.104230330208104
R9407 n_9_26_3 n_10_26_3 8570.306369269674
R9408 n_9_26_3 n_9_27_3 2917.0485771245967
R9409 n_9_26_3 n_9_26_4 0.5597903367738973
R9410 n_9_26_4 n_10_26_4 259.70625361423254
R9411 n_9_26_4 n_9_27_4 88.39541142801806
R9412 n_9_26_4 n_9_26_5 0.462683849782507
R9413 n_9_26_5 n_10_26_5 1632.4393084323187
R9414 n_9_26_5 n_9_27_5 555.628300404685
R9415 n_9_26_5 n_9_26_6 0.15994009622111352
R9416 n_9_26_6 n_10_26_6 272.0732180720531
R9417 n_9_26_6 n_9_27_6 92.60471673411416
R9418 n_9_26_6 n_9_26_7 0.21706155915722525
R9419 n_9_26_7 n_10_26_7 466.4112309806639
R9420 n_9_26_7 n_9_27_7 158.7509429727676
R9421 n_9_26_7 n_9_26_8 0.15994009622111302
R9422 n_9_26_8 n_10_26_8 466.4112309806639
R9423 n_9_26_8 n_9_27_8 158.7509429727676
R9424 n_9_26_8 n_9_26_9 0.15994009622111302
R9425 n_9_26_9 n_10_26_9 466.4112309806639
R9426 n_9_26_9 n_9_27_9 158.7509429727676
R9427 n_9_26_9 n_9_26_10 0.15994009622111302
R9428 n_9_26_10 n_10_26_10 466.4112309806639
R9429 n_9_26_10 n_9_27_10 158.7509429727676
R9430 n_9_26_10 n_9_26_11 0.159940096221112
R9431 n_9_26_11 n_10_26_11 466.41123098066987
R9432 n_9_26_11 n_9_27_11 158.75094297276965
R9433 n_9_26_11 n_9_26_12 0.1599400962211115
R9434 n_9_26_12 n_10_26_12 466.4112309806669
R9435 n_9_26_12 n_9_27_12 158.75094297276866
R9436 n_9_26_12 n_9_26_13 0.15994009622111302
R9437 n_9_26_13 n_10_26_13 466.411230980661
R9438 n_9_26_13 n_9_27_13 158.75094297276664
R9439 n_9_26_13 n_9_26_14 0.799700481105567
R9440 n_9_26_14 n_10_26_14 51.823470108962546
R9441 n_9_26_14 n_9_27_14 17.63899366364081
R9442 n_9_26_14 n_9_26_15 24.710744866162255
R9443 n_9_26_15 n_10_26_15 17140.612738539192
R9444 n_9_26_15 n_9_27_15 5834.097154249141
R9445 n_9_27_0 n_10_27_0 244.86589626484803
R9446 n_9_27_0 n_9_27_1 19.79258690736278
R9447 n_9_27_1 n_10_27_1 342.81225477078726
R9448 n_9_27_1 n_9_27_2 44.98315206218814
R9449 n_9_27_2 n_10_27_2 612.1647406621202
R9450 n_9_27_2 n_9_27_3 42.104230330208104
R9451 n_9_27_3 n_10_27_3 8570.306369269674
R9452 n_9_27_3 n_9_27_4 0.5597903367738973
R9453 n_9_27_4 n_10_27_4 259.70625361423254
R9454 n_9_27_4 n_9_27_5 0.462683849782507
R9455 n_9_27_5 n_10_27_5 1632.4393084323187
R9456 n_9_27_5 n_9_27_6 0.15994009622111352
R9457 n_9_27_6 n_10_27_6 272.0732180720531
R9458 n_9_27_6 n_9_27_7 0.21706155915722525
R9459 n_9_27_7 n_10_27_7 466.4112309806639
R9460 n_9_27_7 n_9_27_8 0.15994009622111302
R9461 n_9_27_8 n_10_27_8 466.4112309806639
R9462 n_9_27_8 n_9_27_9 0.15994009622111302
R9463 n_9_27_9 n_10_27_9 466.4112309806639
R9464 n_9_27_9 n_9_27_10 0.15994009622111302
R9465 n_9_27_10 n_10_27_10 466.4112309806639
R9466 n_9_27_10 n_9_27_11 0.159940096221112
R9467 n_9_27_11 n_10_27_11 466.41123098066987
R9468 n_9_27_11 n_9_27_12 0.1599400962211115
R9469 n_9_27_12 n_10_27_12 466.4112309806669
R9470 n_9_27_12 n_9_27_13 0.15994009622111302
R9471 n_9_27_13 n_10_27_13 466.411230980661
R9472 n_9_27_13 n_9_27_14 0.799700481105567
R9473 n_9_27_14 n_10_27_14 51.823470108962546
R9474 n_9_27_14 n_9_27_15 24.710744866162255
R9475 n_9_27_15 n_10_27_15 17140.612738539192
R9476 n_10_0_0 n_11_0_0 244.86587517703651
R9477 n_10_0_0 n_10_1_0 83.34425223829638
R9478 n_10_0_0 n_10_0_1 19.792585202828377
R9479 n_10_0_1 n_11_0_1 342.8122252478511
R9480 n_10_0_1 n_10_1_1 116.68195313361493
R9481 n_10_0_1 n_10_0_2 44.983148188246304
R9482 n_10_0_2 n_11_0_2 612.1646879425912
R9483 n_10_0_2 n_10_1_2 208.36063059574093
R9484 n_10_0_2 n_10_0_3 42.104226704198545
R9485 n_10_0_3 n_11_0_3 8570.305631196268
R9486 n_10_0_3 n_10_1_3 2917.04882834037
R9487 n_10_0_3 n_10_0_4 0.5597902885648435
R9488 n_10_0_4 n_11_0_4 259.7062312483718
R9489 n_10_0_4 n_10_1_4 88.3954190406173
R9490 n_10_0_4 n_10_0_5 0.46268380993624825
R9491 n_10_0_5 n_11_0_5 1632.4391678469083
R9492 n_10_0_5 n_10_1_5 555.6283482553085
R9493 n_10_0_5 n_10_0_6 0.15994008244709815
R9494 n_10_0_6 n_11_0_6 272.0731946411514
R9495 n_10_0_6 n_10_1_6 92.6047247092181
R9496 n_10_0_6 n_10_0_7 0.21706154046391865
R9497 n_10_0_7 n_11_0_7 466.41119081340383
R9498 n_10_0_7 n_10_1_7 158.75095664437438
R9499 n_10_0_7 n_10_0_8 0.15994008244709762
R9500 n_10_0_8 n_11_0_8 466.41119081340383
R9501 n_10_0_8 n_10_1_8 158.75095664437438
R9502 n_10_0_8 n_10_0_9 0.15994008244709762
R9503 n_10_0_9 n_11_0_9 466.41119081340383
R9504 n_10_0_9 n_10_1_9 158.75095664437438
R9505 n_10_0_9 n_10_0_10 0.15994008244709762
R9506 n_10_0_10 n_11_0_10 466.41119081340383
R9507 n_10_0_10 n_10_1_10 158.75095664437438
R9508 n_10_0_10 n_10_0_11 0.15994008244709662
R9509 n_10_0_11 n_11_0_11 466.4111908134098
R9510 n_10_0_11 n_10_1_11 158.75095664437643
R9511 n_10_0_11 n_10_0_12 0.15994008244709612
R9512 n_10_0_12 n_11_0_12 466.41119081340696
R9513 n_10_0_12 n_10_1_12 158.7509566443754
R9514 n_10_0_12 n_10_0_13 0.15994008244709762
R9515 n_10_0_13 n_11_0_13 466.41119081340094
R9516 n_10_0_13 n_10_1_13 158.7509566443734
R9517 n_10_0_13 n_10_0_14 0.7997004122354902
R9518 n_10_0_14 n_11_0_14 51.82346564593365
R9519 n_10_0_14 n_10_1_14 17.63899518270823
R9520 n_10_0_14 n_10_0_15 24.710742738076874
R9521 n_10_0_15 n_11_0_15 17140.611262392384
R9522 n_10_0_15 n_10_1_15 5834.0976566806885
R9523 n_10_1_0 n_11_1_0 244.86587517703651
R9524 n_10_1_0 n_10_2_0 83.34425223829638
R9525 n_10_1_0 n_10_1_1 19.792585202828377
R9526 n_10_1_1 n_11_1_1 342.8122252478511
R9527 n_10_1_1 n_10_2_1 116.68195313361493
R9528 n_10_1_1 n_10_1_2 44.983148188246304
R9529 n_10_1_2 n_11_1_2 612.1646879425912
R9530 n_10_1_2 n_10_2_2 208.36063059574093
R9531 n_10_1_2 n_10_1_3 42.104226704198545
R9532 n_10_1_3 n_11_1_3 8570.305631196268
R9533 n_10_1_3 n_10_2_3 2917.04882834037
R9534 n_10_1_3 n_10_1_4 0.5597902885648435
R9535 n_10_1_4 n_11_1_4 259.7062312483718
R9536 n_10_1_4 n_10_2_4 88.3954190406173
R9537 n_10_1_4 n_10_1_5 0.46268380993624825
R9538 n_10_1_5 n_11_1_5 1632.4391678469083
R9539 n_10_1_5 n_10_2_5 555.6283482553085
R9540 n_10_1_5 n_10_1_6 0.15994008244709815
R9541 n_10_1_6 n_11_1_6 272.0731946411514
R9542 n_10_1_6 n_10_2_6 92.6047247092181
R9543 n_10_1_6 n_10_1_7 0.21706154046391865
R9544 n_10_1_7 n_11_1_7 466.41119081340383
R9545 n_10_1_7 n_10_2_7 158.75095664437438
R9546 n_10_1_7 n_10_1_8 0.15994008244709762
R9547 n_10_1_8 n_11_1_8 466.41119081340383
R9548 n_10_1_8 n_10_2_8 158.75095664437438
R9549 n_10_1_8 n_10_1_9 0.15994008244709762
R9550 n_10_1_9 n_11_1_9 466.41119081340383
R9551 n_10_1_9 n_10_2_9 158.75095664437438
R9552 n_10_1_9 n_10_1_10 0.15994008244709762
R9553 n_10_1_10 n_11_1_10 466.41119081340383
R9554 n_10_1_10 n_10_2_10 158.75095664437438
R9555 n_10_1_10 n_10_1_11 0.15994008244709662
R9556 n_10_1_11 n_11_1_11 466.4111908134098
R9557 n_10_1_11 n_10_2_11 158.75095664437643
R9558 n_10_1_11 n_10_1_12 0.15994008244709612
R9559 n_10_1_12 n_11_1_12 466.41119081340696
R9560 n_10_1_12 n_10_2_12 158.7509566443754
R9561 n_10_1_12 n_10_1_13 0.15994008244709762
R9562 n_10_1_13 n_11_1_13 466.41119081340094
R9563 n_10_1_13 n_10_2_13 158.7509566443734
R9564 n_10_1_13 n_10_1_14 0.7997004122354902
R9565 n_10_1_14 n_11_1_14 51.82346564593365
R9566 n_10_1_14 n_10_2_14 17.63899518270823
R9567 n_10_1_14 n_10_1_15 24.710742738076874
R9568 n_10_1_15 n_11_1_15 17140.611262392384
R9569 n_10_1_15 n_10_2_15 5834.0976566806885
R9570 n_10_2_0 n_11_2_0 244.86587517703651
R9571 n_10_2_0 n_10_3_0 83.34425223829638
R9572 n_10_2_0 n_10_2_1 19.792585202828377
R9573 n_10_2_1 n_11_2_1 342.8122252478511
R9574 n_10_2_1 n_10_3_1 116.68195313361493
R9575 n_10_2_1 n_10_2_2 44.983148188246304
R9576 n_10_2_2 n_11_2_2 612.1646879425912
R9577 n_10_2_2 n_10_3_2 208.36063059574093
R9578 n_10_2_2 n_10_2_3 42.104226704198545
R9579 n_10_2_3 n_11_2_3 8570.305631196268
R9580 n_10_2_3 n_10_3_3 2917.04882834037
R9581 n_10_2_3 n_10_2_4 0.5597902885648435
R9582 n_10_2_4 n_11_2_4 259.7062312483718
R9583 n_10_2_4 n_10_3_4 88.3954190406173
R9584 n_10_2_4 n_10_2_5 0.46268380993624825
R9585 n_10_2_5 n_11_2_5 1632.4391678469083
R9586 n_10_2_5 n_10_3_5 555.6283482553085
R9587 n_10_2_5 n_10_2_6 0.15994008244709815
R9588 n_10_2_6 n_11_2_6 272.0731946411514
R9589 n_10_2_6 n_10_3_6 92.6047247092181
R9590 n_10_2_6 n_10_2_7 0.21706154046391865
R9591 n_10_2_7 n_11_2_7 466.41119081340383
R9592 n_10_2_7 n_10_3_7 158.75095664437438
R9593 n_10_2_7 n_10_2_8 0.15994008244709762
R9594 n_10_2_8 n_11_2_8 466.41119081340383
R9595 n_10_2_8 n_10_3_8 158.75095664437438
R9596 n_10_2_8 n_10_2_9 0.15994008244709762
R9597 n_10_2_9 n_11_2_9 466.41119081340383
R9598 n_10_2_9 n_10_3_9 158.75095664437438
R9599 n_10_2_9 n_10_2_10 0.15994008244709762
R9600 n_10_2_10 n_11_2_10 466.41119081340383
R9601 n_10_2_10 n_10_3_10 158.75095664437438
R9602 n_10_2_10 n_10_2_11 0.15994008244709662
R9603 n_10_2_11 n_11_2_11 466.4111908134098
R9604 n_10_2_11 n_10_3_11 158.75095664437643
R9605 n_10_2_11 n_10_2_12 0.15994008244709612
R9606 n_10_2_12 n_11_2_12 466.41119081340696
R9607 n_10_2_12 n_10_3_12 158.7509566443754
R9608 n_10_2_12 n_10_2_13 0.15994008244709762
R9609 n_10_2_13 n_11_2_13 466.41119081340094
R9610 n_10_2_13 n_10_3_13 158.7509566443734
R9611 n_10_2_13 n_10_2_14 0.7997004122354902
R9612 n_10_2_14 n_11_2_14 51.82346564593365
R9613 n_10_2_14 n_10_3_14 17.63899518270823
R9614 n_10_2_14 n_10_2_15 24.710742738076874
R9615 n_10_2_15 n_11_2_15 17140.611262392384
R9616 n_10_2_15 n_10_3_15 5834.0976566806885
R9617 n_10_3_0 n_11_3_0 244.86587517703651
R9618 n_10_3_0 n_10_4_0 43.561715134359915
R9619 n_10_3_0 n_10_3_1 19.792585202828377
R9620 n_10_3_1 n_11_3_1 342.8122252478511
R9621 n_10_3_1 n_10_4_1 60.986401188103876
R9622 n_10_3_1 n_10_3_2 44.983148188246304
R9623 n_10_3_2 n_11_3_2 612.1646879425912
R9624 n_10_3_2 n_10_4_2 108.90428783589978
R9625 n_10_3_2 n_10_3_3 42.104226704198545
R9626 n_10_3_3 n_11_3_3 8570.305631196268
R9627 n_10_3_3 n_10_4_3 1524.6600297025955
R9628 n_10_3_3 n_10_3_4 0.5597902885648435
R9629 n_10_3_4 n_11_3_4 259.7062312483718
R9630 n_10_3_4 n_10_4_4 46.20181908189684
R9631 n_10_3_4 n_10_3_5 0.46268380993624825
R9632 n_10_3_5 n_11_3_5 1632.4391678469083
R9633 n_10_3_5 n_10_3_6 0.15994008244709815
R9634 n_10_3_6 n_11_3_6 272.0731946411514
R9635 n_10_3_6 n_10_3_7 0.21706154046391865
R9636 n_10_3_7 n_11_3_7 466.41119081340383
R9637 n_10_3_7 n_10_3_8 0.15994008244709762
R9638 n_10_3_8 n_11_3_8 466.41119081340383
R9639 n_10_3_8 n_10_3_9 0.15994008244709762
R9640 n_10_3_9 n_11_3_9 466.41119081340383
R9641 n_10_3_9 n_10_3_10 0.15994008244709762
R9642 n_10_3_10 n_11_3_10 466.41119081340383
R9643 n_10_3_10 n_10_3_11 0.15994008244709662
R9644 n_10_3_11 n_11_3_11 466.4111908134098
R9645 n_10_3_11 n_10_3_12 0.15994008244709612
R9646 n_10_3_12 n_11_3_12 466.41119081340696
R9647 n_10_3_12 n_10_3_13 0.15994008244709762
R9648 n_10_3_13 n_11_3_13 466.41119081340094
R9649 n_10_3_13 n_10_3_14 0.7997004122354902
R9650 n_10_3_14 n_11_3_14 51.82346564593365
R9651 n_10_3_14 n_10_3_15 24.710742738076874
R9652 n_10_3_15 n_11_3_15 17140.611262392384
R9653 n_10_3_15 n_10_4_15 3049.3200594051636
R9654 n_10_4_0 n_11_4_0 5400.15926770706
R9655 n_10_4_0 n_10_5_0 3.779178030423486
R9656 n_10_4_0 n_10_4_1 436.49656097510314
R9657 n_10_4_1 n_11_4_1 7560.2229747898855
R9658 n_10_4_1 n_10_5_1 5.29084924259288
R9659 n_10_4_1 n_10_4_2 992.0376385797799
R9660 n_10_4_2 n_11_4_2 13500.398169267653
R9661 n_10_4_2 n_10_5_2 9.447945076058712
R9662 n_10_4_2 n_10_4_3 928.547229710674
R9663 n_10_4_3 n_11_4_3 189005.57436974702
R9664 n_10_4_3 n_10_5_3 132.27123106482185
R9665 n_10_4_3 n_10_4_4 12.345357280103938
R9666 n_10_4_4 n_11_4_4 5727.44164756809
R9667 n_10_4_4 n_10_5_4 4.008219123176421
R9668 n_10_4_15 n_11_4_15 378011.14873949066
R9669 n_10_4_15 n_10_5_15 264.54246212964136
R9670 n_10_5_0 n_11_5_0 5400.159267706966
R9671 n_10_5_0 n_10_6_0 3.779178030423519
R9672 n_10_5_0 n_10_5_1 436.49656097509535
R9673 n_10_5_1 n_11_5_1 7560.222974789751
R9674 n_10_5_1 n_10_6_1 5.290849242592927
R9675 n_10_5_1 n_10_5_2 992.0376385797623
R9676 n_10_5_2 n_11_5_2 13500.398169267413
R9677 n_10_5_2 n_10_6_2 9.447945076058797
R9678 n_10_5_2 n_10_5_3 928.5472297106575
R9679 n_10_5_3 n_11_5_3 189005.57436974364
R9680 n_10_5_3 n_10_6_3 132.271231064823
R9681 n_10_5_3 n_10_5_4 12.34535728010372
R9682 n_10_5_4 n_11_5_4 5727.441647567988
R9683 n_10_5_4 n_10_6_4 4.008219123176456
R9684 n_10_5_15 n_11_5_15 378011.1487394839
R9685 n_10_5_15 n_10_6_15 264.5424621296437
R9686 n_10_6_0 n_11_6_0 5400.159267706966
R9687 n_10_6_0 n_10_7_0 3.779178030423486
R9688 n_10_6_0 n_10_6_1 436.49656097509535
R9689 n_10_6_1 n_11_6_1 7560.222974789751
R9690 n_10_6_1 n_10_7_1 5.29084924259288
R9691 n_10_6_1 n_10_6_2 992.0376385797623
R9692 n_10_6_2 n_11_6_2 13500.398169267413
R9693 n_10_6_2 n_10_7_2 9.447945076058712
R9694 n_10_6_2 n_10_6_3 928.5472297106575
R9695 n_10_6_3 n_11_6_3 189005.57436974364
R9696 n_10_6_3 n_10_7_3 132.27123106482185
R9697 n_10_6_3 n_10_6_4 12.34535728010372
R9698 n_10_6_4 n_11_6_4 5727.441647567988
R9699 n_10_6_4 n_10_7_4 4.008219123176421
R9700 n_10_6_15 n_11_6_15 378011.1487394839
R9701 n_10_6_15 n_10_7_15 264.54246212964136
R9702 n_10_7_0 n_11_7_0 5400.15926770706
R9703 n_10_7_0 n_10_8_0 110.4436503739355
R9704 n_10_7_0 n_10_7_1 436.49656097510314
R9705 n_10_7_1 n_11_7_1 7560.2229747898855
R9706 n_10_7_1 n_10_8_1 154.62111052350969
R9707 n_10_7_1 n_10_7_2 992.0376385797799
R9708 n_10_7_2 n_11_7_2 13500.398169267653
R9709 n_10_7_2 n_10_8_2 276.10912593483874
R9710 n_10_7_2 n_10_7_3 928.547229710674
R9711 n_10_7_3 n_11_7_3 189005.57436974702
R9712 n_10_7_3 n_10_8_3 3865.527763087738
R9713 n_10_7_3 n_10_7_4 12.345357280103938
R9714 n_10_7_4 n_11_7_4 5727.44164756809
R9715 n_10_7_4 n_10_8_4 117.13720494205269
R9716 n_10_7_15 n_11_7_15 378011.14873949066
R9717 n_10_7_15 n_10_8_15 7731.055526175408
R9718 n_10_8_0 n_11_8_0 93.99999875576307
R9719 n_10_8_0 n_10_9_0 217.1081227174476
R9720 n_10_8_0 n_10_8_1 7.5980492712349985
R9721 n_10_8_1 n_11_8_1 131.5999982580683
R9722 n_10_8_1 n_10_9_1 303.9513718044266
R9723 n_10_8_1 n_10_8_2 17.268293798261357
R9724 n_10_8_2 n_11_8_2 234.99999688940767
R9725 n_10_8_2 n_10_9_2 542.7703067936189
R9726 n_10_8_2 n_10_8_3 16.163122995172632
R9727 n_10_8_3 n_11_8_3 3289.9999564517047
R9728 n_10_8_3 n_10_9_3 7598.784295110658
R9729 n_10_8_3 n_10_8_4 0.21489432282280824
R9730 n_10_8_4 n_11_8_4 99.6969683773244
R9731 n_10_8_4 n_10_9_4 230.26619076092908
R9732 n_10_8_4 n_10_8_5 0.21489432282280824
R9733 n_10_8_5 n_11_8_5 3289.9999564517047
R9734 n_10_8_5 n_10_9_5 7598.784295110658
R9735 n_10_8_5 n_10_8_6 0.414439051158273
R9736 n_10_8_6 n_11_8_6 731.1111014337121
R9737 n_10_8_6 n_10_9_6 1688.6187322468131
R9738 n_10_8_6 n_10_8_7 0.5832845905190502
R9739 n_10_8_7 n_11_8_7 1253.3333167435103
R9740 n_10_8_7 n_10_9_7 2894.774969565974
R9741 n_10_8_7 n_10_8_8 0.4297886456456151
R9742 n_10_8_8 n_11_8_8 1253.3333167435103
R9743 n_10_8_8 n_10_9_8 2894.774969565974
R9744 n_10_8_8 n_10_8_9 0.4297886456456151
R9745 n_10_8_9 n_11_8_9 1253.3333167435103
R9746 n_10_8_9 n_10_9_9 2894.774969565974
R9747 n_10_8_9 n_10_8_10 0.4297886456456151
R9748 n_10_8_10 n_11_8_10 1253.3333167435103
R9749 n_10_8_10 n_10_9_10 2894.774969565974
R9750 n_10_8_10 n_10_8_11 0.42978864564561237
R9751 n_10_8_11 n_11_8_11 1253.3333167435262
R9752 n_10_8_11 n_10_9_11 2894.7749695660114
R9753 n_10_8_11 n_10_8_12 0.429788645645611
R9754 n_10_8_12 n_11_8_12 1253.3333167435185
R9755 n_10_8_12 n_10_9_12 2894.7749695659927
R9756 n_10_8_12 n_10_8_13 0.42978864564561514
R9757 n_10_8_13 n_11_8_13 1253.3333167435026
R9758 n_10_8_13 n_10_9_13 2894.774969565956
R9759 n_10_8_13 n_10_8_14 2.148943228228081
R9760 n_10_8_14 n_11_8_14 139.25925741594529
R9761 n_10_8_14 n_10_9_14 321.6416632851076
R9762 n_10_8_14 n_10_8_15 11.143805597811419
R9763 n_10_8_15 n_11_8_15 6579.999912903351
R9764 n_10_8_15 n_10_9_15 15197.56859022118
R9765 n_10_9_0 n_11_9_0 93.99999875576299
R9766 n_10_9_0 n_10_10_0 217.1081227174476
R9767 n_10_9_0 n_10_9_1 7.598049271234992
R9768 n_10_9_1 n_11_9_1 131.5999982580682
R9769 n_10_9_1 n_10_10_1 303.9513718044266
R9770 n_10_9_1 n_10_9_2 17.268293798261347
R9771 n_10_9_2 n_11_9_2 234.99999688940753
R9772 n_10_9_2 n_10_10_2 542.7703067936189
R9773 n_10_9_2 n_10_9_3 16.16312299517262
R9774 n_10_9_3 n_11_9_3 3289.999956451703
R9775 n_10_9_3 n_10_10_3 7598.784295110658
R9776 n_10_9_3 n_10_9_4 0.21489432282280807
R9777 n_10_9_4 n_11_9_4 99.69696837732431
R9778 n_10_9_4 n_10_10_4 230.26619076092908
R9779 n_10_9_4 n_10_9_5 0.21489432282280807
R9780 n_10_9_5 n_11_9_5 3289.999956451703
R9781 n_10_9_5 n_10_10_5 7598.784295110658
R9782 n_10_9_5 n_10_9_6 0.41443905115827273
R9783 n_10_9_6 n_11_9_6 731.1111014337116
R9784 n_10_9_6 n_10_10_6 1688.6187322468131
R9785 n_10_9_6 n_10_9_7 0.5832845905190498
R9786 n_10_9_7 n_11_9_7 1253.3333167435094
R9787 n_10_9_7 n_10_10_7 2894.774969565974
R9788 n_10_9_7 n_10_9_8 0.4297886456456148
R9789 n_10_9_8 n_11_9_8 1253.3333167435094
R9790 n_10_9_8 n_10_10_8 2894.774969565974
R9791 n_10_9_8 n_10_9_9 0.4297886456456148
R9792 n_10_9_9 n_11_9_9 1253.3333167435094
R9793 n_10_9_9 n_10_10_9 2894.774969565974
R9794 n_10_9_9 n_10_9_10 0.4297886456456148
R9795 n_10_9_10 n_11_9_10 1253.3333167435094
R9796 n_10_9_10 n_10_10_10 2894.774969565974
R9797 n_10_9_10 n_10_9_11 0.42978864564561203
R9798 n_10_9_11 n_11_9_11 1253.3333167435258
R9799 n_10_9_11 n_10_10_11 2894.7749695660114
R9800 n_10_9_11 n_10_9_12 0.4297886456456107
R9801 n_10_9_12 n_11_9_12 1253.3333167435176
R9802 n_10_9_12 n_10_10_12 2894.7749695659927
R9803 n_10_9_12 n_10_9_13 0.4297886456456148
R9804 n_10_9_13 n_11_9_13 1253.3333167435017
R9805 n_10_9_13 n_10_10_13 2894.774969565956
R9806 n_10_9_13 n_10_9_14 2.1489432282280796
R9807 n_10_9_14 n_11_9_14 139.25925741594523
R9808 n_10_9_14 n_10_10_14 321.6416632851076
R9809 n_10_9_14 n_10_9_15 11.143805597811413
R9810 n_10_9_15 n_11_9_15 6579.999912903348
R9811 n_10_9_15 n_10_10_15 15197.56859022118
R9812 n_10_10_0 n_11_10_0 93.99999875576307
R9813 n_10_10_0 n_10_11_0 217.10812271744754
R9814 n_10_10_0 n_10_10_1 7.5980492712349985
R9815 n_10_10_1 n_11_10_1 131.5999982580683
R9816 n_10_10_1 n_10_11_1 303.9513718044265
R9817 n_10_10_1 n_10_10_2 17.268293798261357
R9818 n_10_10_2 n_11_10_2 234.99999688940767
R9819 n_10_10_2 n_10_11_2 542.7703067936188
R9820 n_10_10_2 n_10_10_3 16.163122995172632
R9821 n_10_10_3 n_11_10_3 3289.9999564517047
R9822 n_10_10_3 n_10_11_3 7598.784295110656
R9823 n_10_10_3 n_10_10_4 0.21489432282280824
R9824 n_10_10_4 n_11_10_4 99.6969683773244
R9825 n_10_10_4 n_10_11_4 230.266190760929
R9826 n_10_10_4 n_10_10_5 0.21489432282280824
R9827 n_10_10_5 n_11_10_5 3289.9999564517047
R9828 n_10_10_5 n_10_11_5 7598.784295110656
R9829 n_10_10_5 n_10_10_6 0.414439051158273
R9830 n_10_10_6 n_11_10_6 731.1111014337121
R9831 n_10_10_6 n_10_11_6 1688.6187322468124
R9832 n_10_10_6 n_10_10_7 0.5832845905190502
R9833 n_10_10_7 n_11_10_7 1253.3333167435103
R9834 n_10_10_7 n_10_11_7 2894.774969565973
R9835 n_10_10_7 n_10_10_8 0.4297886456456151
R9836 n_10_10_8 n_11_10_8 1253.3333167435103
R9837 n_10_10_8 n_10_11_8 2894.774969565973
R9838 n_10_10_8 n_10_10_9 0.4297886456456151
R9839 n_10_10_9 n_11_10_9 1253.3333167435103
R9840 n_10_10_9 n_10_11_9 2894.774969565973
R9841 n_10_10_9 n_10_10_10 0.4297886456456151
R9842 n_10_10_10 n_11_10_10 1253.3333167435103
R9843 n_10_10_10 n_10_11_10 2894.774969565973
R9844 n_10_10_10 n_10_10_11 0.42978864564561237
R9845 n_10_10_11 n_11_10_11 1253.3333167435262
R9846 n_10_10_11 n_10_11_11 2894.7749695660104
R9847 n_10_10_11 n_10_10_12 0.429788645645611
R9848 n_10_10_12 n_11_10_12 1253.3333167435185
R9849 n_10_10_12 n_10_11_12 2894.774969565992
R9850 n_10_10_12 n_10_10_13 0.42978864564561514
R9851 n_10_10_13 n_11_10_13 1253.3333167435026
R9852 n_10_10_13 n_10_11_13 2894.774969565955
R9853 n_10_10_13 n_10_10_14 2.148943228228081
R9854 n_10_10_14 n_11_10_14 139.25925741594529
R9855 n_10_10_14 n_10_11_14 321.6416632851075
R9856 n_10_10_14 n_10_10_15 11.143805597811419
R9857 n_10_10_15 n_11_10_15 6579.999912903351
R9858 n_10_10_15 n_10_11_15 15197.568590221177
R9859 n_10_11_0 n_11_11_0 93.99999875576307
R9860 n_10_11_0 n_10_12_0 110.44365361735524
R9861 n_10_11_0 n_10_11_1 7.5980492712349985
R9862 n_10_11_1 n_11_11_1 131.5999982580683
R9863 n_10_11_1 n_10_12_1 154.6211150642973
R9864 n_10_11_1 n_10_11_2 17.268293798261357
R9865 n_10_11_2 n_11_11_2 234.99999688940767
R9866 n_10_11_2 n_10_12_2 276.1091340433881
R9867 n_10_11_2 n_10_11_3 16.163122995172632
R9868 n_10_11_3 n_11_11_3 3289.9999564517047
R9869 n_10_11_3 n_10_12_3 3865.5278766074293
R9870 n_10_11_3 n_10_11_4 0.21489432282280824
R9871 n_10_11_4 n_11_11_4 99.6969683773244
R9872 n_10_11_4 n_10_12_4 117.13720838204333
R9873 n_10_11_4 n_10_11_5 0.21489432282280824
R9874 n_10_11_5 n_11_11_5 3289.9999564517047
R9875 n_10_11_5 n_10_11_6 0.414439051158273
R9876 n_10_11_6 n_11_11_6 731.1111014337121
R9877 n_10_11_6 n_10_11_7 0.5832845905190502
R9878 n_10_11_7 n_11_11_7 1253.3333167435103
R9879 n_10_11_7 n_10_11_8 0.4297886456456151
R9880 n_10_11_8 n_11_11_8 1253.3333167435103
R9881 n_10_11_8 n_10_11_9 0.4297886456456151
R9882 n_10_11_9 n_11_11_9 1253.3333167435103
R9883 n_10_11_9 n_10_11_10 0.4297886456456151
R9884 n_10_11_10 n_11_11_10 1253.3333167435103
R9885 n_10_11_10 n_10_11_11 0.42978864564561237
R9886 n_10_11_11 n_11_11_11 1253.3333167435262
R9887 n_10_11_11 n_10_11_12 0.429788645645611
R9888 n_10_11_12 n_11_11_12 1253.3333167435185
R9889 n_10_11_12 n_10_11_13 0.42978864564561514
R9890 n_10_11_13 n_11_11_13 1253.3333167435026
R9891 n_10_11_13 n_10_11_14 2.148943228228081
R9892 n_10_11_14 n_11_11_14 139.25925741594529
R9893 n_10_11_14 n_10_11_15 11.143805597811419
R9894 n_10_11_15 n_11_11_15 6579.999912903351
R9895 n_10_11_15 n_10_12_15 7731.0557532147905
R9896 n_10_12_0 n_11_12_0 5400.149998520495
R9897 n_10_12_0 n_10_13_0 3.779184517262937
R9898 n_10_12_0 n_10_12_1 436.49581174385673
R9899 n_10_12_1 n_11_12_1 7560.209997928692
R9900 n_10_12_1 n_10_13_1 5.290858324168111
R9901 n_10_12_1 n_10_12_2 992.0359357814925
R9902 n_10_12_2 n_11_12_2 13500.374996301238
R9903 n_10_12_2 n_10_13_2 9.44796129315734
R9904 n_10_12_2 n_10_12_3 928.545635891477
R9905 n_10_12_3 n_11_12_3 189005.24994821713
R9906 n_10_12_3 n_10_13_3 132.27145810420262
R9907 n_10_12_3 n_10_12_4 12.345336089725254
R9908 n_10_12_4 n_11_12_4 5727.431816612641
R9909 n_10_12_4 n_10_13_4 4.008226003157657
R9910 n_10_12_15 n_11_12_15 378010.499896431
R9911 n_10_12_15 n_10_13_15 264.5429162084029
R9912 n_10_13_0 n_11_13_0 5400.149998520495
R9913 n_10_13_0 n_10_14_0 3.779184517262937
R9914 n_10_13_0 n_10_13_1 436.49581174385673
R9915 n_10_13_1 n_11_13_1 7560.209997928692
R9916 n_10_13_1 n_10_14_1 5.290858324168111
R9917 n_10_13_1 n_10_13_2 992.0359357814925
R9918 n_10_13_2 n_11_13_2 13500.374996301238
R9919 n_10_13_2 n_10_14_2 9.44796129315734
R9920 n_10_13_2 n_10_13_3 928.545635891477
R9921 n_10_13_3 n_11_13_3 189005.24994821713
R9922 n_10_13_3 n_10_14_3 132.27145810420262
R9923 n_10_13_3 n_10_13_4 12.345336089725254
R9924 n_10_13_4 n_11_13_4 5727.431816612641
R9925 n_10_13_4 n_10_14_4 4.008226003157657
R9926 n_10_13_15 n_11_13_15 378010.499896431
R9927 n_10_13_15 n_10_14_15 264.5429162084029
R9928 n_10_14_0 n_11_14_0 5400.149998520495
R9929 n_10_14_0 n_10_15_0 3.779184517262937
R9930 n_10_14_0 n_10_14_1 436.49581174385673
R9931 n_10_14_1 n_11_14_1 7560.209997928692
R9932 n_10_14_1 n_10_15_1 5.290858324168111
R9933 n_10_14_1 n_10_14_2 992.0359357814925
R9934 n_10_14_2 n_11_14_2 13500.374996301238
R9935 n_10_14_2 n_10_15_2 9.44796129315734
R9936 n_10_14_2 n_10_14_3 928.545635891477
R9937 n_10_14_3 n_11_14_3 189005.24994821713
R9938 n_10_14_3 n_10_15_3 132.27145810420262
R9939 n_10_14_3 n_10_14_4 12.345336089725254
R9940 n_10_14_4 n_11_14_4 5727.431816612641
R9941 n_10_14_4 n_10_15_4 4.008226003157657
R9942 n_10_14_15 n_11_14_15 378010.499896431
R9943 n_10_14_15 n_10_15_15 264.5429162084029
R9944 n_10_15_0 n_11_15_0 5400.149998520495
R9945 n_10_15_0 n_10_16_0 110.44365361735518
R9946 n_10_15_0 n_10_15_1 436.49581174385673
R9947 n_10_15_1 n_11_15_1 7560.209997928692
R9948 n_10_15_1 n_10_16_1 154.62111506429721
R9949 n_10_15_1 n_10_15_2 992.0359357814925
R9950 n_10_15_2 n_11_15_2 13500.374996301238
R9951 n_10_15_2 n_10_16_2 276.10913404338794
R9952 n_10_15_2 n_10_15_3 928.545635891477
R9953 n_10_15_3 n_11_15_3 189005.24994821713
R9954 n_10_15_3 n_10_16_3 3865.5278766074266
R9955 n_10_15_3 n_10_15_4 12.345336089725254
R9956 n_10_15_4 n_11_15_4 5727.431816612641
R9957 n_10_15_4 n_10_16_4 117.13720838204327
R9958 n_10_15_15 n_11_15_15 378010.499896431
R9959 n_10_15_15 n_10_16_15 7731.055753214786
R9960 n_10_16_0 n_11_16_0 93.99999875576313
R9961 n_10_16_0 n_10_17_0 217.10812271744754
R9962 n_10_16_0 n_10_16_1 7.598049271235002
R9963 n_10_16_1 n_11_16_1 131.59999825806835
R9964 n_10_16_1 n_10_17_1 303.95137180442657
R9965 n_10_16_1 n_10_16_2 17.268293798261368
R9966 n_10_16_2 n_11_16_2 234.9999968894078
R9967 n_10_16_2 n_10_17_2 542.7703067936188
R9968 n_10_16_2 n_10_16_3 16.16312299517264
R9969 n_10_16_3 n_11_16_3 3289.9999564517066
R9970 n_10_16_3 n_10_17_3 7598.784295110656
R9971 n_10_16_3 n_10_16_4 0.21489432282280835
R9972 n_10_16_4 n_11_16_4 99.69696837732442
R9973 n_10_16_4 n_10_17_4 230.26619076092902
R9974 n_10_16_4 n_10_16_5 0.21489432282280835
R9975 n_10_16_5 n_11_16_5 3289.9999564517066
R9976 n_10_16_5 n_10_17_5 7598.784295110656
R9977 n_10_16_5 n_10_16_6 0.4144390511582732
R9978 n_10_16_6 n_11_16_6 731.1111014337125
R9979 n_10_16_6 n_10_17_6 1688.6187322468127
R9980 n_10_16_6 n_10_16_7 0.5832845905190505
R9981 n_10_16_7 n_11_16_7 1253.3333167435112
R9982 n_10_16_7 n_10_17_7 2894.774969565973
R9983 n_10_16_7 n_10_16_8 0.4297886456456153
R9984 n_10_16_8 n_11_16_8 1253.3333167435112
R9985 n_10_16_8 n_10_17_8 2894.774969565973
R9986 n_10_16_8 n_10_16_9 0.4297886456456153
R9987 n_10_16_9 n_11_16_9 1253.3333167435112
R9988 n_10_16_9 n_10_17_9 2894.774969565973
R9989 n_10_16_9 n_10_16_10 0.4297886456456153
R9990 n_10_16_10 n_11_16_10 1253.3333167435112
R9991 n_10_16_10 n_10_17_10 2894.774969565973
R9992 n_10_16_10 n_10_16_11 0.4297886456456126
R9993 n_10_16_11 n_11_16_11 1253.3333167435271
R9994 n_10_16_11 n_10_17_11 2894.7749695660104
R9995 n_10_16_11 n_10_16_12 0.4297886456456112
R9996 n_10_16_12 n_11_16_12 1253.333316743519
R9997 n_10_16_12 n_10_17_12 2894.774969565992
R9998 n_10_16_12 n_10_16_13 0.42978864564561536
R9999 n_10_16_13 n_11_16_13 1253.3333167435032
R10000 n_10_16_13 n_10_17_13 2894.774969565955
R10001 n_10_16_13 n_10_16_14 2.148943228228082
R10002 n_10_16_14 n_11_16_14 139.2592574159454
R10003 n_10_16_14 n_10_17_14 321.6416632851075
R10004 n_10_16_14 n_10_16_15 11.143805597811426
R10005 n_10_16_15 n_11_16_15 6579.999912903355
R10006 n_10_16_15 n_10_17_15 15197.568590221177
R10007 n_10_17_0 n_11_17_0 93.99999875576299
R10008 n_10_17_0 n_10_18_0 217.10812271744769
R10009 n_10_17_0 n_10_17_1 7.598049271234992
R10010 n_10_17_1 n_11_17_1 131.5999982580682
R10011 n_10_17_1 n_10_18_1 303.95137180442674
R10012 n_10_17_1 n_10_17_2 17.268293798261347
R10013 n_10_17_2 n_11_17_2 234.99999688940753
R10014 n_10_17_2 n_10_18_2 542.770306793619
R10015 n_10_17_2 n_10_17_3 16.16312299517262
R10016 n_10_17_3 n_11_17_3 3289.999956451703
R10017 n_10_17_3 n_10_18_3 7598.78429511066
R10018 n_10_17_3 n_10_17_4 0.21489432282280807
R10019 n_10_17_4 n_11_17_4 99.69696837732431
R10020 n_10_17_4 n_10_18_4 230.26619076092913
R10021 n_10_17_4 n_10_17_5 0.21489432282280807
R10022 n_10_17_5 n_11_17_5 3289.999956451703
R10023 n_10_17_5 n_10_18_5 7598.78429511066
R10024 n_10_17_5 n_10_17_6 0.41443905115827273
R10025 n_10_17_6 n_11_17_6 731.1111014337116
R10026 n_10_17_6 n_10_18_6 1688.6187322468136
R10027 n_10_17_6 n_10_17_7 0.5832845905190498
R10028 n_10_17_7 n_11_17_7 1253.3333167435094
R10029 n_10_17_7 n_10_18_7 2894.774969565975
R10030 n_10_17_7 n_10_17_8 0.4297886456456148
R10031 n_10_17_8 n_11_17_8 1253.3333167435094
R10032 n_10_17_8 n_10_18_8 2894.774969565975
R10033 n_10_17_8 n_10_17_9 0.4297886456456148
R10034 n_10_17_9 n_11_17_9 1253.3333167435094
R10035 n_10_17_9 n_10_18_9 2894.774969565975
R10036 n_10_17_9 n_10_17_10 0.4297886456456148
R10037 n_10_17_10 n_11_17_10 1253.3333167435094
R10038 n_10_17_10 n_10_18_10 2894.774969565975
R10039 n_10_17_10 n_10_17_11 0.42978864564561203
R10040 n_10_17_11 n_11_17_11 1253.3333167435258
R10041 n_10_17_11 n_10_18_11 2894.7749695660123
R10042 n_10_17_11 n_10_17_12 0.4297886456456107
R10043 n_10_17_12 n_11_17_12 1253.3333167435176
R10044 n_10_17_12 n_10_18_12 2894.7749695659936
R10045 n_10_17_12 n_10_17_13 0.4297886456456148
R10046 n_10_17_13 n_11_17_13 1253.3333167435017
R10047 n_10_17_13 n_10_18_13 2894.7749695659563
R10048 n_10_17_13 n_10_17_14 2.1489432282280796
R10049 n_10_17_14 n_11_17_14 139.25925741594523
R10050 n_10_17_14 n_10_18_14 321.6416632851077
R10051 n_10_17_14 n_10_17_15 11.143805597811413
R10052 n_10_17_15 n_11_17_15 6579.999912903348
R10053 n_10_17_15 n_10_18_15 15197.568590221186
R10054 n_10_18_0 n_11_18_0 93.99999875576299
R10055 n_10_18_0 n_10_19_0 217.10812271744754
R10056 n_10_18_0 n_10_18_1 7.598049271234992
R10057 n_10_18_1 n_11_18_1 131.5999982580682
R10058 n_10_18_1 n_10_19_1 303.95137180442657
R10059 n_10_18_1 n_10_18_2 17.268293798261347
R10060 n_10_18_2 n_11_18_2 234.99999688940753
R10061 n_10_18_2 n_10_19_2 542.7703067936188
R10062 n_10_18_2 n_10_18_3 16.16312299517262
R10063 n_10_18_3 n_11_18_3 3289.999956451703
R10064 n_10_18_3 n_10_19_3 7598.784295110656
R10065 n_10_18_3 n_10_18_4 0.21489432282280807
R10066 n_10_18_4 n_11_18_4 99.69696837732431
R10067 n_10_18_4 n_10_19_4 230.26619076092902
R10068 n_10_18_4 n_10_18_5 0.21489432282280807
R10069 n_10_18_5 n_11_18_5 3289.999956451703
R10070 n_10_18_5 n_10_19_5 7598.784295110656
R10071 n_10_18_5 n_10_18_6 0.41443905115827273
R10072 n_10_18_6 n_11_18_6 731.1111014337116
R10073 n_10_18_6 n_10_19_6 1688.6187322468127
R10074 n_10_18_6 n_10_18_7 0.5832845905190498
R10075 n_10_18_7 n_11_18_7 1253.3333167435094
R10076 n_10_18_7 n_10_19_7 2894.774969565973
R10077 n_10_18_7 n_10_18_8 0.4297886456456148
R10078 n_10_18_8 n_11_18_8 1253.3333167435094
R10079 n_10_18_8 n_10_19_8 2894.774969565973
R10080 n_10_18_8 n_10_18_9 0.4297886456456148
R10081 n_10_18_9 n_11_18_9 1253.3333167435094
R10082 n_10_18_9 n_10_19_9 2894.774969565973
R10083 n_10_18_9 n_10_18_10 0.4297886456456148
R10084 n_10_18_10 n_11_18_10 1253.3333167435094
R10085 n_10_18_10 n_10_19_10 2894.774969565973
R10086 n_10_18_10 n_10_18_11 0.42978864564561203
R10087 n_10_18_11 n_11_18_11 1253.3333167435258
R10088 n_10_18_11 n_10_19_11 2894.7749695660104
R10089 n_10_18_11 n_10_18_12 0.4297886456456107
R10090 n_10_18_12 n_11_18_12 1253.3333167435176
R10091 n_10_18_12 n_10_19_12 2894.774969565992
R10092 n_10_18_12 n_10_18_13 0.4297886456456148
R10093 n_10_18_13 n_11_18_13 1253.3333167435017
R10094 n_10_18_13 n_10_19_13 2894.774969565955
R10095 n_10_18_13 n_10_18_14 2.1489432282280796
R10096 n_10_18_14 n_11_18_14 139.25925741594523
R10097 n_10_18_14 n_10_19_14 321.6416632851075
R10098 n_10_18_14 n_10_18_15 11.143805597811413
R10099 n_10_18_15 n_11_18_15 6579.999912903348
R10100 n_10_18_15 n_10_19_15 15197.568590221177
R10101 n_10_19_0 n_11_19_0 93.99999875576313
R10102 n_10_19_0 n_10_20_0 110.44365396273233
R10103 n_10_19_0 n_10_19_1 7.598049271235002
R10104 n_10_19_1 n_11_19_1 131.59999825806835
R10105 n_10_19_1 n_10_20_1 154.62111554782524
R10106 n_10_19_1 n_10_19_2 17.268293798261368
R10107 n_10_19_2 n_11_19_2 234.9999968894078
R10108 n_10_19_2 n_10_20_2 276.1091349068308
R10109 n_10_19_2 n_10_19_3 16.16312299517264
R10110 n_10_19_3 n_11_19_3 3289.9999564517066
R10111 n_10_19_3 n_10_20_3 3865.5278886956266
R10112 n_10_19_3 n_10_19_4 0.21489432282280835
R10113 n_10_19_4 n_11_19_4 99.69696837732442
R10114 n_10_19_4 n_10_20_4 117.13720874835236
R10115 n_10_19_4 n_10_19_5 0.21489432282280835
R10116 n_10_19_5 n_11_19_5 3289.9999564517066
R10117 n_10_19_5 n_10_19_6 0.4144390511582732
R10118 n_10_19_6 n_11_19_6 731.1111014337125
R10119 n_10_19_6 n_10_19_7 0.5832845905190505
R10120 n_10_19_7 n_11_19_7 1253.3333167435112
R10121 n_10_19_7 n_10_19_8 0.4297886456456153
R10122 n_10_19_8 n_11_19_8 1253.3333167435112
R10123 n_10_19_8 n_10_19_9 0.4297886456456153
R10124 n_10_19_9 n_11_19_9 1253.3333167435112
R10125 n_10_19_9 n_10_19_10 0.4297886456456153
R10126 n_10_19_10 n_11_19_10 1253.3333167435112
R10127 n_10_19_10 n_10_19_11 0.4297886456456126
R10128 n_10_19_11 n_11_19_11 1253.3333167435271
R10129 n_10_19_11 n_10_19_12 0.4297886456456112
R10130 n_10_19_12 n_11_19_12 1253.333316743519
R10131 n_10_19_12 n_10_19_13 0.42978864564561536
R10132 n_10_19_13 n_11_19_13 1253.3333167435032
R10133 n_10_19_13 n_10_19_14 2.148943228228082
R10134 n_10_19_14 n_11_19_14 139.2592574159454
R10135 n_10_19_14 n_10_19_15 11.143805597811426
R10136 n_10_19_15 n_11_19_15 6579.999912903355
R10137 n_10_19_15 n_10_20_15 7731.055777391186
R10138 n_10_20_0 n_11_20_0 5400.149011488476
R10139 n_10_20_0 n_10_21_0 3.779185208017231
R10140 n_10_20_0 n_10_20_1 436.49573196175027
R10141 n_10_20_1 n_11_20_1 7560.208616083866
R10142 n_10_20_1 n_10_21_1 5.290859291224123
R10143 n_10_20_1 n_10_20_2 992.0357544585232
R10144 n_10_20_2 n_11_20_2 13500.372528721193
R10145 n_10_20_2 n_10_21_2 9.447963020043076
R10146 n_10_20_2 n_10_20_3 928.5454661731777
R10147 n_10_20_3 n_11_20_3 189005.2154020965
R10148 n_10_20_3 n_10_21_3 132.27148228060292
R10149 n_10_20_3 n_10_20_4 12.345333833261634
R10150 n_10_20_4 n_11_20_4 5727.430769760502
R10151 n_10_20_4 n_10_21_4 4.008226735775847
R10152 n_10_20_15 n_11_20_15 378010.43080418964
R10153 n_10_20_15 n_10_21_15 264.5429645612035
R10154 n_10_21_0 n_11_21_0 5400.149011488476
R10155 n_10_21_0 n_10_22_0 3.779185208017097
R10156 n_10_21_0 n_10_21_1 436.49573196175027
R10157 n_10_21_1 n_11_21_1 7560.208616083866
R10158 n_10_21_1 n_10_22_1 5.290859291223935
R10159 n_10_21_1 n_10_21_2 992.0357544585232
R10160 n_10_21_2 n_11_21_2 13500.372528721193
R10161 n_10_21_2 n_10_22_2 9.44796302004274
R10162 n_10_21_2 n_10_21_3 928.5454661731777
R10163 n_10_21_3 n_11_21_3 189005.2154020965
R10164 n_10_21_3 n_10_22_3 132.27148228059824
R10165 n_10_21_3 n_10_21_4 12.345333833261634
R10166 n_10_21_4 n_11_21_4 5727.430769760502
R10167 n_10_21_4 n_10_22_4 4.008226735775705
R10168 n_10_21_15 n_11_21_15 378010.43080418964
R10169 n_10_21_15 n_10_22_15 264.54296456119414
R10170 n_10_22_0 n_11_22_0 5400.14901148886
R10171 n_10_22_0 n_10_23_0 3.779185208017097
R10172 n_10_22_0 n_10_22_1 436.4957319617813
R10173 n_10_22_1 n_11_22_1 7560.208616084405
R10174 n_10_22_1 n_10_23_1 5.290859291223935
R10175 n_10_22_1 n_10_22_2 992.0357544585938
R10176 n_10_22_2 n_11_22_2 13500.372528722151
R10177 n_10_22_2 n_10_23_2 9.44796302004274
R10178 n_10_22_2 n_10_22_3 928.5454661732439
R10179 n_10_22_3 n_11_22_3 189005.21540210996
R10180 n_10_22_3 n_10_23_3 132.27148228059824
R10181 n_10_22_3 n_10_22_4 12.345333833262512
R10182 n_10_22_4 n_11_22_4 5727.430769760907
R10183 n_10_22_4 n_10_23_4 4.008226735775705
R10184 n_10_22_15 n_11_22_15 378010.43080421654
R10185 n_10_22_15 n_10_23_15 264.54296456119414
R10186 n_10_23_0 n_11_23_0 5400.149011488476
R10187 n_10_23_0 n_10_24_0 43.561715134360014
R10188 n_10_23_0 n_10_23_1 436.49573196175027
R10189 n_10_23_1 n_11_23_1 7560.208616083866
R10190 n_10_23_1 n_10_24_1 60.98640118810401
R10191 n_10_23_1 n_10_23_2 992.0357544585232
R10192 n_10_23_2 n_11_23_2 13500.372528721193
R10193 n_10_23_2 n_10_24_2 108.90428783590002
R10194 n_10_23_2 n_10_23_3 928.5454661731777
R10195 n_10_23_3 n_11_23_3 189005.2154020965
R10196 n_10_23_3 n_10_24_3 1524.6600297025986
R10197 n_10_23_3 n_10_23_4 12.345333833261634
R10198 n_10_23_4 n_11_23_4 5727.430769760502
R10199 n_10_23_4 n_10_24_4 46.20181908189694
R10200 n_10_23_15 n_11_23_15 378010.43080418964
R10201 n_10_23_15 n_10_24_15 3049.320059405171
R10202 n_10_24_0 n_11_24_0 244.86589626484803
R10203 n_10_24_0 n_10_25_0 83.34424506070266
R10204 n_10_24_0 n_10_24_1 19.792586907362775
R10205 n_10_24_1 n_11_24_1 342.81225477078726
R10206 n_10_24_1 n_10_25_1 116.68194308498371
R10207 n_10_24_1 n_10_24_2 44.98315206218812
R10208 n_10_24_2 n_11_24_2 612.1647406621202
R10209 n_10_24_2 n_10_25_2 208.36061265175664
R10210 n_10_24_2 n_10_24_3 42.10423033020808
R10211 n_10_24_3 n_11_24_3 8570.306369269674
R10212 n_10_24_3 n_10_25_3 2917.04857712459
R10213 n_10_24_3 n_10_24_4 0.5597903367738971
R10214 n_10_24_4 n_11_24_4 259.70625361423254
R10215 n_10_24_4 n_10_25_4 88.3954114280179
R10216 n_10_24_4 n_10_24_5 0.4626838497825068
R10217 n_10_24_5 n_11_24_5 1632.4393084323187
R10218 n_10_24_5 n_10_25_5 555.6283004046838
R10219 n_10_24_5 n_10_24_6 0.15994009622111344
R10220 n_10_24_6 n_11_24_6 272.0732180720531
R10221 n_10_24_6 n_10_25_6 92.60471673411396
R10222 n_10_24_6 n_10_24_7 0.21706155915722514
R10223 n_10_24_7 n_11_24_7 466.4112309806639
R10224 n_10_24_7 n_10_25_7 158.7509429727673
R10225 n_10_24_7 n_10_24_8 0.15994009622111297
R10226 n_10_24_8 n_11_24_8 466.4112309806639
R10227 n_10_24_8 n_10_25_8 158.7509429727673
R10228 n_10_24_8 n_10_24_9 0.15994009622111297
R10229 n_10_24_9 n_11_24_9 466.4112309806639
R10230 n_10_24_9 n_10_25_9 158.7509429727673
R10231 n_10_24_9 n_10_24_10 0.15994009622111297
R10232 n_10_24_10 n_11_24_10 466.4112309806639
R10233 n_10_24_10 n_10_25_10 158.7509429727673
R10234 n_10_24_10 n_10_24_11 0.15994009622111194
R10235 n_10_24_11 n_11_24_11 466.41123098066987
R10236 n_10_24_11 n_10_25_11 158.75094297276934
R10237 n_10_24_11 n_10_24_12 0.15994009622111144
R10238 n_10_24_12 n_11_24_12 466.4112309806669
R10239 n_10_24_12 n_10_25_12 158.7509429727683
R10240 n_10_24_12 n_10_24_13 0.15994009622111297
R10241 n_10_24_13 n_11_24_13 466.411230980661
R10242 n_10_24_13 n_10_25_13 158.75094297276632
R10243 n_10_24_13 n_10_24_14 0.7997004811055668
R10244 n_10_24_14 n_11_24_14 51.823470108962546
R10245 n_10_24_14 n_10_25_14 17.638993663640775
R10246 n_10_24_14 n_10_24_15 24.710744866162244
R10247 n_10_24_15 n_11_24_15 17140.612738539192
R10248 n_10_24_15 n_10_25_15 5834.097154249128
R10249 n_10_25_0 n_11_25_0 244.86589626484883
R10250 n_10_25_0 n_10_26_0 83.34424506070266
R10251 n_10_25_0 n_10_25_1 19.792586907362836
R10252 n_10_25_1 n_11_25_1 342.8122547707883
R10253 n_10_25_1 n_10_26_1 116.68194308498371
R10254 n_10_25_1 n_10_25_2 44.98315206218826
R10255 n_10_25_2 n_11_25_2 612.1647406621221
R10256 n_10_25_2 n_10_26_2 208.36061265175664
R10257 n_10_25_2 n_10_25_3 42.10423033020821
R10258 n_10_25_3 n_11_25_3 8570.306369269701
R10259 n_10_25_3 n_10_26_3 2917.04857712459
R10260 n_10_25_3 n_10_25_4 0.5597903367738989
R10261 n_10_25_4 n_11_25_4 259.7062536142334
R10262 n_10_25_4 n_10_26_4 88.3954114280179
R10263 n_10_25_4 n_10_25_5 0.46268384978250826
R10264 n_10_25_5 n_11_25_5 1632.4393084323237
R10265 n_10_25_5 n_10_26_5 555.6283004046838
R10266 n_10_25_5 n_10_25_6 0.15994009622111396
R10267 n_10_25_6 n_11_25_6 272.07321807205403
R10268 n_10_25_6 n_10_26_6 92.60471673411396
R10269 n_10_25_6 n_10_25_7 0.21706155915722586
R10270 n_10_25_7 n_11_25_7 466.4112309806655
R10271 n_10_25_7 n_10_26_7 158.7509429727673
R10272 n_10_25_7 n_10_25_8 0.15994009622111346
R10273 n_10_25_8 n_11_25_8 466.4112309806655
R10274 n_10_25_8 n_10_26_8 158.7509429727673
R10275 n_10_25_8 n_10_25_9 0.15994009622111346
R10276 n_10_25_9 n_11_25_9 466.4112309806655
R10277 n_10_25_9 n_10_26_9 158.7509429727673
R10278 n_10_25_9 n_10_25_10 0.15994009622111346
R10279 n_10_25_10 n_11_25_10 466.4112309806655
R10280 n_10_25_10 n_10_26_10 158.7509429727673
R10281 n_10_25_10 n_10_25_11 0.15994009622111244
R10282 n_10_25_11 n_11_25_11 466.4112309806714
R10283 n_10_25_11 n_10_26_11 158.75094297276934
R10284 n_10_25_11 n_10_25_12 0.15994009622111194
R10285 n_10_25_12 n_11_25_12 466.4112309806683
R10286 n_10_25_12 n_10_26_12 158.7509429727683
R10287 n_10_25_12 n_10_25_13 0.1599400962211135
R10288 n_10_25_13 n_11_25_13 466.41123098066254
R10289 n_10_25_13 n_10_26_13 158.75094297276632
R10290 n_10_25_13 n_10_25_14 0.7997004811055695
R10291 n_10_25_14 n_11_25_14 51.82347010896271
R10292 n_10_25_14 n_10_26_14 17.638993663640775
R10293 n_10_25_14 n_10_25_15 24.71074486616232
R10294 n_10_25_15 n_11_25_15 17140.612738539246
R10295 n_10_25_15 n_10_26_15 5834.097154249128
R10296 n_10_26_0 n_11_26_0 244.86589626484803
R10297 n_10_26_0 n_10_27_0 83.3442450607028
R10298 n_10_26_0 n_10_26_1 19.792586907362775
R10299 n_10_26_1 n_11_26_1 342.81225477078726
R10300 n_10_26_1 n_10_27_1 116.6819430849839
R10301 n_10_26_1 n_10_26_2 44.98315206218812
R10302 n_10_26_2 n_11_26_2 612.1647406621202
R10303 n_10_26_2 n_10_27_2 208.36061265175695
R10304 n_10_26_2 n_10_26_3 42.10423033020808
R10305 n_10_26_3 n_11_26_3 8570.306369269674
R10306 n_10_26_3 n_10_27_3 2917.0485771245944
R10307 n_10_26_3 n_10_26_4 0.5597903367738971
R10308 n_10_26_4 n_11_26_4 259.70625361423254
R10309 n_10_26_4 n_10_27_4 88.39541142801804
R10310 n_10_26_4 n_10_26_5 0.4626838497825068
R10311 n_10_26_5 n_11_26_5 1632.4393084323187
R10312 n_10_26_5 n_10_27_5 555.6283004046846
R10313 n_10_26_5 n_10_26_6 0.15994009622111344
R10314 n_10_26_6 n_11_26_6 272.0732180720531
R10315 n_10_26_6 n_10_27_6 92.60471673411412
R10316 n_10_26_6 n_10_26_7 0.21706155915722514
R10317 n_10_26_7 n_11_26_7 466.4112309806639
R10318 n_10_26_7 n_10_27_7 158.75094297276755
R10319 n_10_26_7 n_10_26_8 0.15994009622111297
R10320 n_10_26_8 n_11_26_8 466.4112309806639
R10321 n_10_26_8 n_10_27_8 158.75094297276755
R10322 n_10_26_8 n_10_26_9 0.15994009622111297
R10323 n_10_26_9 n_11_26_9 466.4112309806639
R10324 n_10_26_9 n_10_27_9 158.75094297276755
R10325 n_10_26_9 n_10_26_10 0.15994009622111297
R10326 n_10_26_10 n_11_26_10 466.4112309806639
R10327 n_10_26_10 n_10_27_10 158.75094297276755
R10328 n_10_26_10 n_10_26_11 0.15994009622111194
R10329 n_10_26_11 n_11_26_11 466.41123098066987
R10330 n_10_26_11 n_10_27_11 158.7509429727696
R10331 n_10_26_11 n_10_26_12 0.15994009622111144
R10332 n_10_26_12 n_11_26_12 466.4112309806669
R10333 n_10_26_12 n_10_27_12 158.75094297276857
R10334 n_10_26_12 n_10_26_13 0.15994009622111297
R10335 n_10_26_13 n_11_26_13 466.411230980661
R10336 n_10_26_13 n_10_27_13 158.75094297276658
R10337 n_10_26_13 n_10_26_14 0.7997004811055668
R10338 n_10_26_14 n_11_26_14 51.823470108962546
R10339 n_10_26_14 n_10_27_14 17.638993663640804
R10340 n_10_26_14 n_10_26_15 24.710744866162244
R10341 n_10_26_15 n_11_26_15 17140.612738539192
R10342 n_10_26_15 n_10_27_15 5834.097154249138
R10343 n_10_27_0 n_11_27_0 244.86589626484803
R10344 n_10_27_0 n_10_27_1 19.792586907362775
R10345 n_10_27_1 n_11_27_1 342.81225477078726
R10346 n_10_27_1 n_10_27_2 44.98315206218812
R10347 n_10_27_2 n_11_27_2 612.1647406621202
R10348 n_10_27_2 n_10_27_3 42.10423033020808
R10349 n_10_27_3 n_11_27_3 8570.306369269674
R10350 n_10_27_3 n_10_27_4 0.5597903367738971
R10351 n_10_27_4 n_11_27_4 259.70625361423254
R10352 n_10_27_4 n_10_27_5 0.4626838497825068
R10353 n_10_27_5 n_11_27_5 1632.4393084323187
R10354 n_10_27_5 n_10_27_6 0.15994009622111344
R10355 n_10_27_6 n_11_27_6 272.0732180720531
R10356 n_10_27_6 n_10_27_7 0.21706155915722514
R10357 n_10_27_7 n_11_27_7 466.4112309806639
R10358 n_10_27_7 n_10_27_8 0.15994009622111297
R10359 n_10_27_8 n_11_27_8 466.4112309806639
R10360 n_10_27_8 n_10_27_9 0.15994009622111297
R10361 n_10_27_9 n_11_27_9 466.4112309806639
R10362 n_10_27_9 n_10_27_10 0.15994009622111297
R10363 n_10_27_10 n_11_27_10 466.4112309806639
R10364 n_10_27_10 n_10_27_11 0.15994009622111194
R10365 n_10_27_11 n_11_27_11 466.41123098066987
R10366 n_10_27_11 n_10_27_12 0.15994009622111144
R10367 n_10_27_12 n_11_27_12 466.4112309806669
R10368 n_10_27_12 n_10_27_13 0.15994009622111297
R10369 n_10_27_13 n_11_27_13 466.411230980661
R10370 n_10_27_13 n_10_27_14 0.7997004811055668
R10371 n_10_27_14 n_11_27_14 51.823470108962546
R10372 n_10_27_14 n_10_27_15 24.710744866162244
R10373 n_10_27_15 n_11_27_15 17140.612738539192
R10374 n_11_0_0 n_12_0_0 125.67181422348106
R10375 n_11_0_0 n_11_1_0 83.34425223829642
R10376 n_11_0_0 n_11_0_1 19.792585202828388
R10377 n_11_0_1 n_12_0_1 175.94053991287345
R10378 n_11_0_1 n_11_1_1 116.68195313361498
R10379 n_11_0_1 n_11_0_2 44.98314818824633
R10380 n_11_0_2 n_12_0_2 314.17953555870264
R10381 n_11_0_2 n_11_1_2 208.36063059574104
R10382 n_11_0_2 n_11_0_3 42.10422670419857
R10383 n_11_0_3 n_12_0_3 4398.513497821832
R10384 n_11_0_3 n_11_1_3 2917.048828340372
R10385 n_11_0_3 n_11_0_4 0.5597902885648438
R10386 n_11_0_4 n_12_0_4 133.2882878127828
R10387 n_11_0_4 n_11_1_4 88.39541904061731
R10388 n_11_0_4 n_11_0_5 0.46268380993624847
R10389 n_11_0_5 n_12_0_5 837.812094823206
R10390 n_11_0_5 n_11_1_5 555.6283482553089
R10391 n_11_0_5 n_11_0_6 0.1599400824470982
R10392 n_11_0_6 n_12_0_6 139.63534913720105
R10393 n_11_0_6 n_11_1_6 92.60472470921815
R10394 n_11_0_6 n_11_0_7 0.21706154046391873
R10395 n_11_0_7 n_12_0_7 239.3748842352025
R10396 n_11_0_7 n_11_1_7 158.75095664437444
R10397 n_11_0_7 n_11_0_8 0.1599400824470977
R10398 n_11_0_8 n_12_0_8 239.3748842352025
R10399 n_11_0_8 n_11_1_8 158.75095664437444
R10400 n_11_0_8 n_11_0_9 0.1599400824470977
R10401 n_11_0_9 n_12_0_9 239.3748842352025
R10402 n_11_0_9 n_11_1_9 158.75095664437444
R10403 n_11_0_9 n_11_0_10 0.1599400824470977
R10404 n_11_0_10 n_12_0_10 239.3748842352025
R10405 n_11_0_10 n_11_1_10 158.75095664437444
R10406 n_11_0_10 n_11_0_11 0.15994008244709668
R10407 n_11_0_11 n_12_0_11 239.37488423520557
R10408 n_11_0_11 n_11_1_11 158.7509566443765
R10409 n_11_0_11 n_11_0_12 0.15994008244709618
R10410 n_11_0_12 n_12_0_12 239.37488423520412
R10411 n_11_0_12 n_11_1_12 158.7509566443755
R10412 n_11_0_12 n_11_0_13 0.15994008244709768
R10413 n_11_0_13 n_12_0_13 239.37488423520102
R10414 n_11_0_13 n_11_1_13 158.75095664437345
R10415 n_11_0_13 n_11_0_14 0.7997004122354905
R10416 n_11_0_14 n_12_0_14 26.597209359466888
R10417 n_11_0_14 n_11_1_14 17.638995182708236
R10418 n_11_0_14 n_11_0_15 24.710742738076885
R10419 n_11_0_15 n_12_0_15 8797.026995643586
R10420 n_11_0_15 n_11_1_15 5834.097656680692
R10421 n_11_1_0 n_12_1_0 125.67181422348106
R10422 n_11_1_0 n_11_2_0 83.34425223829642
R10423 n_11_1_0 n_11_1_1 19.792585202828388
R10424 n_11_1_1 n_12_1_1 175.94053991287345
R10425 n_11_1_1 n_11_2_1 116.68195313361498
R10426 n_11_1_1 n_11_1_2 44.98314818824633
R10427 n_11_1_2 n_12_1_2 314.17953555870264
R10428 n_11_1_2 n_11_2_2 208.36063059574104
R10429 n_11_1_2 n_11_1_3 42.10422670419857
R10430 n_11_1_3 n_12_1_3 4398.513497821832
R10431 n_11_1_3 n_11_2_3 2917.048828340372
R10432 n_11_1_3 n_11_1_4 0.5597902885648438
R10433 n_11_1_4 n_12_1_4 133.2882878127828
R10434 n_11_1_4 n_11_2_4 88.39541904061731
R10435 n_11_1_4 n_11_1_5 0.46268380993624847
R10436 n_11_1_5 n_12_1_5 837.812094823206
R10437 n_11_1_5 n_11_2_5 555.6283482553089
R10438 n_11_1_5 n_11_1_6 0.1599400824470982
R10439 n_11_1_6 n_12_1_6 139.63534913720105
R10440 n_11_1_6 n_11_2_6 92.60472470921815
R10441 n_11_1_6 n_11_1_7 0.21706154046391873
R10442 n_11_1_7 n_12_1_7 239.3748842352025
R10443 n_11_1_7 n_11_2_7 158.75095664437444
R10444 n_11_1_7 n_11_1_8 0.1599400824470977
R10445 n_11_1_8 n_12_1_8 239.3748842352025
R10446 n_11_1_8 n_11_2_8 158.75095664437444
R10447 n_11_1_8 n_11_1_9 0.1599400824470977
R10448 n_11_1_9 n_12_1_9 239.3748842352025
R10449 n_11_1_9 n_11_2_9 158.75095664437444
R10450 n_11_1_9 n_11_1_10 0.1599400824470977
R10451 n_11_1_10 n_12_1_10 239.3748842352025
R10452 n_11_1_10 n_11_2_10 158.75095664437444
R10453 n_11_1_10 n_11_1_11 0.15994008244709668
R10454 n_11_1_11 n_12_1_11 239.37488423520557
R10455 n_11_1_11 n_11_2_11 158.7509566443765
R10456 n_11_1_11 n_11_1_12 0.15994008244709618
R10457 n_11_1_12 n_12_1_12 239.37488423520412
R10458 n_11_1_12 n_11_2_12 158.7509566443755
R10459 n_11_1_12 n_11_1_13 0.15994008244709768
R10460 n_11_1_13 n_12_1_13 239.37488423520102
R10461 n_11_1_13 n_11_2_13 158.75095664437345
R10462 n_11_1_13 n_11_1_14 0.7997004122354905
R10463 n_11_1_14 n_12_1_14 26.597209359466888
R10464 n_11_1_14 n_11_2_14 17.638995182708236
R10465 n_11_1_14 n_11_1_15 24.710742738076885
R10466 n_11_1_15 n_12_1_15 8797.026995643586
R10467 n_11_1_15 n_11_2_15 5834.097656680692
R10468 n_11_2_0 n_12_2_0 125.67181422348106
R10469 n_11_2_0 n_11_3_0 83.34425223829642
R10470 n_11_2_0 n_11_2_1 19.792585202828388
R10471 n_11_2_1 n_12_2_1 175.94053991287345
R10472 n_11_2_1 n_11_3_1 116.68195313361498
R10473 n_11_2_1 n_11_2_2 44.98314818824633
R10474 n_11_2_2 n_12_2_2 314.17953555870264
R10475 n_11_2_2 n_11_3_2 208.36063059574104
R10476 n_11_2_2 n_11_2_3 42.10422670419857
R10477 n_11_2_3 n_12_2_3 4398.513497821832
R10478 n_11_2_3 n_11_3_3 2917.048828340372
R10479 n_11_2_3 n_11_2_4 0.5597902885648438
R10480 n_11_2_4 n_12_2_4 133.2882878127828
R10481 n_11_2_4 n_11_3_4 88.39541904061731
R10482 n_11_2_4 n_11_2_5 0.46268380993624847
R10483 n_11_2_5 n_12_2_5 837.812094823206
R10484 n_11_2_5 n_11_3_5 555.6283482553089
R10485 n_11_2_5 n_11_2_6 0.1599400824470982
R10486 n_11_2_6 n_12_2_6 139.63534913720105
R10487 n_11_2_6 n_11_3_6 92.60472470921815
R10488 n_11_2_6 n_11_2_7 0.21706154046391873
R10489 n_11_2_7 n_12_2_7 239.3748842352025
R10490 n_11_2_7 n_11_3_7 158.75095664437444
R10491 n_11_2_7 n_11_2_8 0.1599400824470977
R10492 n_11_2_8 n_12_2_8 239.3748842352025
R10493 n_11_2_8 n_11_3_8 158.75095664437444
R10494 n_11_2_8 n_11_2_9 0.1599400824470977
R10495 n_11_2_9 n_12_2_9 239.3748842352025
R10496 n_11_2_9 n_11_3_9 158.75095664437444
R10497 n_11_2_9 n_11_2_10 0.1599400824470977
R10498 n_11_2_10 n_12_2_10 239.3748842352025
R10499 n_11_2_10 n_11_3_10 158.75095664437444
R10500 n_11_2_10 n_11_2_11 0.15994008244709668
R10501 n_11_2_11 n_12_2_11 239.37488423520557
R10502 n_11_2_11 n_11_3_11 158.7509566443765
R10503 n_11_2_11 n_11_2_12 0.15994008244709618
R10504 n_11_2_12 n_12_2_12 239.37488423520412
R10505 n_11_2_12 n_11_3_12 158.7509566443755
R10506 n_11_2_12 n_11_2_13 0.15994008244709768
R10507 n_11_2_13 n_12_2_13 239.37488423520102
R10508 n_11_2_13 n_11_3_13 158.75095664437345
R10509 n_11_2_13 n_11_2_14 0.7997004122354905
R10510 n_11_2_14 n_12_2_14 26.597209359466888
R10511 n_11_2_14 n_11_3_14 17.638995182708236
R10512 n_11_2_14 n_11_2_15 24.710742738076885
R10513 n_11_2_15 n_12_2_15 8797.026995643586
R10514 n_11_2_15 n_11_3_15 5834.097656680692
R10515 n_11_3_0 n_12_3_0 125.67181422348106
R10516 n_11_3_0 n_11_4_0 43.561715134359936
R10517 n_11_3_0 n_11_3_1 19.792585202828388
R10518 n_11_3_1 n_12_3_1 175.94053991287345
R10519 n_11_3_1 n_11_4_1 60.98640118810391
R10520 n_11_3_1 n_11_3_2 44.98314818824633
R10521 n_11_3_2 n_12_3_2 314.17953555870264
R10522 n_11_3_2 n_11_4_2 108.90428783589984
R10523 n_11_3_2 n_11_3_3 42.10422670419857
R10524 n_11_3_3 n_12_3_3 4398.513497821832
R10525 n_11_3_3 n_11_4_3 1524.6600297025964
R10526 n_11_3_3 n_11_3_4 0.5597902885648438
R10527 n_11_3_4 n_12_3_4 133.2882878127828
R10528 n_11_3_4 n_11_4_4 46.20181908189685
R10529 n_11_3_4 n_11_3_5 0.46268380993624847
R10530 n_11_3_5 n_12_3_5 837.812094823206
R10531 n_11_3_5 n_11_3_6 0.1599400824470982
R10532 n_11_3_6 n_12_3_6 139.63534913720105
R10533 n_11_3_6 n_11_3_7 0.21706154046391873
R10534 n_11_3_7 n_12_3_7 239.3748842352025
R10535 n_11_3_7 n_11_3_8 0.1599400824470977
R10536 n_11_3_8 n_12_3_8 239.3748842352025
R10537 n_11_3_8 n_11_3_9 0.1599400824470977
R10538 n_11_3_9 n_12_3_9 239.3748842352025
R10539 n_11_3_9 n_11_3_10 0.1599400824470977
R10540 n_11_3_10 n_12_3_10 239.3748842352025
R10541 n_11_3_10 n_11_3_11 0.15994008244709668
R10542 n_11_3_11 n_12_3_11 239.37488423520557
R10543 n_11_3_11 n_11_3_12 0.15994008244709618
R10544 n_11_3_12 n_12_3_12 239.37488423520412
R10545 n_11_3_12 n_11_3_13 0.15994008244709768
R10546 n_11_3_13 n_12_3_13 239.37488423520102
R10547 n_11_3_13 n_11_3_14 0.7997004122354905
R10548 n_11_3_14 n_12_3_14 26.597209359466888
R10549 n_11_3_14 n_11_3_15 24.710742738076885
R10550 n_11_3_15 n_12_3_15 8797.026995643586
R10551 n_11_3_15 n_11_4_15 3049.3200594051655
R10552 n_11_4_0 n_12_4_0 2771.5083278869834
R10553 n_11_4_0 n_11_5_0 3.7791780304234877
R10554 n_11_4_0 n_11_4_1 436.4965609751034
R10555 n_11_4_1 n_12_4_1 3880.111659041777
R10556 n_11_4_1 n_11_5_1 5.290849242592882
R10557 n_11_4_1 n_11_4_2 992.0376385797804
R10558 n_11_4_2 n_12_4_2 6928.770819717459
R10559 n_11_4_2 n_11_5_2 9.44794507605872
R10560 n_11_4_2 n_11_4_3 928.5472297106745
R10561 n_11_4_3 n_12_4_3 97002.79147604435
R10562 n_11_4_3 n_11_5_3 132.27123106482196
R10563 n_11_4_3 n_11_4_4 12.345357280103947
R10564 n_11_4_4 n_12_4_4 2939.4785295771017
R10565 n_11_4_4 n_11_5_4 4.0082191231764215
R10566 n_11_4_15 n_12_4_15 194005.582952087
R10567 n_11_4_15 n_11_5_15 264.54246212964154
R10568 n_11_5_0 n_12_5_0 2771.5083278869347
R10569 n_11_5_0 n_11_6_0 3.779178030423521
R10570 n_11_5_0 n_11_5_1 436.49656097509563
R10571 n_11_5_1 n_12_5_1 3880.1116590417078
R10572 n_11_5_1 n_11_6_1 5.290849242592929
R10573 n_11_5_1 n_11_5_2 992.0376385797628
R10574 n_11_5_2 n_12_5_2 6928.770819717336
R10575 n_11_5_2 n_11_6_2 9.447945076058803
R10576 n_11_5_2 n_11_5_3 928.5472297106579
R10577 n_11_5_3 n_12_5_3 97002.79147604262
R10578 n_11_5_3 n_11_6_3 132.27123106482313
R10579 n_11_5_3 n_11_5_4 12.345357280103725
R10580 n_11_5_4 n_12_5_4 2939.4785295770494
R10581 n_11_5_4 n_11_6_4 4.008219123176457
R10582 n_11_5_15 n_12_5_15 194005.58295208353
R10583 n_11_5_15 n_11_6_15 264.54246212964387
R10584 n_11_6_0 n_12_6_0 2771.5083278869347
R10585 n_11_6_0 n_11_7_0 3.7791780304234877
R10586 n_11_6_0 n_11_6_1 436.49656097509563
R10587 n_11_6_1 n_12_6_1 3880.1116590417078
R10588 n_11_6_1 n_11_7_1 5.290849242592882
R10589 n_11_6_1 n_11_6_2 992.0376385797628
R10590 n_11_6_2 n_12_6_2 6928.770819717336
R10591 n_11_6_2 n_11_7_2 9.44794507605872
R10592 n_11_6_2 n_11_6_3 928.5472297106579
R10593 n_11_6_3 n_12_6_3 97002.79147604262
R10594 n_11_6_3 n_11_7_3 132.27123106482196
R10595 n_11_6_3 n_11_6_4 12.345357280103725
R10596 n_11_6_4 n_12_6_4 2939.4785295770494
R10597 n_11_6_4 n_11_7_4 4.0082191231764215
R10598 n_11_6_15 n_12_6_15 194005.58295208353
R10599 n_11_6_15 n_11_7_15 264.54246212964154
R10600 n_11_7_0 n_12_7_0 2771.5083278869834
R10601 n_11_7_0 n_11_8_0 110.44365037393554
R10602 n_11_7_0 n_11_7_1 436.4965609751034
R10603 n_11_7_1 n_12_7_1 3880.111659041777
R10604 n_11_7_1 n_11_8_1 154.62111052350977
R10605 n_11_7_1 n_11_7_2 992.0376385797804
R10606 n_11_7_2 n_12_7_2 6928.770819717459
R10607 n_11_7_2 n_11_8_2 276.1091259348389
R10608 n_11_7_2 n_11_7_3 928.5472297106745
R10609 n_11_7_3 n_12_7_3 97002.79147604435
R10610 n_11_7_3 n_11_8_3 3865.527763087741
R10611 n_11_7_3 n_11_7_4 12.345357280103947
R10612 n_11_7_4 n_12_7_4 2939.4785295771017
R10613 n_11_7_4 n_11_8_4 117.13720494205273
R10614 n_11_7_15 n_12_7_15 194005.582952087
R10615 n_11_7_15 n_11_8_15 7731.055526175412
R10616 n_11_8_0 n_12_8_0 48.243351067603335
R10617 n_11_8_0 n_11_9_0 217.1081227174477
R10618 n_11_8_0 n_11_8_1 7.598049271235001
R10619 n_11_8_1 n_12_8_1 67.54069149464466
R10620 n_11_8_1 n_11_9_1 303.9513718044268
R10621 n_11_8_1 n_11_8_2 17.268293798261368
R10622 n_11_8_2 n_12_8_2 120.60837766900832
R10623 n_11_8_2 n_11_9_2 542.7703067936193
R10624 n_11_8_2 n_11_8_3 16.16312299517264
R10625 n_11_8_3 n_12_8_3 1688.517287366115
R10626 n_11_8_3 n_11_9_3 7598.784295110663
R10627 n_11_8_3 n_11_8_4 0.2148943228228083
R10628 n_11_8_4 n_12_8_4 51.16719052624591
R10629 n_11_8_4 n_11_9_4 230.26619076092913
R10630 n_11_8_4 n_11_8_5 0.2148943228228083
R10631 n_11_8_5 n_11_9_5 7598.784295110663
R10632 n_11_8_5 n_11_8_6 0.4144390511582731
R10633 n_11_8_6 n_11_9_6 1688.6187322468138
R10634 n_11_8_6 n_11_8_7 0.5832845905190505
R10635 n_11_8_7 n_11_9_7 2894.7749695659754
R10636 n_11_8_7 n_11_8_8 0.42978864564561525
R10637 n_11_8_8 n_11_9_8 2894.7749695659754
R10638 n_11_8_8 n_11_8_9 0.42978864564561525
R10639 n_11_8_9 n_11_9_9 2894.7749695659754
R10640 n_11_8_9 n_11_8_10 0.42978864564561525
R10641 n_11_8_10 n_11_9_10 2894.7749695659754
R10642 n_11_8_10 n_11_8_11 0.4297886456456125
R10643 n_11_8_11 n_11_9_11 2894.7749695660123
R10644 n_11_8_11 n_11_8_12 0.42978864564561114
R10645 n_11_8_12 n_11_9_12 2894.774969565994
R10646 n_11_8_12 n_11_8_13 0.42978864564561525
R10647 n_11_8_13 n_11_9_13 2894.7749695659577
R10648 n_11_8_13 n_11_8_14 2.148943228228082
R10649 n_11_8_14 n_11_9_14 321.6416632851078
R10650 n_11_8_14 n_11_8_15 11.143805597811426
R10651 n_11_8_15 n_12_8_15 3377.0345747322
R10652 n_11_8_15 n_11_9_15 15197.56859022119
R10653 n_11_9_0 n_12_9_0 48.243351067603285
R10654 n_11_9_0 n_11_10_0 217.1081227174477
R10655 n_11_9_0 n_11_9_1 7.598049271234997
R10656 n_11_9_1 n_12_9_1 67.54069149464462
R10657 n_11_9_1 n_11_10_1 303.9513718044268
R10658 n_11_9_1 n_11_9_2 17.268293798261354
R10659 n_11_9_2 n_12_9_2 120.60837766900823
R10660 n_11_9_2 n_11_10_2 542.7703067936193
R10661 n_11_9_2 n_11_9_3 16.16312299517263
R10662 n_11_9_3 n_12_9_3 1688.517287366114
R10663 n_11_9_3 n_11_10_3 7598.784295110663
R10664 n_11_9_3 n_11_9_4 0.21489432282280818
R10665 n_11_9_4 n_12_9_4 51.167190526245875
R10666 n_11_9_4 n_11_10_4 230.26619076092913
R10667 n_11_9_4 n_11_9_5 0.21489432282280818
R10668 n_11_9_5 n_11_10_5 7598.784295110663
R10669 n_11_9_5 n_11_9_6 0.41443905115827295
R10670 n_11_9_6 n_11_10_6 1688.6187322468138
R10671 n_11_9_6 n_11_9_7 0.5832845905190501
R10672 n_11_9_7 n_11_10_7 2894.7749695659754
R10673 n_11_9_7 n_11_9_8 0.42978864564561503
R10674 n_11_9_8 n_11_10_8 2894.7749695659754
R10675 n_11_9_8 n_11_9_9 0.42978864564561503
R10676 n_11_9_9 n_11_10_9 2894.7749695659754
R10677 n_11_9_9 n_11_9_10 0.42978864564561503
R10678 n_11_9_10 n_11_10_10 2894.7749695659754
R10679 n_11_9_10 n_11_9_11 0.42978864564561226
R10680 n_11_9_11 n_11_10_11 2894.7749695660123
R10681 n_11_9_11 n_11_9_12 0.4297886456456109
R10682 n_11_9_12 n_11_10_12 2894.774969565994
R10683 n_11_9_12 n_11_9_13 0.42978864564561503
R10684 n_11_9_13 n_11_10_13 2894.7749695659577
R10685 n_11_9_13 n_11_9_14 2.1489432282280805
R10686 n_11_9_14 n_11_10_14 321.6416632851078
R10687 n_11_9_14 n_11_9_15 11.143805597811417
R10688 n_11_9_15 n_12_9_15 3377.034574732198
R10689 n_11_9_15 n_11_10_15 15197.56859022119
R10690 n_11_10_0 n_12_10_0 48.243351067603335
R10691 n_11_10_0 n_11_11_0 217.10812271744763
R10692 n_11_10_0 n_11_10_1 7.598049271235001
R10693 n_11_10_1 n_12_10_1 67.54069149464466
R10694 n_11_10_1 n_11_11_1 303.9513718044267
R10695 n_11_10_1 n_11_10_2 17.268293798261368
R10696 n_11_10_2 n_12_10_2 120.60837766900832
R10697 n_11_10_2 n_11_11_2 542.7703067936192
R10698 n_11_10_2 n_11_10_3 16.16312299517264
R10699 n_11_10_3 n_12_10_3 1688.517287366115
R10700 n_11_10_3 n_11_11_3 7598.78429511066
R10701 n_11_10_3 n_11_10_4 0.2148943228228083
R10702 n_11_10_4 n_12_10_4 51.16719052624591
R10703 n_11_10_4 n_11_11_4 230.26619076092908
R10704 n_11_10_4 n_11_10_5 0.2148943228228083
R10705 n_11_10_5 n_11_11_5 7598.78429511066
R10706 n_11_10_5 n_11_10_6 0.4144390511582731
R10707 n_11_10_6 n_11_11_6 1688.6187322468134
R10708 n_11_10_6 n_11_10_7 0.5832845905190505
R10709 n_11_10_7 n_11_11_7 2894.7749695659745
R10710 n_11_10_7 n_11_10_8 0.42978864564561525
R10711 n_11_10_8 n_11_11_8 2894.7749695659745
R10712 n_11_10_8 n_11_10_9 0.42978864564561525
R10713 n_11_10_9 n_11_11_9 2894.7749695659745
R10714 n_11_10_9 n_11_10_10 0.42978864564561525
R10715 n_11_10_10 n_11_11_10 2894.7749695659745
R10716 n_11_10_10 n_11_10_11 0.4297886456456125
R10717 n_11_10_11 n_11_11_11 2894.774969566012
R10718 n_11_10_11 n_11_10_12 0.42978864564561114
R10719 n_11_10_12 n_11_11_12 2894.774969565993
R10720 n_11_10_12 n_11_10_13 0.42978864564561525
R10721 n_11_10_13 n_11_11_13 2894.774969565957
R10722 n_11_10_13 n_11_10_14 2.148943228228082
R10723 n_11_10_14 n_11_11_14 321.6416632851077
R10724 n_11_10_14 n_11_10_15 11.143805597811426
R10725 n_11_10_15 n_12_10_15 3377.0345747322
R10726 n_11_10_15 n_11_11_15 15197.568590221184
R10727 n_11_11_0 n_12_11_0 48.243351067603335
R10728 n_11_11_0 n_11_12_0 110.44365361735528
R10729 n_11_11_0 n_11_11_1 7.598049271235001
R10730 n_11_11_1 n_12_11_1 67.54069149464466
R10731 n_11_11_1 n_11_12_1 154.6211150642974
R10732 n_11_11_1 n_11_11_2 17.268293798261368
R10733 n_11_11_2 n_12_11_2 120.60837766900832
R10734 n_11_11_2 n_11_12_2 276.1091340433883
R10735 n_11_11_2 n_11_11_3 16.16312299517264
R10736 n_11_11_3 n_12_11_3 1688.517287366115
R10737 n_11_11_3 n_11_12_3 3865.5278766074316
R10738 n_11_11_3 n_11_11_4 0.2148943228228083
R10739 n_11_11_4 n_12_11_4 51.16719052624591
R10740 n_11_11_4 n_11_12_4 117.13720838204337
R10741 n_11_11_4 n_11_11_5 0.2148943228228083
R10742 n_11_11_5 n_11_11_6 0.4144390511582731
R10743 n_11_11_6 n_11_11_7 0.5832845905190505
R10744 n_11_11_7 n_11_11_8 0.42978864564561525
R10745 n_11_11_8 n_11_11_9 0.42978864564561525
R10746 n_11_11_9 n_11_11_10 0.42978864564561525
R10747 n_11_11_10 n_11_11_11 0.4297886456456125
R10748 n_11_11_11 n_11_11_12 0.42978864564561114
R10749 n_11_11_12 n_11_11_13 0.42978864564561525
R10750 n_11_11_13 n_11_11_14 2.148943228228082
R10751 n_11_11_14 n_11_11_15 11.143805597811426
R10752 n_11_11_15 n_12_11_15 3377.0345747322
R10753 n_11_11_15 n_11_12_15 7731.055753214794
R10754 n_11_12_0 n_12_12_0 2771.5035706888184
R10755 n_11_12_0 n_11_13_0 3.779184517262938
R10756 n_11_12_0 n_11_12_1 436.49581174385685
R10757 n_11_12_1 n_12_12_1 3880.104998964345
R10758 n_11_12_1 n_11_13_1 5.290858324168114
R10759 n_11_12_1 n_11_12_2 992.035935781493
R10760 n_11_12_2 n_12_12_2 6928.7589267220455
R10761 n_11_12_2 n_11_13_2 9.447961293157347
R10762 n_11_12_2 n_11_12_3 928.5456358914773
R10763 n_11_12_3 n_12_12_3 97002.62497410855
R10764 n_11_12_3 n_11_13_3 132.27145810420274
R10765 n_11_12_3 n_11_12_4 12.345336089725256
R10766 n_11_12_4 n_12_12_4 2939.4734840638953
R10767 n_11_12_4 n_11_13_4 4.008226003157658
R10768 n_11_12_15 n_12_12_15 194005.24994821538
R10769 n_11_12_15 n_11_13_15 264.5429162084031
R10770 n_11_13_0 n_12_13_0 2771.5035706888184
R10771 n_11_13_0 n_11_14_0 3.779184517262938
R10772 n_11_13_0 n_11_13_1 436.49581174385685
R10773 n_11_13_1 n_12_13_1 3880.104998964345
R10774 n_11_13_1 n_11_14_1 5.290858324168114
R10775 n_11_13_1 n_11_13_2 992.035935781493
R10776 n_11_13_2 n_12_13_2 6928.7589267220455
R10777 n_11_13_2 n_11_14_2 9.447961293157347
R10778 n_11_13_2 n_11_13_3 928.5456358914773
R10779 n_11_13_3 n_12_13_3 97002.62497410855
R10780 n_11_13_3 n_11_14_3 132.27145810420274
R10781 n_11_13_3 n_11_13_4 12.345336089725256
R10782 n_11_13_4 n_12_13_4 2939.4734840638953
R10783 n_11_13_4 n_11_14_4 4.008226003157658
R10784 n_11_13_15 n_12_13_15 194005.24994821538
R10785 n_11_13_15 n_11_14_15 264.5429162084031
R10786 n_11_14_0 n_12_14_0 2771.5035706888184
R10787 n_11_14_0 n_11_15_0 3.779184517262938
R10788 n_11_14_0 n_11_14_1 436.49581174385685
R10789 n_11_14_1 n_12_14_1 3880.104998964345
R10790 n_11_14_1 n_11_15_1 5.290858324168114
R10791 n_11_14_1 n_11_14_2 992.035935781493
R10792 n_11_14_2 n_12_14_2 6928.7589267220455
R10793 n_11_14_2 n_11_15_2 9.447961293157347
R10794 n_11_14_2 n_11_14_3 928.5456358914773
R10795 n_11_14_3 n_12_14_3 97002.62497410855
R10796 n_11_14_3 n_11_15_3 132.27145810420274
R10797 n_11_14_3 n_11_14_4 12.345336089725256
R10798 n_11_14_4 n_12_14_4 2939.4734840638953
R10799 n_11_14_4 n_11_15_4 4.008226003157658
R10800 n_11_14_15 n_12_14_15 194005.24994821538
R10801 n_11_14_15 n_11_15_15 264.5429162084031
R10802 n_11_15_0 n_12_15_0 2771.5035706888184
R10803 n_11_15_0 n_11_16_0 110.44365361735522
R10804 n_11_15_0 n_11_15_1 436.49581174385685
R10805 n_11_15_1 n_12_15_1 3880.104998964345
R10806 n_11_15_1 n_11_16_1 154.62111506429733
R10807 n_11_15_1 n_11_15_2 992.035935781493
R10808 n_11_15_2 n_12_15_2 6928.7589267220455
R10809 n_11_15_2 n_11_16_2 276.1091340433881
R10810 n_11_15_2 n_11_15_3 928.5456358914773
R10811 n_11_15_3 n_12_15_3 97002.62497410855
R10812 n_11_15_3 n_11_16_3 3865.5278766074293
R10813 n_11_15_3 n_11_15_4 12.345336089725256
R10814 n_11_15_4 n_12_15_4 2939.4734840638953
R10815 n_11_15_4 n_11_16_4 117.1372083820433
R10816 n_11_15_15 n_12_15_15 194005.24994821538
R10817 n_11_15_15 n_11_16_15 7731.05575321479
R10818 n_11_16_0 n_12_16_0 48.24335106760336
R10819 n_11_16_0 n_11_17_0 217.10812271744766
R10820 n_11_16_0 n_11_16_1 7.5980492712350065
R10821 n_11_16_1 n_12_16_1 67.54069149464469
R10822 n_11_16_1 n_11_17_1 303.9513718044267
R10823 n_11_16_1 n_11_16_2 17.26829379826138
R10824 n_11_16_2 n_12_16_2 120.60837766900839
R10825 n_11_16_2 n_11_17_2 542.770306793619
R10826 n_11_16_2 n_11_16_3 16.16312299517265
R10827 n_11_16_3 n_12_16_3 1688.5172873661159
R10828 n_11_16_3 n_11_17_3 7598.78429511066
R10829 n_11_16_3 n_11_16_4 0.21489432282280846
R10830 n_11_16_4 n_12_16_4 51.167190526245925
R10831 n_11_16_4 n_11_17_4 230.26619076092908
R10832 n_11_16_4 n_11_16_5 0.21489432282280846
R10833 n_11_16_5 n_11_17_5 7598.78429511066
R10834 n_11_16_5 n_11_16_6 0.41443905115827345
R10835 n_11_16_6 n_11_17_6 1688.6187322468131
R10836 n_11_16_6 n_11_16_7 0.5832845905190508
R10837 n_11_16_7 n_11_17_7 2894.7749695659745
R10838 n_11_16_7 n_11_16_8 0.42978864564561553
R10839 n_11_16_8 n_11_17_8 2894.7749695659745
R10840 n_11_16_8 n_11_16_9 0.42978864564561553
R10841 n_11_16_9 n_11_17_9 2894.7749695659745
R10842 n_11_16_9 n_11_16_10 0.42978864564561553
R10843 n_11_16_10 n_11_17_10 2894.7749695659745
R10844 n_11_16_10 n_11_16_11 0.4297886456456128
R10845 n_11_16_11 n_11_17_11 2894.7749695660114
R10846 n_11_16_11 n_11_16_12 0.4297886456456114
R10847 n_11_16_12 n_11_17_12 2894.774969565993
R10848 n_11_16_12 n_11_16_13 0.4297886456456156
R10849 n_11_16_13 n_11_17_13 2894.774969565957
R10850 n_11_16_13 n_11_16_14 2.148943228228083
R10851 n_11_16_14 n_11_17_14 321.6416632851077
R10852 n_11_16_14 n_11_16_15 11.143805597811433
R10853 n_11_16_15 n_12_16_15 3377.034574732202
R10854 n_11_16_15 n_11_17_15 15197.568590221184
R10855 n_11_17_0 n_12_17_0 48.243351067603285
R10856 n_11_17_0 n_11_18_0 217.10812271744777
R10857 n_11_17_0 n_11_17_1 7.598049271234997
R10858 n_11_17_1 n_12_17_1 67.54069149464462
R10859 n_11_17_1 n_11_18_1 303.9513718044269
R10860 n_11_17_1 n_11_17_2 17.268293798261354
R10861 n_11_17_2 n_12_17_2 120.60837766900823
R10862 n_11_17_2 n_11_18_2 542.7703067936194
R10863 n_11_17_2 n_11_17_3 16.16312299517263
R10864 n_11_17_3 n_12_17_3 1688.517287366114
R10865 n_11_17_3 n_11_18_3 7598.784295110665
R10866 n_11_17_3 n_11_17_4 0.21489432282280818
R10867 n_11_17_4 n_12_17_4 51.167190526245875
R10868 n_11_17_4 n_11_18_4 230.26619076092922
R10869 n_11_17_4 n_11_17_5 0.21489432282280818
R10870 n_11_17_5 n_11_18_5 7598.784295110665
R10871 n_11_17_5 n_11_17_6 0.41443905115827295
R10872 n_11_17_6 n_11_18_6 1688.6187322468143
R10873 n_11_17_6 n_11_17_7 0.5832845905190501
R10874 n_11_17_7 n_11_18_7 2894.7749695659763
R10875 n_11_17_7 n_11_17_8 0.42978864564561503
R10876 n_11_17_8 n_11_18_8 2894.7749695659763
R10877 n_11_17_8 n_11_17_9 0.42978864564561503
R10878 n_11_17_9 n_11_18_9 2894.7749695659763
R10879 n_11_17_9 n_11_17_10 0.42978864564561503
R10880 n_11_17_10 n_11_18_10 2894.7749695659763
R10881 n_11_17_10 n_11_17_11 0.42978864564561226
R10882 n_11_17_11 n_11_18_11 2894.774969566013
R10883 n_11_17_11 n_11_17_12 0.4297886456456109
R10884 n_11_17_12 n_11_18_12 2894.774969565995
R10885 n_11_17_12 n_11_17_13 0.42978864564561503
R10886 n_11_17_13 n_11_18_13 2894.774969565958
R10887 n_11_17_13 n_11_17_14 2.1489432282280805
R10888 n_11_17_14 n_11_18_14 321.6416632851079
R10889 n_11_17_14 n_11_17_15 11.143805597811417
R10890 n_11_17_15 n_12_17_15 3377.034574732198
R10891 n_11_17_15 n_11_18_15 15197.568590221195
R10892 n_11_18_0 n_12_18_0 48.243351067603285
R10893 n_11_18_0 n_11_19_0 217.10812271744766
R10894 n_11_18_0 n_11_18_1 7.598049271234997
R10895 n_11_18_1 n_12_18_1 67.54069149464462
R10896 n_11_18_1 n_11_19_1 303.9513718044267
R10897 n_11_18_1 n_11_18_2 17.268293798261354
R10898 n_11_18_2 n_12_18_2 120.60837766900823
R10899 n_11_18_2 n_11_19_2 542.770306793619
R10900 n_11_18_2 n_11_18_3 16.16312299517263
R10901 n_11_18_3 n_12_18_3 1688.517287366114
R10902 n_11_18_3 n_11_19_3 7598.78429511066
R10903 n_11_18_3 n_11_18_4 0.21489432282280818
R10904 n_11_18_4 n_12_18_4 51.167190526245875
R10905 n_11_18_4 n_11_19_4 230.26619076092908
R10906 n_11_18_4 n_11_18_5 0.21489432282280818
R10907 n_11_18_5 n_11_19_5 7598.78429511066
R10908 n_11_18_5 n_11_18_6 0.41443905115827295
R10909 n_11_18_6 n_11_19_6 1688.6187322468131
R10910 n_11_18_6 n_11_18_7 0.5832845905190501
R10911 n_11_18_7 n_11_19_7 2894.7749695659745
R10912 n_11_18_7 n_11_18_8 0.42978864564561503
R10913 n_11_18_8 n_11_19_8 2894.7749695659745
R10914 n_11_18_8 n_11_18_9 0.42978864564561503
R10915 n_11_18_9 n_11_19_9 2894.7749695659745
R10916 n_11_18_9 n_11_18_10 0.42978864564561503
R10917 n_11_18_10 n_11_19_10 2894.7749695659745
R10918 n_11_18_10 n_11_18_11 0.42978864564561226
R10919 n_11_18_11 n_11_19_11 2894.7749695660114
R10920 n_11_18_11 n_11_18_12 0.4297886456456109
R10921 n_11_18_12 n_11_19_12 2894.774969565993
R10922 n_11_18_12 n_11_18_13 0.42978864564561503
R10923 n_11_18_13 n_11_19_13 2894.774969565957
R10924 n_11_18_13 n_11_18_14 2.1489432282280805
R10925 n_11_18_14 n_11_19_14 321.6416632851077
R10926 n_11_18_14 n_11_18_15 11.143805597811417
R10927 n_11_18_15 n_12_18_15 3377.034574732198
R10928 n_11_18_15 n_11_19_15 15197.568590221184
R10929 n_11_19_0 n_12_19_0 48.24335106760336
R10930 n_11_19_0 n_11_20_0 110.44365396273237
R10931 n_11_19_0 n_11_19_1 7.5980492712350065
R10932 n_11_19_1 n_12_19_1 67.54069149464469
R10933 n_11_19_1 n_11_20_1 154.62111554782533
R10934 n_11_19_1 n_11_19_2 17.26829379826138
R10935 n_11_19_2 n_12_19_2 120.60837766900839
R10936 n_11_19_2 n_11_20_2 276.10913490683095
R10937 n_11_19_2 n_11_19_3 16.16312299517265
R10938 n_11_19_3 n_12_19_3 1688.5172873661159
R10939 n_11_19_3 n_11_20_3 3865.5278886956294
R10940 n_11_19_3 n_11_19_4 0.21489432282280846
R10941 n_11_19_4 n_12_19_4 51.167190526245925
R10942 n_11_19_4 n_11_20_4 117.13720874835239
R10943 n_11_19_4 n_11_19_5 0.21489432282280846
R10944 n_11_19_5 n_11_19_6 0.41443905115827345
R10945 n_11_19_6 n_11_19_7 0.5832845905190508
R10946 n_11_19_7 n_11_19_8 0.42978864564561553
R10947 n_11_19_8 n_11_19_9 0.42978864564561553
R10948 n_11_19_9 n_11_19_10 0.42978864564561553
R10949 n_11_19_10 n_11_19_11 0.4297886456456128
R10950 n_11_19_11 n_11_19_12 0.4297886456456114
R10951 n_11_19_12 n_11_19_13 0.4297886456456156
R10952 n_11_19_13 n_11_19_14 2.148943228228083
R10953 n_11_19_14 n_11_19_15 11.143805597811433
R10954 n_11_19_15 n_12_19_15 3377.034574732202
R10955 n_11_19_15 n_11_20_15 7731.05577739119
R10956 n_11_20_0 n_12_20_0 2771.503064117193
R10957 n_11_20_0 n_11_21_0 3.7791852080172323
R10958 n_11_20_0 n_11_20_1 436.49573196175044
R10959 n_11_20_1 n_12_20_1 3880.104289764069
R10960 n_11_20_1 n_11_21_1 5.290859291224126
R10961 n_11_20_1 n_11_20_2 992.0357544585238
R10962 n_11_20_2 n_12_20_2 6928.757660292983
R10963 n_11_20_2 n_11_21_2 9.447963020043082
R10964 n_11_20_2 n_11_20_3 928.5454661731783
R10965 n_11_20_3 n_12_20_3 97002.60724410164
R10966 n_11_20_3 n_11_21_3 132.271482280603
R10967 n_11_20_3 n_11_20_4 12.34533383326164
R10968 n_11_20_4 n_12_20_4 2939.4729467909597
R10969 n_11_20_4 n_11_21_4 4.008226735775849
R10970 n_11_20_15 n_12_20_15 194005.21448820157
R10971 n_11_20_15 n_11_21_15 264.5429645612037
R10972 n_11_21_0 n_12_21_0 2771.503064117193
R10973 n_11_21_0 n_11_22_0 3.7791852080170982
R10974 n_11_21_0 n_11_21_1 436.49573196175044
R10975 n_11_21_1 n_12_21_1 3880.104289764069
R10976 n_11_21_1 n_11_22_1 5.2908592912239385
R10977 n_11_21_1 n_11_21_2 992.0357544585238
R10978 n_11_21_2 n_12_21_2 6928.757660292983
R10979 n_11_21_2 n_11_22_2 9.447963020042746
R10980 n_11_21_2 n_11_21_3 928.5454661731783
R10981 n_11_21_3 n_12_21_3 97002.60724410164
R10982 n_11_21_3 n_11_22_3 132.27148228059832
R10983 n_11_21_3 n_11_21_4 12.34533383326164
R10984 n_11_21_4 n_12_21_4 2939.4729467909597
R10985 n_11_21_4 n_11_22_4 4.008226735775706
R10986 n_11_21_15 n_12_21_15 194005.21448820157
R10987 n_11_21_15 n_11_22_15 264.54296456119425
R10988 n_11_22_0 n_12_22_0 2771.50306411739
R10989 n_11_22_0 n_11_23_0 3.7791852080170982
R10990 n_11_22_0 n_11_22_1 436.4957319617814
R10991 n_11_22_1 n_12_22_1 3880.1042897643456
R10992 n_11_22_1 n_11_23_1 5.2908592912239385
R10993 n_11_22_1 n_11_22_2 992.0357544585942
R10994 n_11_22_2 n_12_22_2 6928.757660293474
R10995 n_11_22_2 n_11_23_2 9.447963020042746
R10996 n_11_22_2 n_11_22_3 928.5454661732442
R10997 n_11_22_3 n_12_22_3 97002.60724410856
R10998 n_11_22_3 n_11_23_3 132.27148228059832
R10999 n_11_22_3 n_11_22_4 12.345333833262517
R11000 n_11_22_4 n_12_22_4 2939.472946791168
R11001 n_11_22_4 n_11_23_4 4.008226735775706
R11002 n_11_22_15 n_12_22_15 194005.21448821537
R11003 n_11_22_15 n_11_23_15 264.54296456119425
R11004 n_11_23_0 n_12_23_0 2771.503064117193
R11005 n_11_23_0 n_11_24_0 43.561715134360036
R11006 n_11_23_0 n_11_23_1 436.49573196175044
R11007 n_11_23_1 n_12_23_1 3880.104289764069
R11008 n_11_23_1 n_11_24_1 60.98640118810405
R11009 n_11_23_1 n_11_23_2 992.0357544585238
R11010 n_11_23_2 n_12_23_2 6928.757660292983
R11011 n_11_23_2 n_11_24_2 108.90428783590009
R11012 n_11_23_2 n_11_23_3 928.5454661731783
R11013 n_11_23_3 n_12_23_3 97002.60724410164
R11014 n_11_23_3 n_11_24_3 1524.6600297025998
R11015 n_11_23_3 n_11_23_4 12.34533383326164
R11016 n_11_23_4 n_12_23_4 2939.4729467909597
R11017 n_11_23_4 n_11_24_4 46.20181908189696
R11018 n_11_23_15 n_12_23_15 194005.21448820157
R11019 n_11_23_15 n_11_24_15 3049.3200594051723
R11020 n_11_24_0 n_12_24_0 125.67182504631838
R11021 n_11_24_0 n_11_25_0 83.34424506070269
R11022 n_11_24_0 n_11_24_1 19.79258690736278
R11023 n_11_24_1 n_12_24_1 175.9405550648457
R11024 n_11_24_1 n_11_25_1 116.68194308498379
R11025 n_11_24_1 n_11_24_2 44.98315206218814
R11026 n_11_24_2 n_12_24_2 314.179562615796
R11027 n_11_24_2 n_11_25_2 208.36061265175675
R11028 n_11_24_2 n_11_24_3 42.104230330208104
R11029 n_11_24_3 n_12_24_3 4398.513876621139
R11030 n_11_24_3 n_11_25_3 2917.048577124592
R11031 n_11_24_3 n_11_24_4 0.5597903367738973
R11032 n_11_24_4 n_12_24_4 133.28829929154966
R11033 n_11_24_4 n_11_25_4 88.39541142801792
R11034 n_11_24_4 n_11_24_5 0.462683849782507
R11035 n_11_24_5 n_12_24_5 837.8121669754552
R11036 n_11_24_5 n_11_25_5 555.6283004046841
R11037 n_11_24_5 n_11_24_6 0.15994009622111352
R11038 n_11_24_6 n_12_24_6 139.63536116257586
R11039 n_11_24_6 n_11_25_6 92.60471673411402
R11040 n_11_24_6 n_11_24_7 0.21706155915722525
R11041 n_11_24_7 n_12_24_7 239.37490485013075
R11042 n_11_24_7 n_11_25_7 158.75094297276735
R11043 n_11_24_7 n_11_24_8 0.15994009622111302
R11044 n_11_24_8 n_12_24_8 239.37490485013075
R11045 n_11_24_8 n_11_25_8 158.75094297276735
R11046 n_11_24_8 n_11_24_9 0.15994009622111302
R11047 n_11_24_9 n_12_24_9 239.37490485013075
R11048 n_11_24_9 n_11_25_9 158.75094297276735
R11049 n_11_24_9 n_11_24_10 0.15994009622111302
R11050 n_11_24_10 n_12_24_10 239.37490485013075
R11051 n_11_24_10 n_11_25_10 158.75094297276735
R11052 n_11_24_10 n_11_24_11 0.159940096221112
R11053 n_11_24_11 n_12_24_11 239.37490485013382
R11054 n_11_24_11 n_11_25_11 158.7509429727694
R11055 n_11_24_11 n_11_24_12 0.1599400962211115
R11056 n_11_24_12 n_12_24_12 239.37490485013228
R11057 n_11_24_12 n_11_25_12 158.75094297276843
R11058 n_11_24_12 n_11_24_13 0.15994009622111302
R11059 n_11_24_13 n_12_24_13 239.37490485012927
R11060 n_11_24_13 n_11_25_13 158.75094297276638
R11061 n_11_24_13 n_11_24_14 0.799700481105567
R11062 n_11_24_14 n_12_24_14 26.597211650014472
R11063 n_11_24_14 n_11_25_14 17.638993663640782
R11064 n_11_24_14 n_11_24_15 24.710744866162255
R11065 n_11_24_15 n_12_24_15 8797.027753242199
R11066 n_11_24_15 n_11_25_15 5834.097154249132
R11067 n_11_25_0 n_12_25_0 125.67182504631879
R11068 n_11_25_0 n_11_26_0 83.34424506070269
R11069 n_11_25_0 n_11_25_1 19.792586907362846
R11070 n_11_25_1 n_12_25_1 175.94055506484628
R11071 n_11_25_1 n_11_26_1 116.68194308498379
R11072 n_11_25_1 n_11_25_2 44.98315206218829
R11073 n_11_25_2 n_12_25_2 314.17956261579695
R11074 n_11_25_2 n_11_26_2 208.36061265175675
R11075 n_11_25_2 n_11_25_3 42.10423033020824
R11076 n_11_25_3 n_12_25_3 4398.513876621154
R11077 n_11_25_3 n_11_26_3 2917.048577124592
R11078 n_11_25_3 n_11_25_4 0.5597903367738992
R11079 n_11_25_4 n_12_25_4 133.28829929155012
R11080 n_11_25_4 n_11_26_4 88.39541142801792
R11081 n_11_25_4 n_11_25_5 0.46268384978250854
R11082 n_11_25_5 n_12_25_5 837.8121669754578
R11083 n_11_25_5 n_11_26_5 555.6283004046841
R11084 n_11_25_5 n_11_25_6 0.15994009622111405
R11085 n_11_25_6 n_12_25_6 139.6353611625763
R11086 n_11_25_6 n_11_26_6 92.60471673411402
R11087 n_11_25_6 n_11_25_7 0.21706155915722597
R11088 n_11_25_7 n_12_25_7 239.37490485013157
R11089 n_11_25_7 n_11_26_7 158.75094297276735
R11090 n_11_25_7 n_11_25_8 0.15994009622111355
R11091 n_11_25_8 n_12_25_8 239.37490485013157
R11092 n_11_25_8 n_11_26_8 158.75094297276735
R11093 n_11_25_8 n_11_25_9 0.15994009622111355
R11094 n_11_25_9 n_12_25_9 239.37490485013157
R11095 n_11_25_9 n_11_26_9 158.75094297276735
R11096 n_11_25_9 n_11_25_10 0.15994009622111355
R11097 n_11_25_10 n_12_25_10 239.37490485013157
R11098 n_11_25_10 n_11_26_10 158.75094297276735
R11099 n_11_25_10 n_11_25_11 0.15994009622111255
R11100 n_11_25_11 n_12_25_11 239.3749048501346
R11101 n_11_25_11 n_11_26_11 158.7509429727694
R11102 n_11_25_11 n_11_25_12 0.15994009622111202
R11103 n_11_25_12 n_12_25_12 239.374904850133
R11104 n_11_25_12 n_11_26_12 158.75094297276843
R11105 n_11_25_12 n_11_25_13 0.15994009622111355
R11106 n_11_25_13 n_12_25_13 239.37490485013004
R11107 n_11_25_13 n_11_26_13 158.75094297276638
R11108 n_11_25_13 n_11_25_14 0.7997004811055698
R11109 n_11_25_14 n_12_25_14 26.597211650014554
R11110 n_11_25_14 n_11_26_14 17.638993663640782
R11111 n_11_25_14 n_11_25_15 24.710744866162337
R11112 n_11_25_15 n_12_25_15 8797.027753242228
R11113 n_11_25_15 n_11_26_15 5834.097154249132
R11114 n_11_26_0 n_12_26_0 125.67182504631838
R11115 n_11_26_0 n_11_27_0 83.34424506070283
R11116 n_11_26_0 n_11_26_1 19.79258690736278
R11117 n_11_26_1 n_12_26_1 175.9405550648457
R11118 n_11_26_1 n_11_27_1 116.68194308498397
R11119 n_11_26_1 n_11_26_2 44.98315206218814
R11120 n_11_26_2 n_12_26_2 314.179562615796
R11121 n_11_26_2 n_11_27_2 208.3606126517571
R11122 n_11_26_2 n_11_26_3 42.104230330208104
R11123 n_11_26_3 n_12_26_3 4398.513876621139
R11124 n_11_26_3 n_11_27_3 2917.0485771245967
R11125 n_11_26_3 n_11_26_4 0.5597903367738973
R11126 n_11_26_4 n_12_26_4 133.28829929154966
R11127 n_11_26_4 n_11_27_4 88.39541142801806
R11128 n_11_26_4 n_11_26_5 0.462683849782507
R11129 n_11_26_5 n_12_26_5 837.8121669754552
R11130 n_11_26_5 n_11_27_5 555.628300404685
R11131 n_11_26_5 n_11_26_6 0.15994009622111352
R11132 n_11_26_6 n_12_26_6 139.63536116257586
R11133 n_11_26_6 n_11_27_6 92.60471673411416
R11134 n_11_26_6 n_11_26_7 0.21706155915722525
R11135 n_11_26_7 n_12_26_7 239.37490485013075
R11136 n_11_26_7 n_11_27_7 158.7509429727676
R11137 n_11_26_7 n_11_26_8 0.15994009622111302
R11138 n_11_26_8 n_12_26_8 239.37490485013075
R11139 n_11_26_8 n_11_27_8 158.7509429727676
R11140 n_11_26_8 n_11_26_9 0.15994009622111302
R11141 n_11_26_9 n_12_26_9 239.37490485013075
R11142 n_11_26_9 n_11_27_9 158.7509429727676
R11143 n_11_26_9 n_11_26_10 0.15994009622111302
R11144 n_11_26_10 n_12_26_10 239.37490485013075
R11145 n_11_26_10 n_11_27_10 158.7509429727676
R11146 n_11_26_10 n_11_26_11 0.159940096221112
R11147 n_11_26_11 n_12_26_11 239.37490485013382
R11148 n_11_26_11 n_11_27_11 158.75094297276965
R11149 n_11_26_11 n_11_26_12 0.1599400962211115
R11150 n_11_26_12 n_12_26_12 239.37490485013228
R11151 n_11_26_12 n_11_27_12 158.75094297276866
R11152 n_11_26_12 n_11_26_13 0.15994009622111302
R11153 n_11_26_13 n_12_26_13 239.37490485012927
R11154 n_11_26_13 n_11_27_13 158.75094297276664
R11155 n_11_26_13 n_11_26_14 0.799700481105567
R11156 n_11_26_14 n_12_26_14 26.597211650014472
R11157 n_11_26_14 n_11_27_14 17.63899366364081
R11158 n_11_26_14 n_11_26_15 24.710744866162255
R11159 n_11_26_15 n_12_26_15 8797.027753242199
R11160 n_11_26_15 n_11_27_15 5834.097154249141
R11161 n_11_27_0 n_12_27_0 125.67182504631838
R11162 n_11_27_0 n_11_27_1 19.79258690736278
R11163 n_11_27_1 n_12_27_1 175.9405550648457
R11164 n_11_27_1 n_11_27_2 44.98315206218814
R11165 n_11_27_2 n_12_27_2 314.179562615796
R11166 n_11_27_2 n_11_27_3 42.104230330208104
R11167 n_11_27_3 n_12_27_3 4398.513876621139
R11168 n_11_27_3 n_11_27_4 0.5597903367738973
R11169 n_11_27_4 n_12_27_4 133.28829929154966
R11170 n_11_27_4 n_11_27_5 0.462683849782507
R11171 n_11_27_5 n_12_27_5 837.8121669754552
R11172 n_11_27_5 n_11_27_6 0.15994009622111352
R11173 n_11_27_6 n_12_27_6 139.63536116257586
R11174 n_11_27_6 n_11_27_7 0.21706155915722525
R11175 n_11_27_7 n_12_27_7 239.37490485013075
R11176 n_11_27_7 n_11_27_8 0.15994009622111302
R11177 n_11_27_8 n_12_27_8 239.37490485013075
R11178 n_11_27_8 n_11_27_9 0.15994009622111302
R11179 n_11_27_9 n_12_27_9 239.37490485013075
R11180 n_11_27_9 n_11_27_10 0.15994009622111302
R11181 n_11_27_10 n_12_27_10 239.37490485013075
R11182 n_11_27_10 n_11_27_11 0.159940096221112
R11183 n_11_27_11 n_12_27_11 239.37490485013382
R11184 n_11_27_11 n_11_27_12 0.1599400962211115
R11185 n_11_27_12 n_12_27_12 239.37490485013228
R11186 n_11_27_12 n_11_27_13 0.15994009622111302
R11187 n_11_27_13 n_12_27_13 239.37490485012927
R11188 n_11_27_13 n_11_27_14 0.799700481105567
R11189 n_11_27_14 n_12_27_14 26.597211650014472
R11190 n_11_27_14 n_11_27_15 24.710744866162255
R11191 n_11_27_15 n_12_27_15 8797.027753242199
R11192 n_12_0_0 n_13_0_0 6.477753269925552
R11193 n_12_0_0 n_12_1_0 3150.5002452092954
R11194 n_12_0_0 n_12_0_1 748.1805026763932
R11195 n_12_0_1 n_13_0_1 9.06885457789577
R11196 n_12_0_1 n_12_1_1 4410.700343293014
R11197 n_12_0_1 n_12_0_2 1700.4102333554388
R11198 n_12_0_2 n_13_0_2 16.19438317481388
R11199 n_12_0_2 n_12_1_2 7876.25061302324
R11200 n_12_0_2 n_12_0_3 1591.5839784206908
R11201 n_12_0_3 n_13_0_3 226.72136444739408
R11202 n_12_0_3 n_12_1_3 110267.50858232524
R11203 n_12_0_3 n_12_0_4 21.160660681756593
R11204 n_12_0_4 n_13_0_4 6.87034437719376
R11205 n_12_0_4 n_12_1_4 3341.4396540098564
R11206 n_12_0_4 n_12_0_5 17.489933828798815
R11207 n_12_0_5 n_13_0_5 43.18502179950363
R11208 n_12_0_5 n_12_1_5 21003.33496806195
R11209 n_12_0_5 n_12_0_6 6.045903051930455
R11210 n_12_0_6 n_13_0_6 7.197503633250607
R11211 n_12_0_6 n_12_1_6 3500.5558280103255
R11212 n_12_0_6 n_12_0_7 8.205154141905608
R11213 n_12_0_7 n_13_0_7 12.338577657001077
R11214 n_12_0_7 n_12_1_7 6000.95284801772
R11215 n_12_0_7 n_12_0_8 6.045903051930436
R11216 n_12_0_8 n_13_0_8 12.338577657001077
R11217 n_12_0_8 n_12_1_8 6000.95284801772
R11218 n_12_0_8 n_12_0_9 6.045903051930436
R11219 n_12_0_9 n_13_0_9 12.338577657001077
R11220 n_12_0_9 n_12_1_9 6000.95284801772
R11221 n_12_0_9 n_12_0_10 6.045903051930436
R11222 n_12_0_10 n_13_0_10 12.338577657001077
R11223 n_12_0_10 n_12_1_10 6000.95284801772
R11224 n_12_0_10 n_12_0_11 6.045903051930397
R11225 n_12_0_11 n_13_0_11 12.338577657001235
R11226 n_12_0_11 n_12_1_11 6000.952848017796
R11227 n_12_0_11 n_12_0_12 6.045903051930377
R11228 n_12_0_12 n_13_0_12 12.33857765700116
R11229 n_12_0_12 n_12_1_12 6000.952848017758
R11230 n_12_0_12 n_12_0_13 6.045903051930436
R11231 n_12_0_13 n_13_0_13 12.338577657001
R11232 n_12_0_13 n_12_1_13 6000.952848017681
R11233 n_12_0_13 n_12_0_14 30.229515259652253
R11234 n_12_0_14 n_13_0_14 1.3709530730001167
R11235 n_12_0_14 n_12_1_14 666.7725386686341
R11236 n_12_0_14 n_12_0_15 934.0920215232634
R11237 n_12_0_15 n_13_0_15 453.4427288947842
R11238 n_12_0_15 n_12_1_15 220535.01716464857
R11239 n_12_1_0 n_13_1_0 6.477753269925552
R11240 n_12_1_0 n_12_2_0 3150.5002452092954
R11241 n_12_1_0 n_12_1_1 748.1805026763932
R11242 n_12_1_1 n_13_1_1 9.06885457789577
R11243 n_12_1_1 n_12_2_1 4410.700343293014
R11244 n_12_1_1 n_12_1_2 1700.4102333554388
R11245 n_12_1_2 n_13_1_2 16.19438317481388
R11246 n_12_1_2 n_12_2_2 7876.25061302324
R11247 n_12_1_2 n_12_1_3 1591.5839784206908
R11248 n_12_1_3 n_13_1_3 226.72136444739408
R11249 n_12_1_3 n_12_2_3 110267.50858232524
R11250 n_12_1_3 n_12_1_4 21.160660681756593
R11251 n_12_1_4 n_13_1_4 6.87034437719376
R11252 n_12_1_4 n_12_2_4 3341.4396540098564
R11253 n_12_1_4 n_12_1_5 17.489933828798815
R11254 n_12_1_5 n_13_1_5 43.18502179950363
R11255 n_12_1_5 n_12_2_5 21003.33496806195
R11256 n_12_1_5 n_12_1_6 6.045903051930455
R11257 n_12_1_6 n_13_1_6 7.197503633250607
R11258 n_12_1_6 n_12_2_6 3500.5558280103255
R11259 n_12_1_6 n_12_1_7 8.205154141905608
R11260 n_12_1_7 n_13_1_7 12.338577657001077
R11261 n_12_1_7 n_12_2_7 6000.95284801772
R11262 n_12_1_7 n_12_1_8 6.045903051930436
R11263 n_12_1_8 n_13_1_8 12.338577657001077
R11264 n_12_1_8 n_12_2_8 6000.95284801772
R11265 n_12_1_8 n_12_1_9 6.045903051930436
R11266 n_12_1_9 n_13_1_9 12.338577657001077
R11267 n_12_1_9 n_12_2_9 6000.95284801772
R11268 n_12_1_9 n_12_1_10 6.045903051930436
R11269 n_12_1_10 n_13_1_10 12.338577657001077
R11270 n_12_1_10 n_12_2_10 6000.95284801772
R11271 n_12_1_10 n_12_1_11 6.045903051930397
R11272 n_12_1_11 n_13_1_11 12.338577657001235
R11273 n_12_1_11 n_12_2_11 6000.952848017796
R11274 n_12_1_11 n_12_1_12 6.045903051930377
R11275 n_12_1_12 n_13_1_12 12.33857765700116
R11276 n_12_1_12 n_12_2_12 6000.952848017758
R11277 n_12_1_12 n_12_1_13 6.045903051930436
R11278 n_12_1_13 n_13_1_13 12.338577657001
R11279 n_12_1_13 n_12_2_13 6000.952848017681
R11280 n_12_1_13 n_12_1_14 30.229515259652253
R11281 n_12_1_14 n_13_1_14 1.3709530730001167
R11282 n_12_1_14 n_12_2_14 666.7725386686341
R11283 n_12_1_14 n_12_1_15 934.0920215232634
R11284 n_12_1_15 n_13_1_15 453.4427288947842
R11285 n_12_1_15 n_12_2_15 220535.01716464857
R11286 n_12_2_0 n_13_2_0 6.477753269925552
R11287 n_12_2_0 n_12_3_0 3150.5002452092954
R11288 n_12_2_0 n_12_2_1 748.1805026763932
R11289 n_12_2_1 n_13_2_1 9.06885457789577
R11290 n_12_2_1 n_12_3_1 4410.700343293014
R11291 n_12_2_1 n_12_2_2 1700.4102333554388
R11292 n_12_2_2 n_13_2_2 16.19438317481388
R11293 n_12_2_2 n_12_3_2 7876.25061302324
R11294 n_12_2_2 n_12_2_3 1591.5839784206908
R11295 n_12_2_3 n_13_2_3 226.72136444739408
R11296 n_12_2_3 n_12_3_3 110267.50858232524
R11297 n_12_2_3 n_12_2_4 21.160660681756593
R11298 n_12_2_4 n_13_2_4 6.87034437719376
R11299 n_12_2_4 n_12_3_4 3341.4396540098564
R11300 n_12_2_4 n_12_2_5 17.489933828798815
R11301 n_12_2_5 n_13_2_5 43.18502179950363
R11302 n_12_2_5 n_12_3_5 21003.33496806195
R11303 n_12_2_5 n_12_2_6 6.045903051930455
R11304 n_12_2_6 n_13_2_6 7.197503633250607
R11305 n_12_2_6 n_12_3_6 3500.5558280103255
R11306 n_12_2_6 n_12_2_7 8.205154141905608
R11307 n_12_2_7 n_13_2_7 12.338577657001077
R11308 n_12_2_7 n_12_3_7 6000.95284801772
R11309 n_12_2_7 n_12_2_8 6.045903051930436
R11310 n_12_2_8 n_13_2_8 12.338577657001077
R11311 n_12_2_8 n_12_3_8 6000.95284801772
R11312 n_12_2_8 n_12_2_9 6.045903051930436
R11313 n_12_2_9 n_13_2_9 12.338577657001077
R11314 n_12_2_9 n_12_3_9 6000.95284801772
R11315 n_12_2_9 n_12_2_10 6.045903051930436
R11316 n_12_2_10 n_13_2_10 12.338577657001077
R11317 n_12_2_10 n_12_3_10 6000.95284801772
R11318 n_12_2_10 n_12_2_11 6.045903051930397
R11319 n_12_2_11 n_13_2_11 12.338577657001235
R11320 n_12_2_11 n_12_3_11 6000.952848017796
R11321 n_12_2_11 n_12_2_12 6.045903051930377
R11322 n_12_2_12 n_13_2_12 12.33857765700116
R11323 n_12_2_12 n_12_3_12 6000.952848017758
R11324 n_12_2_12 n_12_2_13 6.045903051930436
R11325 n_12_2_13 n_13_2_13 12.338577657001
R11326 n_12_2_13 n_12_3_13 6000.952848017681
R11327 n_12_2_13 n_12_2_14 30.229515259652253
R11328 n_12_2_14 n_13_2_14 1.3709530730001167
R11329 n_12_2_14 n_12_3_14 666.7725386686341
R11330 n_12_2_14 n_12_2_15 934.0920215232634
R11331 n_12_2_15 n_13_2_15 453.4427288947842
R11332 n_12_2_15 n_12_3_15 220535.01716464857
R11333 n_12_3_0 n_13_3_0 6.477753269925552
R11334 n_12_3_0 n_12_4_0 1646.6785714285472
R11335 n_12_3_0 n_12_3_1 748.1805026763932
R11336 n_12_3_1 n_13_3_1 9.06885457789577
R11337 n_12_3_1 n_12_4_1 2305.3499999999667
R11338 n_12_3_1 n_12_3_2 1700.4102333554388
R11339 n_12_3_2 n_13_3_2 16.19438317481388
R11340 n_12_3_2 n_12_4_2 4116.696428571369
R11341 n_12_3_2 n_12_3_3 1591.5839784206908
R11342 n_12_3_3 n_13_3_3 226.72136444739408
R11343 n_12_3_3 n_12_4_3 57633.749999999105
R11344 n_12_3_3 n_12_3_4 21.160660681756593
R11345 n_12_3_4 n_13_3_4 6.87034437719376
R11346 n_12_3_4 n_12_4_4 1746.477272727246
R11347 n_12_3_4 n_12_3_5 17.489933828798815
R11348 n_12_3_5 n_13_3_5 43.18502179950363
R11349 n_12_3_5 n_12_3_6 6.045903051930455
R11350 n_12_3_6 n_13_3_6 7.197503633250607
R11351 n_12_3_6 n_12_3_7 8.205154141905608
R11352 n_12_3_7 n_13_3_7 12.338577657001077
R11353 n_12_3_7 n_12_3_8 6.045903051930436
R11354 n_12_3_8 n_13_3_8 12.338577657001077
R11355 n_12_3_8 n_12_3_9 6.045903051930436
R11356 n_12_3_9 n_13_3_9 12.338577657001077
R11357 n_12_3_9 n_12_3_10 6.045903051930436
R11358 n_12_3_10 n_13_3_10 12.338577657001077
R11359 n_12_3_10 n_12_3_11 6.045903051930397
R11360 n_12_3_11 n_13_3_11 12.338577657001235
R11361 n_12_3_11 n_12_3_12 6.045903051930377
R11362 n_12_3_12 n_13_3_12 12.33857765700116
R11363 n_12_3_12 n_12_3_13 6.045903051930436
R11364 n_12_3_13 n_13_3_13 12.338577657001
R11365 n_12_3_13 n_12_3_14 30.229515259652253
R11366 n_12_3_14 n_13_3_14 1.3709530730001167
R11367 n_12_3_14 n_12_3_15 934.0920215232634
R11368 n_12_3_15 n_13_3_15 453.4427288947842
R11369 n_12_3_15 n_12_4_15 115267.4999999972
R11370 n_12_4_0 n_13_4_0 142.85738806690486
R11371 n_12_4_0 n_12_5_0 142.8568976478005
R11372 n_12_4_0 n_12_4_1 16500.028321727335
R11373 n_12_4_1 n_13_4_1 200.0003432936668
R11374 n_12_4_1 n_12_5_1 199.99965670692075
R11375 n_12_4_1 n_12_4_2 37500.064367562125
R11376 n_12_4_2 n_13_4_2 357.1434701672622
R11377 n_12_4_2 n_12_5_2 357.14224411950136
R11378 n_12_4_2 n_12_4_3 35100.06024803815
R11379 n_12_4_3 n_13_4_3 5000.008582341667
R11380 n_12_4_3 n_12_5_3 4999.9914176730135
R11381 n_12_4_3 n_12_4_4 466.66746768521796
R11382 n_12_4_4 n_13_4_4 151.5154115861111
R11383 n_12_4_4 n_12_5_4 151.5148914446368
R11384 n_12_4_15 n_13_4_15 10000.017164683242
R11385 n_12_4_15 n_12_5_15 9999.982835345938
R11386 n_12_5_0 n_13_5_0 142.85738806690233
R11387 n_12_5_0 n_12_6_0 142.8568976478018
R11388 n_12_5_0 n_12_5_1 16500.02832172704
R11389 n_12_5_1 n_13_5_1 200.00034329366324
R11390 n_12_5_1 n_12_6_1 199.9996567069225
R11391 n_12_5_1 n_12_5_2 37500.06436756146
R11392 n_12_5_2 n_13_5_2 357.1434701672558
R11393 n_12_5_2 n_12_6_2 357.1422441195045
R11394 n_12_5_2 n_12_5_3 35100.06024803753
R11395 n_12_5_3 n_13_5_3 5000.0085823415775
R11396 n_12_5_3 n_12_6_3 4999.991417673058
R11397 n_12_5_3 n_12_5_4 466.66746768520966
R11398 n_12_5_4 n_13_5_4 151.51541158610837
R11399 n_12_5_4 n_12_6_4 151.51489144463812
R11400 n_12_5_15 n_13_5_15 10000.017164683064
R11401 n_12_5_15 n_12_6_15 9999.982835346027
R11402 n_12_6_0 n_13_6_0 142.85738806690233
R11403 n_12_6_0 n_12_7_0 142.8568976478005
R11404 n_12_6_0 n_12_6_1 16500.02832172704
R11405 n_12_6_1 n_13_6_1 200.00034329366324
R11406 n_12_6_1 n_12_7_1 199.99965670692075
R11407 n_12_6_1 n_12_6_2 37500.06436756146
R11408 n_12_6_2 n_13_6_2 357.1434701672558
R11409 n_12_6_2 n_12_7_2 357.14224411950136
R11410 n_12_6_2 n_12_6_3 35100.06024803753
R11411 n_12_6_3 n_13_6_3 5000.0085823415775
R11412 n_12_6_3 n_12_7_3 4999.9914176730135
R11413 n_12_6_3 n_12_6_4 466.66746768520966
R11414 n_12_6_4 n_13_6_4 151.51541158610837
R11415 n_12_6_4 n_12_7_4 151.5148914446368
R11416 n_12_6_15 n_13_6_15 10000.017164683064
R11417 n_12_6_15 n_12_7_15 9999.982835345938
R11418 n_12_7_0 n_13_7_0 142.85738806690486
R11419 n_12_7_0 n_12_8_0 4174.885948823841
R11420 n_12_7_0 n_12_7_1 16500.028321727335
R11421 n_12_7_1 n_13_7_1 200.0003432936668
R11422 n_12_7_1 n_12_8_1 5844.840328353377
R11423 n_12_7_1 n_12_7_2 37500.064367562125
R11424 n_12_7_2 n_13_7_2 357.1434701672622
R11425 n_12_7_2 n_12_8_2 10437.214872059603
R11426 n_12_7_2 n_12_7_3 35100.06024803815
R11427 n_12_7_3 n_13_7_3 5000.008582341667
R11428 n_12_7_3 n_12_8_3 146121.00820883428
R11429 n_12_7_3 n_12_7_4 466.66746768521796
R11430 n_12_7_4 n_13_7_4 151.5154115861111
R11431 n_12_7_4 n_12_8_4 4427.909339661646
R11432 n_12_7_15 n_13_7_15 10000.017164683242
R11433 n_12_7_15 n_12_8_15 292242.01641766605
R11434 n_12_8_0 n_13_8_0 2.4867033794435622
R11435 n_12_8_0 n_12_9_0 8206.914999999884
R11436 n_12_8_0 n_12_8_1 287.21424032572827
R11437 n_12_8_1 n_13_8_1 3.4813847312209862
R11438 n_12_8_1 n_12_9_1 11489.680999999839
R11439 n_12_8_1 n_12_8_2 652.759637103928
R11440 n_12_8_2 n_13_8_2 6.216758448608904
R11441 n_12_8_2 n_12_9_2 20517.287499999715
R11442 n_12_8_2 n_12_8_3 610.9830203292765
R11443 n_12_8_3 n_13_8_3 87.03461828052458
R11444 n_12_8_3 n_12_9_3 287242.0249999957
R11445 n_12_8_3 n_12_8_4 8.123231039515554
R11446 n_12_8_4 n_13_8_4 2.637412675167412
R11447 n_12_8_4 n_12_9_4 8704.30378787866
R11448 n_12_8_15 n_13_8_15 174.0692365610476
R11449 n_12_8_15 n_12_9_15 574484.0499999863
R11450 n_12_9_0 n_13_9_0 2.4867033794435596
R11451 n_12_9_0 n_12_10_0 8206.914999999884
R11452 n_12_9_0 n_12_9_1 287.2142403257281
R11453 n_12_9_1 n_13_9_1 3.4813847312209845
R11454 n_12_9_1 n_12_10_1 11489.680999999839
R11455 n_12_9_1 n_12_9_2 652.7596371039276
R11456 n_12_9_2 n_13_9_2 6.2167584486089
R11457 n_12_9_2 n_12_10_2 20517.287499999715
R11458 n_12_9_2 n_12_9_3 610.9830203292762
R11459 n_12_9_3 n_13_9_3 87.03461828052454
R11460 n_12_9_3 n_12_10_3 287242.0249999957
R11461 n_12_9_3 n_12_9_4 8.123231039515549
R11462 n_12_9_4 n_13_9_4 2.6374126751674103
R11463 n_12_9_4 n_12_10_4 8704.30378787866
R11464 n_12_9_15 n_13_9_15 174.06923656104752
R11465 n_12_9_15 n_12_10_15 574484.0499999863
R11466 n_12_10_0 n_13_10_0 2.4867033794435622
R11467 n_12_10_0 n_12_11_0 8206.914999999883
R11468 n_12_10_0 n_12_10_1 287.21424032572827
R11469 n_12_10_1 n_13_10_1 3.4813847312209862
R11470 n_12_10_1 n_12_11_1 11489.680999999835
R11471 n_12_10_1 n_12_10_2 652.759637103928
R11472 n_12_10_2 n_13_10_2 6.216758448608904
R11473 n_12_10_2 n_12_11_2 20517.287499999708
R11474 n_12_10_2 n_12_10_3 610.9830203292765
R11475 n_12_10_3 n_13_10_3 87.03461828052458
R11476 n_12_10_3 n_12_11_3 287242.0249999956
R11477 n_12_10_3 n_12_10_4 8.123231039515554
R11478 n_12_10_4 n_13_10_4 2.637412675167412
R11479 n_12_10_4 n_12_11_4 8704.303787878656
R11480 n_12_10_15 n_13_10_15 174.0692365610476
R11481 n_12_10_15 n_12_11_15 574484.0499999862
R11482 n_12_11_0 n_13_11_0 2.4867033794435622
R11483 n_12_11_0 n_12_12_0 4174.886071428513
R11484 n_12_11_0 n_12_11_1 287.21424032572827
R11485 n_12_11_1 n_13_11_1 3.4813847312209862
R11486 n_12_11_1 n_12_12_1 5844.8404999999175
R11487 n_12_11_1 n_12_11_2 652.759637103928
R11488 n_12_11_2 n_13_11_2 6.216758448608904
R11489 n_12_11_2 n_12_12_2 10437.215178571283
R11490 n_12_11_2 n_12_11_3 610.9830203292765
R11491 n_12_11_3 n_13_11_3 87.03461828052458
R11492 n_12_11_3 n_12_12_3 146121.0124999978
R11493 n_12_11_3 n_12_11_4 8.123231039515554
R11494 n_12_11_4 n_13_11_4 2.637412675167412
R11495 n_12_11_4 n_12_12_4 4427.909469696904
R11496 n_12_11_15 n_13_11_15 174.0692365610476
R11497 n_12_11_15 n_12_12_15 292242.02499999304
R11498 n_12_12_0 n_13_12_0 142.85714285714033
R11499 n_12_12_0 n_12_13_0 142.85714285714286
R11500 n_12_12_0 n_12_12_1 16499.99999999953
R11501 n_12_12_1 n_13_12_1 199.99999999999648
R11502 n_12_12_1 n_12_13_1 200.00000000000003
R11503 n_12_12_1 n_12_12_2 37499.99999999893
R11504 n_12_12_2 n_13_12_2 357.14285714285086
R11505 n_12_12_2 n_12_13_2 357.1428571428572
R11506 n_12_12_2 n_12_12_3 35099.999999999
R11507 n_12_12_3 n_13_12_3 4999.999999999907
R11508 n_12_12_3 n_12_13_3 4999.999999999996
R11509 n_12_12_3 n_12_12_4 466.66666666665384
R11510 n_12_12_4 n_13_12_4 151.51515151514872
R11511 n_12_12_4 n_12_13_4 151.51515151515142
R11512 n_12_12_15 n_13_12_15 9999.999999999727
R11513 n_12_12_15 n_12_13_15 9999.999999999904
R11514 n_12_13_0 n_13_13_0 142.85714285714033
R11515 n_12_13_0 n_12_14_0 142.85714285714286
R11516 n_12_13_0 n_12_13_1 16499.99999999953
R11517 n_12_13_1 n_13_13_1 199.99999999999648
R11518 n_12_13_1 n_12_14_1 200.00000000000003
R11519 n_12_13_1 n_12_13_2 37499.99999999893
R11520 n_12_13_2 n_13_13_2 357.14285714285086
R11521 n_12_13_2 n_12_14_2 357.1428571428572
R11522 n_12_13_2 n_12_13_3 35099.999999999
R11523 n_12_13_3 n_13_13_3 4999.999999999907
R11524 n_12_13_3 n_12_14_3 4999.999999999996
R11525 n_12_13_3 n_12_13_4 466.66666666665384
R11526 n_12_13_4 n_13_13_4 151.51515151514872
R11527 n_12_13_4 n_12_14_4 151.51515151515142
R11528 n_12_13_15 n_13_13_15 9999.999999999727
R11529 n_12_13_15 n_12_14_15 9999.999999999904
R11530 n_12_14_0 n_13_14_0 142.85714285714033
R11531 n_12_14_0 n_12_15_0 142.85714285714286
R11532 n_12_14_0 n_12_14_1 16499.99999999953
R11533 n_12_14_1 n_13_14_1 199.99999999999648
R11534 n_12_14_1 n_12_15_1 200.00000000000003
R11535 n_12_14_1 n_12_14_2 37499.99999999893
R11536 n_12_14_2 n_13_14_2 357.14285714285086
R11537 n_12_14_2 n_12_15_2 357.1428571428572
R11538 n_12_14_2 n_12_14_3 35099.999999999
R11539 n_12_14_3 n_13_14_3 4999.999999999907
R11540 n_12_14_3 n_12_15_3 4999.999999999996
R11541 n_12_14_3 n_12_14_4 466.66666666665384
R11542 n_12_14_4 n_13_14_4 151.51515151514872
R11543 n_12_14_4 n_12_15_4 151.51515151515142
R11544 n_12_14_15 n_13_14_15 9999.999999999727
R11545 n_12_14_15 n_12_15_15 9999.999999999904
R11546 n_12_15_0 n_13_15_0 142.85714285714033
R11547 n_12_15_0 n_12_16_0 4174.88607142851
R11548 n_12_15_0 n_12_15_1 16499.99999999953
R11549 n_12_15_1 n_13_15_1 199.99999999999648
R11550 n_12_15_1 n_12_16_1 5844.840499999915
R11551 n_12_15_1 n_12_15_2 37499.99999999893
R11552 n_12_15_2 n_13_15_2 357.14285714285086
R11553 n_12_15_2 n_12_16_2 10437.215178571278
R11554 n_12_15_2 n_12_15_3 35099.999999999
R11555 n_12_15_3 n_13_15_3 4999.999999999907
R11556 n_12_15_3 n_12_16_3 146121.0124999977
R11557 n_12_15_3 n_12_15_4 466.66666666665384
R11558 n_12_15_4 n_13_15_4 151.51515151514872
R11559 n_12_15_4 n_12_16_4 4427.909469696901
R11560 n_12_15_15 n_13_15_15 9999.999999999727
R11561 n_12_15_15 n_12_16_15 292242.02499999286
R11562 n_12_16_0 n_13_16_0 2.486703379443564
R11563 n_12_16_0 n_12_17_0 8206.914999999883
R11564 n_12_16_0 n_12_16_1 287.21424032572844
R11565 n_12_16_1 n_13_16_1 3.481384731220988
R11566 n_12_16_1 n_12_17_1 11489.680999999837
R11567 n_12_16_1 n_12_16_2 652.7596371039283
R11568 n_12_16_2 n_13_16_2 6.216758448608909
R11569 n_12_16_2 n_12_17_2 20517.287499999708
R11570 n_12_16_2 n_12_16_3 610.9830203292769
R11571 n_12_16_3 n_13_16_3 87.03461828052463
R11572 n_12_16_3 n_12_17_3 287242.0249999956
R11573 n_12_16_3 n_12_16_4 8.12323103951556
R11574 n_12_16_4 n_13_16_4 2.637412675167413
R11575 n_12_16_4 n_12_17_4 8704.303787878656
R11576 n_12_16_15 n_13_16_15 174.06923656104772
R11577 n_12_16_15 n_12_17_15 574484.0499999862
R11578 n_12_17_0 n_13_17_0 2.4867033794435596
R11579 n_12_17_0 n_12_18_0 8206.914999999888
R11580 n_12_17_0 n_12_17_1 287.2142403257281
R11581 n_12_17_1 n_13_17_1 3.4813847312209845
R11582 n_12_17_1 n_12_18_1 11489.680999999842
R11583 n_12_17_1 n_12_17_2 652.7596371039276
R11584 n_12_17_2 n_13_17_2 6.2167584486089
R11585 n_12_17_2 n_12_18_2 20517.287499999722
R11586 n_12_17_2 n_12_17_3 610.9830203292762
R11587 n_12_17_3 n_13_17_3 87.03461828052454
R11588 n_12_17_3 n_12_18_3 287242.0249999958
R11589 n_12_17_3 n_12_17_4 8.123231039515549
R11590 n_12_17_4 n_13_17_4 2.6374126751674103
R11591 n_12_17_4 n_12_18_4 8704.303787878662
R11592 n_12_17_15 n_13_17_15 174.06923656104752
R11593 n_12_17_15 n_12_18_15 574484.0499999865
R11594 n_12_18_0 n_13_18_0 2.4867033794435596
R11595 n_12_18_0 n_12_19_0 8206.914999999883
R11596 n_12_18_0 n_12_18_1 287.2142403257281
R11597 n_12_18_1 n_13_18_1 3.4813847312209845
R11598 n_12_18_1 n_12_19_1 11489.680999999837
R11599 n_12_18_1 n_12_18_2 652.7596371039276
R11600 n_12_18_2 n_13_18_2 6.2167584486089
R11601 n_12_18_2 n_12_19_2 20517.287499999708
R11602 n_12_18_2 n_12_18_3 610.9830203292762
R11603 n_12_18_3 n_13_18_3 87.03461828052454
R11604 n_12_18_3 n_12_19_3 287242.0249999956
R11605 n_12_18_3 n_12_18_4 8.123231039515549
R11606 n_12_18_4 n_13_18_4 2.6374126751674103
R11607 n_12_18_4 n_12_19_4 8704.303787878656
R11608 n_12_18_15 n_13_18_15 174.06923656104752
R11609 n_12_18_15 n_12_19_15 574484.0499999862
R11610 n_12_19_0 n_13_19_0 2.486703379443564
R11611 n_12_19_0 n_12_20_0 4174.886084484129
R11612 n_12_19_0 n_12_19_1 287.21424032572844
R11613 n_12_19_1 n_13_19_1 3.481384731220988
R11614 n_12_19_1 n_12_20_1 5844.8405182777815
R11615 n_12_19_1 n_12_19_2 652.7596371039283
R11616 n_12_19_2 n_13_19_2 6.216758448608909
R11617 n_12_19_2 n_12_20_2 10437.215211210323
R11618 n_12_19_2 n_12_19_3 610.9830203292769
R11619 n_12_19_3 n_13_19_3 87.03461828052463
R11620 n_12_19_3 n_12_20_3 146121.01295694438
R11621 n_12_19_3 n_12_19_4 8.12323103951556
R11622 n_12_19_4 n_13_19_4 2.637412675167413
R11623 n_12_19_4 n_12_20_4 4427.90948354377
R11624 n_12_19_15 n_13_19_15 174.06923656104772
R11625 n_12_19_15 n_12_20_15 292242.0259138862
R11626 n_12_20_0 n_13_20_0 142.8571167459075
R11627 n_12_20_0 n_12_21_0 142.85716896838048
R11628 n_12_20_0 n_12_20_1 16499.996984152138
R11629 n_12_20_1 n_13_20_1 199.99996344427046
R11630 n_12_20_1 n_12_21_1 200.00003655573266
R11631 n_12_20_1 n_12_20_2 37499.99314580031
R11632 n_12_20_2 n_13_20_2 357.1427918647688
R11633 n_12_20_2 n_12_21_2 357.1429224209512
R11634 n_12_20_2 n_12_20_3 35099.99358446909
R11635 n_12_20_3 n_13_20_3 4999.999086106758
R11636 n_12_20_3 n_12_21_3 5000.000913893312
R11637 n_12_20_3 n_12_20_4 466.66658136996
R11638 n_12_20_4 n_13_20_4 151.51512382141692
R11639 n_12_20_4 n_12_21_4 151.51517920888827
R11640 n_12_20_15 n_13_20_15 9999.998172213425
R11641 n_12_20_15 n_12_21_15 10000.001827786537
R11642 n_12_21_0 n_13_21_0 142.8571167459075
R11643 n_12_21_0 n_12_22_0 142.8571689683754
R11644 n_12_21_0 n_12_21_1 16499.996984152138
R11645 n_12_21_1 n_13_21_1 199.99996344427046
R11646 n_12_21_1 n_12_22_1 200.00003655572556
R11647 n_12_21_1 n_12_21_2 37499.99314580031
R11648 n_12_21_2 n_13_21_2 357.1427918647688
R11649 n_12_21_2 n_12_22_2 357.14292242093853
R11650 n_12_21_2 n_12_21_3 35099.99358446909
R11651 n_12_21_3 n_13_21_3 4999.999086106758
R11652 n_12_21_3 n_12_22_3 5000.000913893135
R11653 n_12_21_3 n_12_21_4 466.66658136996
R11654 n_12_21_4 n_13_21_4 151.51512382141692
R11655 n_12_21_4 n_12_22_4 151.5151792088829
R11656 n_12_21_15 n_13_21_15 9999.998172213425
R11657 n_12_21_15 n_12_22_15 10000.001827786182
R11658 n_12_22_0 n_13_22_0 142.85711674591764
R11659 n_12_22_0 n_12_23_0 142.8571689683754
R11660 n_12_22_0 n_12_22_1 16499.99698415331
R11661 n_12_22_1 n_13_22_1 199.9999634442847
R11662 n_12_22_1 n_12_23_1 200.00003655572556
R11663 n_12_22_1 n_12_22_2 37499.99314580298
R11664 n_12_22_2 n_13_22_2 357.14279186479416
R11665 n_12_22_2 n_12_23_2 357.14292242093853
R11666 n_12_22_2 n_12_22_3 35099.99358447159
R11667 n_12_22_3 n_13_22_3 4999.999086107113
R11668 n_12_22_3 n_12_23_3 5000.000913893135
R11669 n_12_22_3 n_12_22_4 466.66658136999297
R11670 n_12_22_4 n_13_22_4 151.51512382142766
R11671 n_12_22_4 n_12_23_4 151.5151792088829
R11672 n_12_22_15 n_13_22_15 9999.998172214138
R11673 n_12_22_15 n_12_23_15 10000.001827786182
R11674 n_12_23_0 n_13_23_0 142.8571167459075
R11675 n_12_23_0 n_12_24_0 1646.678571428551
R11676 n_12_23_0 n_12_23_1 16499.996984152138
R11677 n_12_23_1 n_13_23_1 199.99996344427046
R11678 n_12_23_1 n_12_24_1 2305.3499999999717
R11679 n_12_23_1 n_12_23_2 37499.99314580031
R11680 n_12_23_2 n_13_23_2 357.1427918647688
R11681 n_12_23_2 n_12_24_2 4116.696428571378
R11682 n_12_23_2 n_12_23_3 35099.99358446909
R11683 n_12_23_3 n_13_23_3 4999.999086106758
R11684 n_12_23_3 n_12_24_3 57633.749999999236
R11685 n_12_23_3 n_12_23_4 466.66658136996
R11686 n_12_23_4 n_13_23_4 151.51512382141692
R11687 n_12_23_4 n_12_24_4 1746.4772727272498
R11688 n_12_23_15 n_13_23_15 9999.998172213425
R11689 n_12_23_15 n_12_24_15 115267.49999999745
R11690 n_12_24_0 n_13_24_0 6.477753827788668
R11691 n_12_24_0 n_12_25_0 3150.499973888717
R11692 n_12_24_0 n_12_24_1 748.1805671095831
R11693 n_12_24_1 n_13_24_1 9.068855358904134
R11694 n_12_24_1 n_12_25_1 4410.699963444204
R11695 n_12_24_1 n_12_24_2 1700.410379794507
R11696 n_12_24_2 n_13_24_2 16.19438456947167
R11697 n_12_24_2 n_12_25_2 7876.249934721793
R11698 n_12_24_2 n_12_24_3 1591.5841154876584
R11699 n_12_24_3 n_13_24_3 226.72138397260318
R11700 n_12_24_3 n_12_25_3 110267.49908610499
R11701 n_12_24_3 n_12_24_4 21.16066250410944
R11702 n_12_24_4 n_13_24_4 6.870344968866762
R11703 n_12_24_4 n_12_25_4 3341.439366245606
R11704 n_12_24_4 n_12_24_5 17.48993533502923
R11705 n_12_24_5 n_13_24_5 43.18502551859108
R11706 n_12_24_5 n_12_25_5 21003.33315925809
R11707 n_12_24_5 n_12_24_6 6.045903572602696
R11708 n_12_24_6 n_13_24_6 7.197504253098513
R11709 n_12_24_6 n_12_25_6 3500.5555265430157
R11710 n_12_24_6 n_12_24_7 8.20515484853222
R11711 n_12_24_7 n_13_24_7 12.33857871959749
R11712 n_12_24_7 n_12_25_7 6000.952331216617
R11713 n_12_24_7 n_12_24_8 6.045903572602677
R11714 n_12_24_8 n_13_24_8 12.33857871959749
R11715 n_12_24_8 n_12_25_8 6000.952331216617
R11716 n_12_24_8 n_12_24_9 6.045903572602677
R11717 n_12_24_9 n_13_24_9 12.33857871959749
R11718 n_12_24_9 n_12_25_9 6000.952331216617
R11719 n_12_24_9 n_12_24_10 6.045903572602677
R11720 n_12_24_10 n_13_24_10 12.33857871959749
R11721 n_12_24_10 n_12_25_10 6000.952331216617
R11722 n_12_24_10 n_12_24_11 6.045903572602638
R11723 n_12_24_11 n_13_24_11 12.338578719597646
R11724 n_12_24_11 n_12_25_11 6000.952331216693
R11725 n_12_24_11 n_12_24_12 6.045903572602619
R11726 n_12_24_12 n_13_24_12 12.338578719597567
R11727 n_12_24_12 n_12_25_12 6000.952331216655
R11728 n_12_24_12 n_12_24_13 6.045903572602677
R11729 n_12_24_13 n_13_24_13 12.338578719597411
R11730 n_12_24_13 n_12_25_13 6000.952331216578
R11731 n_12_24_13 n_12_24_14 30.229517863013463
R11732 n_12_24_14 n_13_24_14 1.3709531910663846
R11733 n_12_24_14 n_12_25_14 666.7724812462893
R11734 n_12_24_14 n_12_24_15 934.0921019671247
R11735 n_12_24_15 n_13_24_15 453.44276794520226
R11736 n_12_24_15 n_12_25_15 220534.99817220803
R11737 n_12_25_0 n_13_25_0 6.477753827788689
R11738 n_12_25_0 n_12_26_0 3150.499973888717
R11739 n_12_25_0 n_12_25_1 748.1805671095855
R11740 n_12_25_1 n_13_25_1 9.068855358904163
R11741 n_12_25_1 n_12_26_1 4410.699963444204
R11742 n_12_25_1 n_12_25_2 1700.4103797945122
R11743 n_12_25_2 n_13_25_2 16.194384569471723
R11744 n_12_25_2 n_12_26_2 7876.249934721793
R11745 n_12_25_2 n_12_25_3 1591.5841154876634
R11746 n_12_25_3 n_13_25_3 226.72138397260392
R11747 n_12_25_3 n_12_26_3 110267.49908610499
R11748 n_12_25_3 n_12_25_4 21.160662504109506
R11749 n_12_25_4 n_13_25_4 6.870344968866785
R11750 n_12_25_4 n_12_26_4 3341.439366245606
R11751 n_12_25_4 n_12_25_5 17.489935335029287
R11752 n_12_25_5 n_13_25_5 43.18502551859122
R11753 n_12_25_5 n_12_26_5 21003.33315925809
R11754 n_12_25_5 n_12_25_6 6.0459035726027155
R11755 n_12_25_6 n_13_25_6 7.197504253098536
R11756 n_12_25_6 n_12_26_6 3500.5555265430157
R11757 n_12_25_6 n_12_25_7 8.205154848532247
R11758 n_12_25_7 n_13_25_7 12.33857871959753
R11759 n_12_25_7 n_12_26_7 6000.952331216617
R11760 n_12_25_7 n_12_25_8 6.045903572602697
R11761 n_12_25_8 n_13_25_8 12.33857871959753
R11762 n_12_25_8 n_12_26_8 6000.952331216617
R11763 n_12_25_8 n_12_25_9 6.045903572602697
R11764 n_12_25_9 n_13_25_9 12.33857871959753
R11765 n_12_25_9 n_12_26_9 6000.952331216617
R11766 n_12_25_9 n_12_25_10 6.045903572602697
R11767 n_12_25_10 n_13_25_10 12.33857871959753
R11768 n_12_25_10 n_12_26_10 6000.952331216617
R11769 n_12_25_10 n_12_25_11 6.045903572602658
R11770 n_12_25_11 n_13_25_11 12.338578719597688
R11771 n_12_25_11 n_12_26_11 6000.952331216693
R11772 n_12_25_11 n_12_25_12 6.045903572602638
R11773 n_12_25_12 n_13_25_12 12.338578719597605
R11774 n_12_25_12 n_12_26_12 6000.952331216655
R11775 n_12_25_12 n_12_25_13 6.045903572602697
R11776 n_12_25_13 n_13_25_13 12.338578719597454
R11777 n_12_25_13 n_12_26_13 6000.952331216578
R11778 n_12_25_13 n_12_25_14 30.22951786301356
R11779 n_12_25_14 n_13_25_14 1.370953191066389
R11780 n_12_25_14 n_12_26_14 666.7724812462893
R11781 n_12_25_14 n_12_25_15 934.0921019671276
R11782 n_12_25_15 n_13_25_15 453.44276794520374
R11783 n_12_25_15 n_12_26_15 220534.99817220803
R11784 n_12_26_0 n_13_26_0 6.477753827788668
R11785 n_12_26_0 n_12_27_0 3150.499973888722
R11786 n_12_26_0 n_12_26_1 748.1805671095831
R11787 n_12_26_1 n_13_26_1 9.068855358904134
R11788 n_12_26_1 n_12_27_1 4410.699963444211
R11789 n_12_26_1 n_12_26_2 1700.410379794507
R11790 n_12_26_2 n_13_26_2 16.19438456947167
R11791 n_12_26_2 n_12_27_2 7876.249934721805
R11792 n_12_26_2 n_12_26_3 1591.5841154876584
R11793 n_12_26_3 n_13_26_3 226.72138397260318
R11794 n_12_26_3 n_12_27_3 110267.49908610516
R11795 n_12_26_3 n_12_26_4 21.16066250410944
R11796 n_12_26_4 n_13_26_4 6.870344968866762
R11797 n_12_26_4 n_12_27_4 3341.4393662456114
R11798 n_12_26_4 n_12_26_5 17.48993533502923
R11799 n_12_26_5 n_13_26_5 43.18502551859108
R11800 n_12_26_5 n_12_27_5 21003.333159258123
R11801 n_12_26_5 n_12_26_6 6.045903572602696
R11802 n_12_26_6 n_13_26_6 7.197504253098513
R11803 n_12_26_6 n_12_27_6 3500.555526543021
R11804 n_12_26_6 n_12_26_7 8.20515484853222
R11805 n_12_26_7 n_13_26_7 12.33857871959749
R11806 n_12_26_7 n_12_27_7 6000.952331216627
R11807 n_12_26_7 n_12_26_8 6.045903572602677
R11808 n_12_26_8 n_13_26_8 12.33857871959749
R11809 n_12_26_8 n_12_27_8 6000.952331216627
R11810 n_12_26_8 n_12_26_9 6.045903572602677
R11811 n_12_26_9 n_13_26_9 12.33857871959749
R11812 n_12_26_9 n_12_27_9 6000.952331216627
R11813 n_12_26_9 n_12_26_10 6.045903572602677
R11814 n_12_26_10 n_13_26_10 12.33857871959749
R11815 n_12_26_10 n_12_27_10 6000.952331216627
R11816 n_12_26_10 n_12_26_11 6.045903572602638
R11817 n_12_26_11 n_13_26_11 12.338578719597646
R11818 n_12_26_11 n_12_27_11 6000.952331216702
R11819 n_12_26_11 n_12_26_12 6.045903572602619
R11820 n_12_26_12 n_13_26_12 12.338578719597567
R11821 n_12_26_12 n_12_27_12 6000.952331216665
R11822 n_12_26_12 n_12_26_13 6.045903572602677
R11823 n_12_26_13 n_13_26_13 12.338578719597411
R11824 n_12_26_13 n_12_27_13 6000.952331216588
R11825 n_12_26_13 n_12_26_14 30.229517863013463
R11826 n_12_26_14 n_13_26_14 1.3709531910663846
R11827 n_12_26_14 n_12_27_14 666.7724812462903
R11828 n_12_26_14 n_12_26_15 934.0921019671247
R11829 n_12_26_15 n_13_26_15 453.44276794520226
R11830 n_12_26_15 n_12_27_15 220534.99817220838
R11831 n_12_27_0 n_13_27_0 6.477753827788668
R11832 n_12_27_0 n_12_27_1 748.1805671095831
R11833 n_12_27_1 n_13_27_1 9.068855358904134
R11834 n_12_27_1 n_12_27_2 1700.410379794507
R11835 n_12_27_2 n_13_27_2 16.19438456947167
R11836 n_12_27_2 n_12_27_3 1591.5841154876584
R11837 n_12_27_3 n_13_27_3 226.72138397260318
R11838 n_12_27_3 n_12_27_4 21.16066250410944
R11839 n_12_27_4 n_13_27_4 6.870344968866762
R11840 n_12_27_4 n_12_27_5 17.48993533502923
R11841 n_12_27_5 n_13_27_5 43.18502551859108
R11842 n_12_27_5 n_12_27_6 6.045903572602696
R11843 n_12_27_6 n_13_27_6 7.197504253098513
R11844 n_12_27_6 n_12_27_7 8.20515484853222
R11845 n_12_27_7 n_13_27_7 12.33857871959749
R11846 n_12_27_7 n_12_27_8 6.045903572602677
R11847 n_12_27_8 n_13_27_8 12.33857871959749
R11848 n_12_27_8 n_12_27_9 6.045903572602677
R11849 n_12_27_9 n_13_27_9 12.33857871959749
R11850 n_12_27_9 n_12_27_10 6.045903572602677
R11851 n_12_27_10 n_13_27_10 12.33857871959749
R11852 n_12_27_10 n_12_27_11 6.045903572602638
R11853 n_12_27_11 n_13_27_11 12.338578719597646
R11854 n_12_27_11 n_12_27_12 6.045903572602619
R11855 n_12_27_12 n_13_27_12 12.338578719597567
R11856 n_12_27_12 n_12_27_13 6.045903572602677
R11857 n_12_27_13 n_13_27_13 12.338578719597411
R11858 n_12_27_13 n_12_27_14 30.229517863013463
R11859 n_12_27_14 n_13_27_14 1.3709531910663846
R11860 n_12_27_14 n_12_27_15 934.0921019671247
R11861 n_12_27_15 n_13_27_15 453.44276794520226
R11862 n_13_0_0 n_14_0_0 6.477753269925437
R11863 n_13_0_0 n_13_1_0 3150.5002452094077
R11864 n_13_0_0 n_13_0_1 748.1805026764197
R11865 n_13_0_1 n_14_0_1 9.06885457789561
R11866 n_13_0_1 n_13_1_1 4410.700343293171
R11867 n_13_0_1 n_13_0_2 1700.4102333554993
R11868 n_13_0_2 n_14_0_2 16.19438317481359
R11869 n_13_0_2 n_13_1_2 7876.250613023518
R11870 n_13_0_2 n_13_0_3 1591.5839784207474
R11871 n_13_0_3 n_14_0_3 226.72136444739004
R11872 n_13_0_3 n_13_1_3 110267.50858232914
R11873 n_13_0_3 n_13_0_4 21.160660681757346
R11874 n_13_0_4 n_14_0_4 6.870344377193638
R11875 n_13_0_4 n_13_1_4 3341.4396540099747
R11876 n_13_0_4 n_13_0_5 17.48993382879944
R11877 n_13_0_5 n_14_0_5 43.18502179950286
R11878 n_13_0_5 n_13_1_5 21003.334968062696
R11879 n_13_0_5 n_13_0_6 6.0459030519306705
R11880 n_13_0_6 n_14_0_6 7.197503633250479
R11881 n_13_0_6 n_13_1_6 3500.5558280104497
R11882 n_13_0_6 n_13_0_7 8.2051541419059
R11883 n_13_0_7 n_14_0_7 12.338577657000858
R11884 n_13_0_7 n_13_1_7 6000.952848017933
R11885 n_13_0_7 n_13_0_8 6.045903051930652
R11886 n_13_0_8 n_14_0_8 12.338577657000858
R11887 n_13_0_8 n_13_1_8 6000.952848017933
R11888 n_13_0_8 n_13_0_9 6.045903051930652
R11889 n_13_0_9 n_14_0_9 12.338577657000858
R11890 n_13_0_9 n_13_1_9 6000.952848017933
R11891 n_13_0_9 n_13_0_10 6.045903051930652
R11892 n_13_0_10 n_14_0_10 12.338577657000858
R11893 n_13_0_10 n_13_1_10 6000.952848017933
R11894 n_13_0_10 n_13_0_11 6.045903051930614
R11895 n_13_0_11 n_14_0_11 12.338577657001014
R11896 n_13_0_11 n_13_1_11 6000.952848018009
R11897 n_13_0_11 n_13_0_12 6.045903051930594
R11898 n_13_0_12 n_14_0_12 12.33857765700094
R11899 n_13_0_12 n_13_1_12 6000.9528480179715
R11900 n_13_0_12 n_13_0_13 6.045903051930651
R11901 n_13_0_13 n_14_0_13 12.33857765700078
R11902 n_13_0_13 n_13_1_13 6000.952848017895
R11903 n_13_0_13 n_13_0_14 30.229515259653333
R11904 n_13_0_14 n_14_0_14 1.3709530730000925
R11905 n_13_0_14 n_13_1_14 666.7725386686578
R11906 n_13_0_14 n_13_0_15 934.0920215232965
R11907 n_13_0_15 n_14_0_15 453.4427288947761
R11908 n_13_0_15 n_13_1_15 220535.0171646564
R11909 n_13_1_0 n_14_1_0 6.477753269925437
R11910 n_13_1_0 n_13_2_0 3150.5002452094077
R11911 n_13_1_0 n_13_1_1 748.1805026764197
R11912 n_13_1_1 n_14_1_1 9.06885457789561
R11913 n_13_1_1 n_13_2_1 4410.700343293171
R11914 n_13_1_1 n_13_1_2 1700.4102333554993
R11915 n_13_1_2 n_14_1_2 16.19438317481359
R11916 n_13_1_2 n_13_2_2 7876.250613023518
R11917 n_13_1_2 n_13_1_3 1591.5839784207474
R11918 n_13_1_3 n_14_1_3 226.72136444739004
R11919 n_13_1_3 n_13_2_3 110267.50858232914
R11920 n_13_1_3 n_13_1_4 21.160660681757346
R11921 n_13_1_4 n_14_1_4 6.870344377193638
R11922 n_13_1_4 n_13_2_4 3341.4396540099747
R11923 n_13_1_4 n_13_1_5 17.48993382879944
R11924 n_13_1_5 n_14_1_5 43.18502179950286
R11925 n_13_1_5 n_13_2_5 21003.334968062696
R11926 n_13_1_5 n_13_1_6 6.0459030519306705
R11927 n_13_1_6 n_14_1_6 7.197503633250479
R11928 n_13_1_6 n_13_2_6 3500.5558280104497
R11929 n_13_1_6 n_13_1_7 8.2051541419059
R11930 n_13_1_7 n_14_1_7 12.338577657000858
R11931 n_13_1_7 n_13_2_7 6000.952848017933
R11932 n_13_1_7 n_13_1_8 6.045903051930652
R11933 n_13_1_8 n_14_1_8 12.338577657000858
R11934 n_13_1_8 n_13_2_8 6000.952848017933
R11935 n_13_1_8 n_13_1_9 6.045903051930652
R11936 n_13_1_9 n_14_1_9 12.338577657000858
R11937 n_13_1_9 n_13_2_9 6000.952848017933
R11938 n_13_1_9 n_13_1_10 6.045903051930652
R11939 n_13_1_10 n_14_1_10 12.338577657000858
R11940 n_13_1_10 n_13_2_10 6000.952848017933
R11941 n_13_1_10 n_13_1_11 6.045903051930614
R11942 n_13_1_11 n_14_1_11 12.338577657001014
R11943 n_13_1_11 n_13_2_11 6000.952848018009
R11944 n_13_1_11 n_13_1_12 6.045903051930594
R11945 n_13_1_12 n_14_1_12 12.33857765700094
R11946 n_13_1_12 n_13_2_12 6000.9528480179715
R11947 n_13_1_12 n_13_1_13 6.045903051930651
R11948 n_13_1_13 n_14_1_13 12.33857765700078
R11949 n_13_1_13 n_13_2_13 6000.952848017895
R11950 n_13_1_13 n_13_1_14 30.229515259653333
R11951 n_13_1_14 n_14_1_14 1.3709530730000925
R11952 n_13_1_14 n_13_2_14 666.7725386686578
R11953 n_13_1_14 n_13_1_15 934.0920215232965
R11954 n_13_1_15 n_14_1_15 453.4427288947761
R11955 n_13_1_15 n_13_2_15 220535.0171646564
R11956 n_13_2_0 n_14_2_0 6.477753269925437
R11957 n_13_2_0 n_13_3_0 3150.5002452094077
R11958 n_13_2_0 n_13_2_1 748.1805026764197
R11959 n_13_2_1 n_14_2_1 9.06885457789561
R11960 n_13_2_1 n_13_3_1 4410.700343293171
R11961 n_13_2_1 n_13_2_2 1700.4102333554993
R11962 n_13_2_2 n_14_2_2 16.19438317481359
R11963 n_13_2_2 n_13_3_2 7876.250613023518
R11964 n_13_2_2 n_13_2_3 1591.5839784207474
R11965 n_13_2_3 n_14_2_3 226.72136444739004
R11966 n_13_2_3 n_13_3_3 110267.50858232914
R11967 n_13_2_3 n_13_2_4 21.160660681757346
R11968 n_13_2_4 n_14_2_4 6.870344377193638
R11969 n_13_2_4 n_13_3_4 3341.4396540099747
R11970 n_13_2_4 n_13_2_5 17.48993382879944
R11971 n_13_2_5 n_14_2_5 43.18502179950286
R11972 n_13_2_5 n_13_3_5 21003.334968062696
R11973 n_13_2_5 n_13_2_6 6.0459030519306705
R11974 n_13_2_6 n_14_2_6 7.197503633250479
R11975 n_13_2_6 n_13_3_6 3500.5558280104497
R11976 n_13_2_6 n_13_2_7 8.2051541419059
R11977 n_13_2_7 n_14_2_7 12.338577657000858
R11978 n_13_2_7 n_13_3_7 6000.952848017933
R11979 n_13_2_7 n_13_2_8 6.045903051930652
R11980 n_13_2_8 n_14_2_8 12.338577657000858
R11981 n_13_2_8 n_13_3_8 6000.952848017933
R11982 n_13_2_8 n_13_2_9 6.045903051930652
R11983 n_13_2_9 n_14_2_9 12.338577657000858
R11984 n_13_2_9 n_13_3_9 6000.952848017933
R11985 n_13_2_9 n_13_2_10 6.045903051930652
R11986 n_13_2_10 n_14_2_10 12.338577657000858
R11987 n_13_2_10 n_13_3_10 6000.952848017933
R11988 n_13_2_10 n_13_2_11 6.045903051930614
R11989 n_13_2_11 n_14_2_11 12.338577657001014
R11990 n_13_2_11 n_13_3_11 6000.952848018009
R11991 n_13_2_11 n_13_2_12 6.045903051930594
R11992 n_13_2_12 n_14_2_12 12.33857765700094
R11993 n_13_2_12 n_13_3_12 6000.9528480179715
R11994 n_13_2_12 n_13_2_13 6.045903051930651
R11995 n_13_2_13 n_14_2_13 12.33857765700078
R11996 n_13_2_13 n_13_3_13 6000.952848017895
R11997 n_13_2_13 n_13_2_14 30.229515259653333
R11998 n_13_2_14 n_14_2_14 1.3709530730000925
R11999 n_13_2_14 n_13_3_14 666.7725386686578
R12000 n_13_2_14 n_13_2_15 934.0920215232965
R12001 n_13_2_15 n_14_2_15 453.4427288947761
R12002 n_13_2_15 n_13_3_15 220535.0171646564
R12003 n_13_3_0 n_14_3_0 6.477753269925437
R12004 n_13_3_0 n_13_4_0 1646.6785714286061
R12005 n_13_3_0 n_13_3_1 748.1805026764197
R12006 n_13_3_1 n_14_3_1 9.06885457789561
R12007 n_13_3_1 n_13_4_1 2305.350000000048
R12008 n_13_3_1 n_13_3_2 1700.4102333554993
R12009 n_13_3_2 n_14_3_2 16.19438317481359
R12010 n_13_3_2 n_13_4_2 4116.696428571514
R12011 n_13_3_2 n_13_3_3 1591.5839784207474
R12012 n_13_3_3 n_14_3_3 226.72136444739004
R12013 n_13_3_3 n_13_4_3 57633.75000000114
R12014 n_13_3_3 n_13_3_4 21.160660681757346
R12015 n_13_3_4 n_14_3_4 6.870344377193638
R12016 n_13_3_4 n_13_4_4 1746.4772727273078
R12017 n_13_3_4 n_13_3_5 17.48993382879944
R12018 n_13_3_5 n_14_3_5 43.18502179950286
R12019 n_13_3_5 n_13_3_6 6.0459030519306705
R12020 n_13_3_6 n_14_3_6 7.197503633250479
R12021 n_13_3_6 n_13_3_7 8.2051541419059
R12022 n_13_3_7 n_14_3_7 12.338577657000858
R12023 n_13_3_7 n_13_3_8 6.045903051930652
R12024 n_13_3_8 n_14_3_8 12.338577657000858
R12025 n_13_3_8 n_13_3_9 6.045903051930652
R12026 n_13_3_9 n_14_3_9 12.338577657000858
R12027 n_13_3_9 n_13_3_10 6.045903051930652
R12028 n_13_3_10 n_14_3_10 12.338577657000858
R12029 n_13_3_10 n_13_3_11 6.045903051930614
R12030 n_13_3_11 n_14_3_11 12.338577657001014
R12031 n_13_3_11 n_13_3_12 6.045903051930594
R12032 n_13_3_12 n_14_3_12 12.33857765700094
R12033 n_13_3_12 n_13_3_13 6.045903051930651
R12034 n_13_3_13 n_14_3_13 12.33857765700078
R12035 n_13_3_13 n_13_3_14 30.229515259653333
R12036 n_13_3_14 n_14_3_14 1.3709530730000925
R12037 n_13_3_14 n_13_3_15 934.0920215232965
R12038 n_13_3_15 n_14_3_15 453.4427288947761
R12039 n_13_3_15 n_13_4_15 115267.5000000013
R12040 n_13_4_0 n_14_4_0 142.85738806690233
R12041 n_13_4_0 n_13_5_0 142.85689764780557
R12042 n_13_4_0 n_13_4_1 16500.02832172792
R12043 n_13_4_1 n_14_4_1 200.00034329366324
R12044 n_13_4_1 n_13_5_1 199.99965670692785
R12045 n_13_4_1 n_13_4_2 37500.06436756346
R12046 n_13_4_2 n_14_4_2 357.1434701672558
R12047 n_13_4_2 n_13_5_2 357.142244119514
R12048 n_13_4_2 n_13_4_3 35100.0602480394
R12049 n_13_4_3 n_14_4_3 5000.0085823415775
R12050 n_13_4_3 n_13_5_3 4999.991417673191
R12051 n_13_4_3 n_13_4_4 466.66746768523456
R12052 n_13_4_4 n_14_4_4 151.5154115861084
R12053 n_13_4_4 n_13_5_4 151.51489144464216
R12054 n_13_4_15 n_14_4_15 10000.017164683066
R12055 n_13_4_15 n_13_5_15 9999.982835346294
R12056 n_13_5_0 n_14_5_0 142.8573880668998
R12057 n_13_5_0 n_13_6_0 142.85689764780685
R12058 n_13_5_0 n_13_5_1 16500.028321727626
R12059 n_13_5_1 n_14_5_1 200.00034329365968
R12060 n_13_5_1 n_13_6_1 199.9996567069296
R12061 n_13_5_1 n_13_5_2 37500.06436756279
R12062 n_13_5_2 n_14_5_2 357.14347016724946
R12063 n_13_5_2 n_13_6_2 357.1422441195171
R12064 n_13_5_2 n_13_5_3 35100.06024803877
R12065 n_13_5_3 n_14_5_3 5000.008582341488
R12066 n_13_5_3 n_13_6_3 4999.9914176732345
R12067 n_13_5_3 n_13_5_4 466.66746768522626
R12068 n_13_5_4 n_14_5_4 151.5154115861057
R12069 n_13_5_4 n_13_6_4 151.5148914446435
R12070 n_13_5_15 n_14_5_15 10000.017164682886
R12071 n_13_5_15 n_13_6_15 9999.982835346384
R12072 n_13_6_0 n_14_6_0 142.8573880668998
R12073 n_13_6_0 n_13_7_0 142.85689764780557
R12074 n_13_6_0 n_13_6_1 16500.028321727626
R12075 n_13_6_1 n_14_6_1 200.00034329365968
R12076 n_13_6_1 n_13_7_1 199.99965670692785
R12077 n_13_6_1 n_13_6_2 37500.06436756279
R12078 n_13_6_2 n_14_6_2 357.14347016724946
R12079 n_13_6_2 n_13_7_2 357.142244119514
R12080 n_13_6_2 n_13_6_3 35100.06024803877
R12081 n_13_6_3 n_14_6_3 5000.008582341488
R12082 n_13_6_3 n_13_7_3 4999.991417673191
R12083 n_13_6_3 n_13_6_4 466.66746768522626
R12084 n_13_6_4 n_14_6_4 151.5154115861057
R12085 n_13_6_4 n_13_7_4 151.51489144464216
R12086 n_13_6_15 n_14_6_15 10000.017164682886
R12087 n_13_6_15 n_13_7_15 9999.982835346294
R12088 n_13_7_0 n_14_7_0 142.85738806690233
R12089 n_13_7_0 n_13_8_0 4174.885948823989
R12090 n_13_7_0 n_13_7_1 16500.02832172792
R12091 n_13_7_1 n_14_7_1 200.00034329366324
R12092 n_13_7_1 n_13_8_1 5844.840328353585
R12093 n_13_7_1 n_13_7_2 37500.06436756346
R12094 n_13_7_2 n_14_7_2 357.1434701672558
R12095 n_13_7_2 n_13_8_2 10437.214872059973
R12096 n_13_7_2 n_13_7_3 35100.0602480394
R12097 n_13_7_3 n_14_7_3 5000.0085823415775
R12098 n_13_7_3 n_13_8_3 146121.00820883946
R12099 n_13_7_3 n_13_7_4 466.66746768523456
R12100 n_13_7_4 n_14_7_4 151.5154115861084
R12101 n_13_7_4 n_13_8_4 4427.909339661803
R12102 n_13_7_15 n_14_7_15 10000.017164683066
R12103 n_13_7_15 n_13_8_15 292242.01641767647
R12104 n_13_8_0 n_14_8_0 2.486703379443518
R12105 n_13_8_0 n_13_9_0 8206.915000000175
R12106 n_13_8_0 n_13_8_1 287.2142403257385
R12107 n_13_8_1 n_14_8_1 3.4813847312209245
R12108 n_13_8_1 n_13_9_1 11489.681000000248
R12109 n_13_8_1 n_13_8_2 652.7596371039511
R12110 n_13_8_2 n_14_8_2 6.216758448608794
R12111 n_13_8_2 n_13_9_2 20517.287500000442
R12112 n_13_8_2 n_13_8_3 610.9830203292984
R12113 n_13_8_3 n_14_8_3 87.03461828052303
R12114 n_13_8_3 n_13_9_3 287242.02500000584
R12115 n_13_8_3 n_13_8_4 8.123231039515844
R12116 n_13_8_4 n_14_8_4 2.637412675167365
R12117 n_13_8_4 n_13_9_4 8704.303787878967
R12118 n_13_8_15 n_14_8_15 174.06923656104453
R12119 n_13_8_15 n_13_9_15 574484.0500000068
R12120 n_13_9_0 n_14_9_0 2.4867033794435156
R12121 n_13_9_0 n_13_10_0 8206.915000000175
R12122 n_13_9_0 n_13_9_1 287.21424032573833
R12123 n_13_9_1 n_14_9_1 3.4813847312209223
R12124 n_13_9_1 n_13_10_1 11489.681000000248
R12125 n_13_9_1 n_13_9_2 652.7596371039508
R12126 n_13_9_2 n_14_9_2 6.21675844860879
R12127 n_13_9_2 n_13_10_2 20517.287500000442
R12128 n_13_9_2 n_13_9_3 610.983020329298
R12129 n_13_9_3 n_14_9_3 87.03461828052299
R12130 n_13_9_3 n_13_10_3 287242.02500000584
R12131 n_13_9_3 n_13_9_4 8.12323103951584
R12132 n_13_9_4 n_14_9_4 2.637412675167363
R12133 n_13_9_4 n_13_10_4 8704.303787878967
R12134 n_13_9_15 n_14_9_15 174.06923656104442
R12135 n_13_9_15 n_13_10_15 574484.0500000068
R12136 n_13_10_0 n_14_10_0 2.486703379443518
R12137 n_13_10_0 n_13_11_0 8206.915000000174
R12138 n_13_10_0 n_13_10_1 287.2142403257385
R12139 n_13_10_1 n_14_10_1 3.4813847312209245
R12140 n_13_10_1 n_13_11_1 11489.681000000244
R12141 n_13_10_1 n_13_10_2 652.7596371039511
R12142 n_13_10_2 n_14_10_2 6.216758448608794
R12143 n_13_10_2 n_13_11_2 20517.287500000435
R12144 n_13_10_2 n_13_10_3 610.9830203292984
R12145 n_13_10_3 n_14_10_3 87.03461828052303
R12146 n_13_10_3 n_13_11_3 287242.0250000058
R12147 n_13_10_3 n_13_10_4 8.123231039515844
R12148 n_13_10_4 n_14_10_4 2.637412675167365
R12149 n_13_10_4 n_13_11_4 8704.303787878966
R12150 n_13_10_15 n_14_10_15 174.06923656104453
R12151 n_13_10_15 n_13_11_15 574484.0500000067
R12152 n_13_11_0 n_14_11_0 2.486703379443518
R12153 n_13_11_0 n_13_12_0 4174.886071428661
R12154 n_13_11_0 n_13_11_1 287.2142403257385
R12155 n_13_11_1 n_14_11_1 3.4813847312209245
R12156 n_13_11_1 n_13_12_1 5844.840500000126
R12157 n_13_11_1 n_13_11_2 652.7596371039511
R12158 n_13_11_2 n_14_11_2 6.216758448608794
R12159 n_13_11_2 n_13_12_2 10437.215178571652
R12160 n_13_11_2 n_13_11_3 610.9830203292984
R12161 n_13_11_3 n_14_11_3 87.03461828052303
R12162 n_13_11_3 n_13_12_3 146121.01250000298
R12163 n_13_11_3 n_13_11_4 8.123231039515844
R12164 n_13_11_4 n_14_11_4 2.637412675167365
R12165 n_13_11_4 n_13_12_4 4427.9094696970615
R12166 n_13_11_15 n_14_11_15 174.06923656104453
R12167 n_13_11_15 n_13_12_15 292242.02500000346
R12168 n_13_12_0 n_14_12_0 142.8571428571378
R12169 n_13_12_0 n_13_13_0 142.85714285714795
R12170 n_13_12_0 n_13_12_1 16500.000000000116
R12171 n_13_12_1 n_14_12_1 199.99999999999292
R12172 n_13_12_1 n_13_13_1 200.00000000000713
R12173 n_13_12_1 n_13_12_2 37500.00000000026
R12174 n_13_12_2 n_14_12_2 357.14285714284455
R12175 n_13_12_2 n_13_13_2 357.14285714286984
R12176 n_13_12_2 n_13_12_3 35100.00000000025
R12177 n_13_12_3 n_14_12_3 4999.999999999818
R12178 n_13_12_3 n_13_13_3 5000.000000000173
R12179 n_13_12_3 n_13_12_4 466.6666666666704
R12180 n_13_12_4 n_14_12_4 151.51515151514604
R12181 n_13_12_4 n_13_13_4 151.5151515151568
R12182 n_13_12_15 n_14_12_15 9999.999999999549
R12183 n_13_12_15 n_13_13_15 10000.00000000026
R12184 n_13_13_0 n_14_13_0 142.8571428571378
R12185 n_13_13_0 n_13_14_0 142.85714285714795
R12186 n_13_13_0 n_13_13_1 16500.000000000116
R12187 n_13_13_1 n_14_13_1 199.99999999999292
R12188 n_13_13_1 n_13_14_1 200.00000000000713
R12189 n_13_13_1 n_13_13_2 37500.00000000026
R12190 n_13_13_2 n_14_13_2 357.14285714284455
R12191 n_13_13_2 n_13_14_2 357.14285714286984
R12192 n_13_13_2 n_13_13_3 35100.00000000025
R12193 n_13_13_3 n_14_13_3 4999.999999999818
R12194 n_13_13_3 n_13_14_3 5000.000000000173
R12195 n_13_13_3 n_13_13_4 466.6666666666704
R12196 n_13_13_4 n_14_13_4 151.51515151514604
R12197 n_13_13_4 n_13_14_4 151.5151515151568
R12198 n_13_13_15 n_14_13_15 9999.999999999549
R12199 n_13_13_15 n_13_14_15 10000.00000000026
R12200 n_13_14_0 n_14_14_0 142.8571428571378
R12201 n_13_14_0 n_13_15_0 142.85714285714795
R12202 n_13_14_0 n_13_14_1 16500.000000000116
R12203 n_13_14_1 n_14_14_1 199.99999999999292
R12204 n_13_14_1 n_13_15_1 200.00000000000713
R12205 n_13_14_1 n_13_14_2 37500.00000000026
R12206 n_13_14_2 n_14_14_2 357.14285714284455
R12207 n_13_14_2 n_13_15_2 357.14285714286984
R12208 n_13_14_2 n_13_14_3 35100.00000000025
R12209 n_13_14_3 n_14_14_3 4999.999999999818
R12210 n_13_14_3 n_13_15_3 5000.000000000173
R12211 n_13_14_3 n_13_14_4 466.6666666666704
R12212 n_13_14_4 n_14_14_4 151.51515151514604
R12213 n_13_14_4 n_13_15_4 151.5151515151568
R12214 n_13_14_15 n_14_14_15 9999.999999999549
R12215 n_13_14_15 n_13_15_15 10000.00000000026
R12216 n_13_15_0 n_14_15_0 142.8571428571378
R12217 n_13_15_0 n_13_16_0 4174.886071428658
R12218 n_13_15_0 n_13_15_1 16500.000000000116
R12219 n_13_15_1 n_14_15_1 199.99999999999292
R12220 n_13_15_1 n_13_16_1 5844.840500000122
R12221 n_13_15_1 n_13_15_2 37500.00000000026
R12222 n_13_15_2 n_14_15_2 357.14285714284455
R12223 n_13_15_2 n_13_16_2 10437.215178571645
R12224 n_13_15_2 n_13_15_3 35100.00000000025
R12225 n_13_15_3 n_14_15_3 4999.999999999818
R12226 n_13_15_3 n_13_16_3 146121.0125000029
R12227 n_13_15_3 n_13_15_4 466.6666666666704
R12228 n_13_15_4 n_14_15_4 151.51515151514604
R12229 n_13_15_4 n_13_16_4 4427.909469697059
R12230 n_13_15_15 n_14_15_15 9999.999999999549
R12231 n_13_15_15 n_13_16_15 292242.0250000033
R12232 n_13_16_0 n_14_16_0 2.4867033794435196
R12233 n_13_16_0 n_13_17_0 8206.915000000174
R12234 n_13_16_0 n_13_16_1 287.2142403257387
R12235 n_13_16_1 n_14_16_1 3.4813847312209263
R12236 n_13_16_1 n_13_17_1 11489.681000000244
R12237 n_13_16_1 n_13_16_2 652.7596371039516
R12238 n_13_16_2 n_14_16_2 6.216758448608798
R12239 n_13_16_2 n_13_17_2 20517.287500000435
R12240 n_13_16_2 n_13_16_3 610.9830203292987
R12241 n_13_16_3 n_14_16_3 87.03461828052308
R12242 n_13_16_3 n_13_17_3 287242.0250000058
R12243 n_13_16_3 n_13_16_4 8.123231039515849
R12244 n_13_16_4 n_14_16_4 2.637412675167366
R12245 n_13_16_4 n_13_17_4 8704.303787878966
R12246 n_13_16_15 n_14_16_15 174.06923656104462
R12247 n_13_16_15 n_13_17_15 574484.0500000067
R12248 n_13_17_0 n_14_17_0 2.4867033794435156
R12249 n_13_17_0 n_13_18_0 8206.91500000018
R12250 n_13_17_0 n_13_17_1 287.21424032573833
R12251 n_13_17_1 n_14_17_1 3.4813847312209223
R12252 n_13_17_1 n_13_18_1 11489.681000000252
R12253 n_13_17_1 n_13_17_2 652.7596371039508
R12254 n_13_17_2 n_14_17_2 6.21675844860879
R12255 n_13_17_2 n_13_18_2 20517.287500000446
R12256 n_13_17_2 n_13_17_3 610.983020329298
R12257 n_13_17_3 n_14_17_3 87.03461828052299
R12258 n_13_17_3 n_13_18_3 287242.02500000596
R12259 n_13_17_3 n_13_17_4 8.12323103951584
R12260 n_13_17_4 n_14_17_4 2.637412675167363
R12261 n_13_17_4 n_13_18_4 8704.30378787897
R12262 n_13_17_15 n_14_17_15 174.06923656104442
R12263 n_13_17_15 n_13_18_15 574484.050000007
R12264 n_13_18_0 n_14_18_0 2.4867033794435156
R12265 n_13_18_0 n_13_19_0 8206.915000000174
R12266 n_13_18_0 n_13_18_1 287.21424032573833
R12267 n_13_18_1 n_14_18_1 3.4813847312209223
R12268 n_13_18_1 n_13_19_1 11489.681000000244
R12269 n_13_18_1 n_13_18_2 652.7596371039508
R12270 n_13_18_2 n_14_18_2 6.21675844860879
R12271 n_13_18_2 n_13_19_2 20517.287500000435
R12272 n_13_18_2 n_13_18_3 610.983020329298
R12273 n_13_18_3 n_14_18_3 87.03461828052299
R12274 n_13_18_3 n_13_19_3 287242.0250000058
R12275 n_13_18_3 n_13_18_4 8.12323103951584
R12276 n_13_18_4 n_14_18_4 2.637412675167363
R12277 n_13_18_4 n_13_19_4 8704.303787878966
R12278 n_13_18_15 n_14_18_15 174.06923656104442
R12279 n_13_18_15 n_13_19_15 574484.0500000067
R12280 n_13_19_0 n_14_19_0 2.4867033794435196
R12281 n_13_19_0 n_13_20_0 4174.886084484277
R12282 n_13_19_0 n_13_19_1 287.2142403257387
R12283 n_13_19_1 n_14_19_1 3.4813847312209263
R12284 n_13_19_1 n_13_20_1 5844.840518277988
R12285 n_13_19_1 n_13_19_2 652.7596371039516
R12286 n_13_19_2 n_14_19_2 6.216758448608798
R12287 n_13_19_2 n_13_20_2 10437.215211210692
R12288 n_13_19_2 n_13_19_3 610.9830203292987
R12289 n_13_19_3 n_14_19_3 87.03461828052308
R12290 n_13_19_3 n_13_20_3 146121.01295694956
R12291 n_13_19_3 n_13_19_4 8.123231039515849
R12292 n_13_19_4 n_14_19_4 2.637412675167366
R12293 n_13_19_4 n_13_20_4 4427.909483543926
R12294 n_13_19_15 n_14_19_15 174.06923656104462
R12295 n_13_19_15 n_13_20_15 292242.0259138966
R12296 n_13_20_0 n_14_20_0 142.85711674590496
R12297 n_13_20_0 n_13_21_0 142.85716896838557
R12298 n_13_20_0 n_13_20_1 16499.996984152724
R12299 n_13_20_1 n_14_20_1 199.9999634442669
R12300 n_13_20_1 n_13_21_1 200.0000365557398
R12301 n_13_20_1 n_13_20_2 37499.993145801636
R12302 n_13_20_2 n_14_20_2 357.14279186476244
R12303 n_13_20_2 n_13_21_2 357.1429224209638
R12304 n_13_20_2 n_13_20_3 35099.993584470336
R12305 n_13_20_3 n_14_20_3 4999.999086106669
R12306 n_13_20_3 n_13_21_3 5000.000913893489
R12307 n_13_20_3 n_13_20_4 466.6665813699765
R12308 n_13_20_4 n_14_20_4 151.51512382141422
R12309 n_13_20_4 n_13_21_4 151.51517920889364
R12310 n_13_20_15 n_14_20_15 9999.998172213249
R12311 n_13_20_15 n_13_21_15 10000.001827786893
R12312 n_13_21_0 n_14_21_0 142.85711674590496
R12313 n_13_21_0 n_13_22_0 142.8571689683805
R12314 n_13_21_0 n_13_21_1 16499.996984152724
R12315 n_13_21_1 n_14_21_1 199.9999634442669
R12316 n_13_21_1 n_13_22_1 200.0000365557327
R12317 n_13_21_1 n_13_21_2 37499.993145801636
R12318 n_13_21_2 n_14_21_2 357.14279186476244
R12319 n_13_21_2 n_13_22_2 357.14292242095115
R12320 n_13_21_2 n_13_21_3 35099.993584470336
R12321 n_13_21_3 n_14_21_3 4999.999086106669
R12322 n_13_21_3 n_13_22_3 5000.000913893311
R12323 n_13_21_3 n_13_21_4 466.6665813699765
R12324 n_13_21_4 n_14_21_4 151.51512382141422
R12325 n_13_21_4 n_13_22_4 151.51517920888824
R12326 n_13_21_15 n_14_21_15 9999.998172213249
R12327 n_13_21_15 n_13_22_15 10000.001827786538
R12328 n_13_22_0 n_14_22_0 142.8571167459151
R12329 n_13_22_0 n_13_23_0 142.8571689683805
R12330 n_13_22_0 n_13_22_1 16499.9969841539
R12331 n_13_22_1 n_14_22_1 199.99996344428115
R12332 n_13_22_1 n_13_23_1 200.0000365557327
R12333 n_13_22_1 n_13_22_2 37499.993145804314
R12334 n_13_22_2 n_14_22_2 357.1427918647878
R12335 n_13_22_2 n_13_23_2 357.14292242095115
R12336 n_13_22_2 n_13_22_3 35099.99358447284
R12337 n_13_22_3 n_14_22_3 4999.999086107025
R12338 n_13_22_3 n_13_23_3 5000.000913893311
R12339 n_13_22_3 n_13_22_4 466.6665813700096
R12340 n_13_22_4 n_14_22_4 151.51512382142496
R12341 n_13_22_4 n_13_23_4 151.51517920888824
R12342 n_13_22_15 n_14_22_15 9999.99817221396
R12343 n_13_22_15 n_13_23_15 10000.001827786538
R12344 n_13_23_0 n_14_23_0 142.85711674590496
R12345 n_13_23_0 n_13_24_0 1646.6785714286095
R12346 n_13_23_0 n_13_23_1 16499.996984152724
R12347 n_13_23_1 n_14_23_1 199.9999634442669
R12348 n_13_23_1 n_13_24_1 2305.3500000000536
R12349 n_13_23_1 n_13_23_2 37499.993145801636
R12350 n_13_23_2 n_14_23_2 357.14279186476244
R12351 n_13_23_2 n_13_24_2 4116.696428571524
R12352 n_13_23_2 n_13_23_3 35099.993584470336
R12353 n_13_23_3 n_14_23_3 4999.999086106669
R12354 n_13_23_3 n_13_24_3 57633.75000000127
R12355 n_13_23_3 n_13_23_4 466.6665813699765
R12356 n_13_23_4 n_14_23_4 151.51512382141422
R12357 n_13_23_4 n_13_24_4 1746.4772727273116
R12358 n_13_23_15 n_14_23_15 9999.998172213249
R12359 n_13_23_15 n_13_24_15 115267.50000000156
R12360 n_13_24_0 n_14_24_0 6.477753827788552
R12361 n_13_24_0 n_13_25_0 3150.4999738888287
R12362 n_13_24_0 n_13_24_1 748.1805671096096
R12363 n_13_24_1 n_14_24_1 9.068855358903972
R12364 n_13_24_1 n_13_25_1 4410.69996344436
R12365 n_13_24_1 n_13_24_2 1700.4103797945672
R12366 n_13_24_2 n_14_24_2 16.19438456947138
R12367 n_13_24_2 n_13_25_2 7876.249934722071
R12368 n_13_24_2 n_13_24_3 1591.5841154877148
R12369 n_13_24_3 n_14_24_3 226.72138397259914
R12370 n_13_24_3 n_13_25_3 110267.49908610889
R12371 n_13_24_3 n_13_24_4 21.16066250411019
R12372 n_13_24_4 n_14_24_4 6.87034496886664
R12373 n_13_24_4 n_13_25_4 3341.439366245724
R12374 n_13_24_4 n_13_24_5 17.489935335029852
R12375 n_13_24_5 n_14_24_5 43.185025518590315
R12376 n_13_24_5 n_13_25_5 21003.333159258837
R12377 n_13_24_5 n_13_24_6 6.045903572602913
R12378 n_13_24_6 n_14_24_6 7.197504253098385
R12379 n_13_24_6 n_13_25_6 3500.55552654314
R12380 n_13_24_6 n_13_24_7 8.205154848532514
R12381 n_13_24_7 n_14_24_7 12.338578719597269
R12382 n_13_24_7 n_13_25_7 6000.952331216831
R12383 n_13_24_7 n_13_24_8 6.045903572602893
R12384 n_13_24_8 n_14_24_8 12.338578719597269
R12385 n_13_24_8 n_13_25_8 6000.952331216831
R12386 n_13_24_8 n_13_24_9 6.045903572602893
R12387 n_13_24_9 n_14_24_9 12.338578719597269
R12388 n_13_24_9 n_13_25_9 6000.952331216831
R12389 n_13_24_9 n_13_24_10 6.045903572602893
R12390 n_13_24_10 n_14_24_10 12.338578719597269
R12391 n_13_24_10 n_13_25_10 6000.952331216831
R12392 n_13_24_10 n_13_24_11 6.045903572602855
R12393 n_13_24_11 n_14_24_11 12.338578719597427
R12394 n_13_24_11 n_13_25_11 6000.952331216906
R12395 n_13_24_11 n_13_24_12 6.045903572602835
R12396 n_13_24_12 n_14_24_12 12.338578719597349
R12397 n_13_24_12 n_13_25_12 6000.9523312168685
R12398 n_13_24_12 n_13_24_13 6.045903572602892
R12399 n_13_24_13 n_14_24_13 12.338578719597193
R12400 n_13_24_13 n_13_25_13 6000.952331216793
R12401 n_13_24_13 n_13_24_14 30.22951786301454
R12402 n_13_24_14 n_14_24_14 1.3709531910663604
R12403 n_13_24_14 n_13_25_14 666.7724812463132
R12404 n_13_24_14 n_13_24_15 934.0921019671579
R12405 n_13_24_15 n_14_24_15 453.4427679451942
R12406 n_13_24_15 n_13_25_15 220534.99817221588
R12407 n_13_25_0 n_14_25_0 6.477753827788574
R12408 n_13_25_0 n_13_26_0 3150.4999738888287
R12409 n_13_25_0 n_13_25_1 748.180567109612
R12410 n_13_25_1 n_14_25_1 9.068855358904003
R12411 n_13_25_1 n_13_26_1 4410.69996344436
R12412 n_13_25_1 n_13_25_2 1700.4103797945727
R12413 n_13_25_2 n_14_25_2 16.194384569471435
R12414 n_13_25_2 n_13_26_2 7876.249934722071
R12415 n_13_25_2 n_13_25_3 1591.58411548772
R12416 n_13_25_3 n_14_25_3 226.72138397259988
R12417 n_13_25_3 n_13_26_3 110267.49908610889
R12418 n_13_25_3 n_13_25_4 21.160662504110256
R12419 n_13_25_4 n_14_25_4 6.870344968866664
R12420 n_13_25_4 n_13_26_4 3341.439366245724
R12421 n_13_25_4 n_13_25_5 17.489935335029905
R12422 n_13_25_5 n_14_25_5 43.18502551859045
R12423 n_13_25_5 n_13_26_5 21003.333159258837
R12424 n_13_25_5 n_13_25_6 6.045903572602931
R12425 n_13_25_6 n_14_25_6 7.197504253098408
R12426 n_13_25_6 n_13_26_6 3500.55552654314
R12427 n_13_25_6 n_13_25_7 8.20515484853254
R12428 n_13_25_7 n_14_25_7 12.338578719597312
R12429 n_13_25_7 n_13_26_7 6000.952331216831
R12430 n_13_25_7 n_13_25_8 6.045903572602913
R12431 n_13_25_8 n_14_25_8 12.338578719597312
R12432 n_13_25_8 n_13_26_8 6000.952331216831
R12433 n_13_25_8 n_13_25_9 6.045903572602913
R12434 n_13_25_9 n_14_25_9 12.338578719597312
R12435 n_13_25_9 n_13_26_9 6000.952331216831
R12436 n_13_25_9 n_13_25_10 6.045903572602913
R12437 n_13_25_10 n_14_25_10 12.338578719597312
R12438 n_13_25_10 n_13_26_10 6000.952331216831
R12439 n_13_25_10 n_13_25_11 6.0459035726028745
R12440 n_13_25_11 n_14_25_11 12.338578719597468
R12441 n_13_25_11 n_13_26_11 6000.952331216906
R12442 n_13_25_11 n_13_25_12 6.045903572602855
R12443 n_13_25_12 n_14_25_12 12.338578719597386
R12444 n_13_25_12 n_13_26_12 6000.9523312168685
R12445 n_13_25_12 n_13_25_13 6.045903572602912
R12446 n_13_25_13 n_14_25_13 12.338578719597233
R12447 n_13_25_13 n_13_26_13 6000.952331216793
R12448 n_13_25_13 n_13_25_14 30.22951786301464
R12449 n_13_25_14 n_14_25_14 1.3709531910663646
R12450 n_13_25_14 n_13_26_14 666.7724812463132
R12451 n_13_25_14 n_13_25_15 934.0921019671609
R12452 n_13_25_15 n_14_25_15 453.44276794519567
R12453 n_13_25_15 n_13_26_15 220534.99817221588
R12454 n_13_26_0 n_14_26_0 6.477753827788552
R12455 n_13_26_0 n_13_27_0 3150.4999738888337
R12456 n_13_26_0 n_13_26_1 748.1805671096096
R12457 n_13_26_1 n_14_26_1 9.068855358903972
R12458 n_13_26_1 n_13_27_1 4410.699963444367
R12459 n_13_26_1 n_13_26_2 1700.4103797945672
R12460 n_13_26_2 n_14_26_2 16.19438456947138
R12461 n_13_26_2 n_13_27_2 7876.249934722084
R12462 n_13_26_2 n_13_26_3 1591.5841154877148
R12463 n_13_26_3 n_14_26_3 226.72138397259914
R12464 n_13_26_3 n_13_27_3 110267.49908610906
R12465 n_13_26_3 n_13_26_4 21.16066250411019
R12466 n_13_26_4 n_14_26_4 6.87034496886664
R12467 n_13_26_4 n_13_27_4 3341.4393662457296
R12468 n_13_26_4 n_13_26_5 17.489935335029852
R12469 n_13_26_5 n_14_26_5 43.185025518590315
R12470 n_13_26_5 n_13_27_5 21003.33315925887
R12471 n_13_26_5 n_13_26_6 6.045903572602913
R12472 n_13_26_6 n_14_26_6 7.197504253098385
R12473 n_13_26_6 n_13_27_6 3500.5555265431453
R12474 n_13_26_6 n_13_26_7 8.205154848532514
R12475 n_13_26_7 n_14_26_7 12.338578719597269
R12476 n_13_26_7 n_13_27_7 6000.95233121684
R12477 n_13_26_7 n_13_26_8 6.045903572602893
R12478 n_13_26_8 n_14_26_8 12.338578719597269
R12479 n_13_26_8 n_13_27_8 6000.95233121684
R12480 n_13_26_8 n_13_26_9 6.045903572602893
R12481 n_13_26_9 n_14_26_9 12.338578719597269
R12482 n_13_26_9 n_13_27_9 6000.95233121684
R12483 n_13_26_9 n_13_26_10 6.045903572602893
R12484 n_13_26_10 n_14_26_10 12.338578719597269
R12485 n_13_26_10 n_13_27_10 6000.95233121684
R12486 n_13_26_10 n_13_26_11 6.045903572602855
R12487 n_13_26_11 n_14_26_11 12.338578719597427
R12488 n_13_26_11 n_13_27_11 6000.952331216916
R12489 n_13_26_11 n_13_26_12 6.045903572602835
R12490 n_13_26_12 n_14_26_12 12.338578719597349
R12491 n_13_26_12 n_13_27_12 6000.952331216878
R12492 n_13_26_12 n_13_26_13 6.045903572602892
R12493 n_13_26_13 n_14_26_13 12.338578719597193
R12494 n_13_26_13 n_13_27_13 6000.952331216802
R12495 n_13_26_13 n_13_26_14 30.22951786301454
R12496 n_13_26_14 n_14_26_14 1.3709531910663604
R12497 n_13_26_14 n_13_27_14 666.7724812463142
R12498 n_13_26_14 n_13_26_15 934.0921019671579
R12499 n_13_26_15 n_14_26_15 453.4427679451942
R12500 n_13_26_15 n_13_27_15 220534.99817221623
R12501 n_13_27_0 n_14_27_0 6.477753827788552
R12502 n_13_27_0 n_13_27_1 748.1805671096096
R12503 n_13_27_1 n_14_27_1 9.068855358903972
R12504 n_13_27_1 n_13_27_2 1700.4103797945672
R12505 n_13_27_2 n_14_27_2 16.19438456947138
R12506 n_13_27_2 n_13_27_3 1591.5841154877148
R12507 n_13_27_3 n_14_27_3 226.72138397259914
R12508 n_13_27_3 n_13_27_4 21.16066250411019
R12509 n_13_27_4 n_14_27_4 6.87034496886664
R12510 n_13_27_4 n_13_27_5 17.489935335029852
R12511 n_13_27_5 n_14_27_5 43.185025518590315
R12512 n_13_27_5 n_13_27_6 6.045903572602913
R12513 n_13_27_6 n_14_27_6 7.197504253098385
R12514 n_13_27_6 n_13_27_7 8.205154848532514
R12515 n_13_27_7 n_14_27_7 12.338578719597269
R12516 n_13_27_7 n_13_27_8 6.045903572602893
R12517 n_13_27_8 n_14_27_8 12.338578719597269
R12518 n_13_27_8 n_13_27_9 6.045903572602893
R12519 n_13_27_9 n_14_27_9 12.338578719597269
R12520 n_13_27_9 n_13_27_10 6.045903572602893
R12521 n_13_27_10 n_14_27_10 12.338578719597269
R12522 n_13_27_10 n_13_27_11 6.045903572602855
R12523 n_13_27_11 n_14_27_11 12.338578719597427
R12524 n_13_27_11 n_13_27_12 6.045903572602835
R12525 n_13_27_12 n_14_27_12 12.338578719597349
R12526 n_13_27_12 n_13_27_13 6.045903572602892
R12527 n_13_27_13 n_14_27_13 12.338578719597193
R12528 n_13_27_13 n_13_27_14 30.22951786301454
R12529 n_13_27_14 n_14_27_14 1.3709531910663604
R12530 n_13_27_14 n_13_27_15 934.0921019671579
R12531 n_13_27_15 n_14_27_15 453.4427679451942
R12532 n_14_0_0 n_15_0_0 6.477753269925552
R12533 n_14_0_0 n_14_1_0 3150.5002452094077
R12534 n_14_0_0 n_14_0_1 748.1805026764197
R12535 n_14_0_1 n_15_0_1 9.06885457789577
R12536 n_14_0_1 n_14_1_1 4410.700343293171
R12537 n_14_0_1 n_14_0_2 1700.4102333554993
R12538 n_14_0_2 n_15_0_2 16.19438317481388
R12539 n_14_0_2 n_14_1_2 7876.250613023518
R12540 n_14_0_2 n_14_0_3 1591.5839784207474
R12541 n_14_0_3 n_15_0_3 226.72136444739408
R12542 n_14_0_3 n_14_1_3 110267.50858232914
R12543 n_14_0_3 n_14_0_4 21.160660681757346
R12544 n_14_0_4 n_15_0_4 6.87034437719376
R12545 n_14_0_4 n_14_1_4 3341.4396540099747
R12546 n_14_0_4 n_14_0_5 17.48993382879944
R12547 n_14_0_5 n_15_0_5 43.18502179950363
R12548 n_14_0_5 n_14_1_5 21003.334968062696
R12549 n_14_0_5 n_14_0_6 6.0459030519306705
R12550 n_14_0_6 n_15_0_6 7.197503633250607
R12551 n_14_0_6 n_14_1_6 3500.5558280104497
R12552 n_14_0_6 n_14_0_7 8.2051541419059
R12553 n_14_0_7 n_15_0_7 12.338577657001077
R12554 n_14_0_7 n_14_1_7 6000.952848017933
R12555 n_14_0_7 n_14_0_8 6.045903051930652
R12556 n_14_0_8 n_15_0_8 12.338577657001077
R12557 n_14_0_8 n_14_1_8 6000.952848017933
R12558 n_14_0_8 n_14_0_9 6.045903051930652
R12559 n_14_0_9 n_15_0_9 12.338577657001077
R12560 n_14_0_9 n_14_1_9 6000.952848017933
R12561 n_14_0_9 n_14_0_10 6.045903051930652
R12562 n_14_0_10 n_15_0_10 12.338577657001077
R12563 n_14_0_10 n_14_1_10 6000.952848017933
R12564 n_14_0_10 n_14_0_11 6.045903051930614
R12565 n_14_0_11 n_15_0_11 12.338577657001235
R12566 n_14_0_11 n_14_1_11 6000.952848018009
R12567 n_14_0_11 n_14_0_12 6.045903051930594
R12568 n_14_0_12 n_15_0_12 12.33857765700116
R12569 n_14_0_12 n_14_1_12 6000.9528480179715
R12570 n_14_0_12 n_14_0_13 6.045903051930651
R12571 n_14_0_13 n_15_0_13 12.338577657001
R12572 n_14_0_13 n_14_1_13 6000.952848017895
R12573 n_14_0_13 n_14_0_14 30.229515259653333
R12574 n_14_0_14 n_15_0_14 1.3709530730001167
R12575 n_14_0_14 n_14_1_14 666.7725386686578
R12576 n_14_0_14 n_14_0_15 934.0920215232965
R12577 n_14_0_15 n_15_0_15 453.4427288947842
R12578 n_14_0_15 n_14_1_15 220535.0171646564
R12579 n_14_1_0 n_15_1_0 6.477753269925552
R12580 n_14_1_0 n_14_2_0 3150.5002452094077
R12581 n_14_1_0 n_14_1_1 748.1805026764197
R12582 n_14_1_1 n_15_1_1 9.06885457789577
R12583 n_14_1_1 n_14_2_1 4410.700343293171
R12584 n_14_1_1 n_14_1_2 1700.4102333554993
R12585 n_14_1_2 n_15_1_2 16.19438317481388
R12586 n_14_1_2 n_14_2_2 7876.250613023518
R12587 n_14_1_2 n_14_1_3 1591.5839784207474
R12588 n_14_1_3 n_15_1_3 226.72136444739408
R12589 n_14_1_3 n_14_2_3 110267.50858232914
R12590 n_14_1_3 n_14_1_4 21.160660681757346
R12591 n_14_1_4 n_15_1_4 6.87034437719376
R12592 n_14_1_4 n_14_2_4 3341.4396540099747
R12593 n_14_1_4 n_14_1_5 17.48993382879944
R12594 n_14_1_5 n_15_1_5 43.18502179950363
R12595 n_14_1_5 n_14_2_5 21003.334968062696
R12596 n_14_1_5 n_14_1_6 6.0459030519306705
R12597 n_14_1_6 n_15_1_6 7.197503633250607
R12598 n_14_1_6 n_14_2_6 3500.5558280104497
R12599 n_14_1_6 n_14_1_7 8.2051541419059
R12600 n_14_1_7 n_15_1_7 12.338577657001077
R12601 n_14_1_7 n_14_2_7 6000.952848017933
R12602 n_14_1_7 n_14_1_8 6.045903051930652
R12603 n_14_1_8 n_15_1_8 12.338577657001077
R12604 n_14_1_8 n_14_2_8 6000.952848017933
R12605 n_14_1_8 n_14_1_9 6.045903051930652
R12606 n_14_1_9 n_15_1_9 12.338577657001077
R12607 n_14_1_9 n_14_2_9 6000.952848017933
R12608 n_14_1_9 n_14_1_10 6.045903051930652
R12609 n_14_1_10 n_15_1_10 12.338577657001077
R12610 n_14_1_10 n_14_2_10 6000.952848017933
R12611 n_14_1_10 n_14_1_11 6.045903051930614
R12612 n_14_1_11 n_15_1_11 12.338577657001235
R12613 n_14_1_11 n_14_2_11 6000.952848018009
R12614 n_14_1_11 n_14_1_12 6.045903051930594
R12615 n_14_1_12 n_15_1_12 12.33857765700116
R12616 n_14_1_12 n_14_2_12 6000.9528480179715
R12617 n_14_1_12 n_14_1_13 6.045903051930651
R12618 n_14_1_13 n_15_1_13 12.338577657001
R12619 n_14_1_13 n_14_2_13 6000.952848017895
R12620 n_14_1_13 n_14_1_14 30.229515259653333
R12621 n_14_1_14 n_15_1_14 1.3709530730001167
R12622 n_14_1_14 n_14_2_14 666.7725386686578
R12623 n_14_1_14 n_14_1_15 934.0920215232965
R12624 n_14_1_15 n_15_1_15 453.4427288947842
R12625 n_14_1_15 n_14_2_15 220535.0171646564
R12626 n_14_2_0 n_15_2_0 6.477753269925552
R12627 n_14_2_0 n_14_3_0 3150.5002452094077
R12628 n_14_2_0 n_14_2_1 748.1805026764197
R12629 n_14_2_1 n_15_2_1 9.06885457789577
R12630 n_14_2_1 n_14_3_1 4410.700343293171
R12631 n_14_2_1 n_14_2_2 1700.4102333554993
R12632 n_14_2_2 n_15_2_2 16.19438317481388
R12633 n_14_2_2 n_14_3_2 7876.250613023518
R12634 n_14_2_2 n_14_2_3 1591.5839784207474
R12635 n_14_2_3 n_15_2_3 226.72136444739408
R12636 n_14_2_3 n_14_3_3 110267.50858232914
R12637 n_14_2_3 n_14_2_4 21.160660681757346
R12638 n_14_2_4 n_15_2_4 6.87034437719376
R12639 n_14_2_4 n_14_3_4 3341.4396540099747
R12640 n_14_2_4 n_14_2_5 17.48993382879944
R12641 n_14_2_5 n_15_2_5 43.18502179950363
R12642 n_14_2_5 n_14_3_5 21003.334968062696
R12643 n_14_2_5 n_14_2_6 6.0459030519306705
R12644 n_14_2_6 n_15_2_6 7.197503633250607
R12645 n_14_2_6 n_14_3_6 3500.5558280104497
R12646 n_14_2_6 n_14_2_7 8.2051541419059
R12647 n_14_2_7 n_15_2_7 12.338577657001077
R12648 n_14_2_7 n_14_3_7 6000.952848017933
R12649 n_14_2_7 n_14_2_8 6.045903051930652
R12650 n_14_2_8 n_15_2_8 12.338577657001077
R12651 n_14_2_8 n_14_3_8 6000.952848017933
R12652 n_14_2_8 n_14_2_9 6.045903051930652
R12653 n_14_2_9 n_15_2_9 12.338577657001077
R12654 n_14_2_9 n_14_3_9 6000.952848017933
R12655 n_14_2_9 n_14_2_10 6.045903051930652
R12656 n_14_2_10 n_15_2_10 12.338577657001077
R12657 n_14_2_10 n_14_3_10 6000.952848017933
R12658 n_14_2_10 n_14_2_11 6.045903051930614
R12659 n_14_2_11 n_15_2_11 12.338577657001235
R12660 n_14_2_11 n_14_3_11 6000.952848018009
R12661 n_14_2_11 n_14_2_12 6.045903051930594
R12662 n_14_2_12 n_15_2_12 12.33857765700116
R12663 n_14_2_12 n_14_3_12 6000.9528480179715
R12664 n_14_2_12 n_14_2_13 6.045903051930651
R12665 n_14_2_13 n_15_2_13 12.338577657001
R12666 n_14_2_13 n_14_3_13 6000.952848017895
R12667 n_14_2_13 n_14_2_14 30.229515259653333
R12668 n_14_2_14 n_15_2_14 1.3709530730001167
R12669 n_14_2_14 n_14_3_14 666.7725386686578
R12670 n_14_2_14 n_14_2_15 934.0920215232965
R12671 n_14_2_15 n_15_2_15 453.4427288947842
R12672 n_14_2_15 n_14_3_15 220535.0171646564
R12673 n_14_3_0 n_15_3_0 6.477753269925552
R12674 n_14_3_0 n_14_4_0 1646.6785714286061
R12675 n_14_3_0 n_14_3_1 748.1805026764197
R12676 n_14_3_1 n_15_3_1 9.06885457789577
R12677 n_14_3_1 n_14_4_1 2305.350000000048
R12678 n_14_3_1 n_14_3_2 1700.4102333554993
R12679 n_14_3_2 n_15_3_2 16.19438317481388
R12680 n_14_3_2 n_14_4_2 4116.696428571514
R12681 n_14_3_2 n_14_3_3 1591.5839784207474
R12682 n_14_3_3 n_15_3_3 226.72136444739408
R12683 n_14_3_3 n_14_4_3 57633.75000000114
R12684 n_14_3_3 n_14_3_4 21.160660681757346
R12685 n_14_3_4 n_15_3_4 6.87034437719376
R12686 n_14_3_4 n_14_4_4 1746.4772727273078
R12687 n_14_3_4 n_14_3_5 17.48993382879944
R12688 n_14_3_5 n_15_3_5 43.18502179950363
R12689 n_14_3_5 n_14_3_6 6.0459030519306705
R12690 n_14_3_6 n_15_3_6 7.197503633250607
R12691 n_14_3_6 n_14_3_7 8.2051541419059
R12692 n_14_3_7 n_15_3_7 12.338577657001077
R12693 n_14_3_7 n_14_3_8 6.045903051930652
R12694 n_14_3_8 n_15_3_8 12.338577657001077
R12695 n_14_3_8 n_14_3_9 6.045903051930652
R12696 n_14_3_9 n_15_3_9 12.338577657001077
R12697 n_14_3_9 n_14_3_10 6.045903051930652
R12698 n_14_3_10 n_15_3_10 12.338577657001077
R12699 n_14_3_10 n_14_3_11 6.045903051930614
R12700 n_14_3_11 n_15_3_11 12.338577657001235
R12701 n_14_3_11 n_14_3_12 6.045903051930594
R12702 n_14_3_12 n_15_3_12 12.33857765700116
R12703 n_14_3_12 n_14_3_13 6.045903051930651
R12704 n_14_3_13 n_15_3_13 12.338577657001
R12705 n_14_3_13 n_14_3_14 30.229515259653333
R12706 n_14_3_14 n_15_3_14 1.3709530730001167
R12707 n_14_3_14 n_14_3_15 934.0920215232965
R12708 n_14_3_15 n_15_3_15 453.4427288947842
R12709 n_14_3_15 n_14_4_15 115267.5000000013
R12710 n_14_4_0 n_15_4_0 142.85738806690486
R12711 n_14_4_0 n_14_5_0 142.85689764780557
R12712 n_14_4_0 n_14_4_1 16500.02832172792
R12713 n_14_4_1 n_15_4_1 200.0003432936668
R12714 n_14_4_1 n_14_5_1 199.99965670692785
R12715 n_14_4_1 n_14_4_2 37500.06436756346
R12716 n_14_4_2 n_15_4_2 357.1434701672622
R12717 n_14_4_2 n_14_5_2 357.142244119514
R12718 n_14_4_2 n_14_4_3 35100.0602480394
R12719 n_14_4_3 n_15_4_3 5000.008582341667
R12720 n_14_4_3 n_14_5_3 4999.991417673191
R12721 n_14_4_3 n_14_4_4 466.66746768523456
R12722 n_14_4_4 n_15_4_4 151.5154115861111
R12723 n_14_4_4 n_14_5_4 151.51489144464216
R12724 n_14_4_15 n_15_4_15 10000.017164683242
R12725 n_14_4_15 n_14_5_15 9999.982835346294
R12726 n_14_5_0 n_15_5_0 142.85738806690233
R12727 n_14_5_0 n_14_6_0 142.85689764780685
R12728 n_14_5_0 n_14_5_1 16500.028321727626
R12729 n_14_5_1 n_15_5_1 200.00034329366324
R12730 n_14_5_1 n_14_6_1 199.9996567069296
R12731 n_14_5_1 n_14_5_2 37500.06436756279
R12732 n_14_5_2 n_15_5_2 357.1434701672558
R12733 n_14_5_2 n_14_6_2 357.1422441195171
R12734 n_14_5_2 n_14_5_3 35100.06024803877
R12735 n_14_5_3 n_15_5_3 5000.0085823415775
R12736 n_14_5_3 n_14_6_3 4999.9914176732345
R12737 n_14_5_3 n_14_5_4 466.66746768522626
R12738 n_14_5_4 n_15_5_4 151.51541158610837
R12739 n_14_5_4 n_14_6_4 151.5148914446435
R12740 n_14_5_15 n_15_5_15 10000.017164683064
R12741 n_14_5_15 n_14_6_15 9999.982835346384
R12742 n_14_6_0 n_15_6_0 142.85738806690233
R12743 n_14_6_0 n_14_7_0 142.85689764780557
R12744 n_14_6_0 n_14_6_1 16500.028321727626
R12745 n_14_6_1 n_15_6_1 200.00034329366324
R12746 n_14_6_1 n_14_7_1 199.99965670692785
R12747 n_14_6_1 n_14_6_2 37500.06436756279
R12748 n_14_6_2 n_15_6_2 357.1434701672558
R12749 n_14_6_2 n_14_7_2 357.142244119514
R12750 n_14_6_2 n_14_6_3 35100.06024803877
R12751 n_14_6_3 n_15_6_3 5000.0085823415775
R12752 n_14_6_3 n_14_7_3 4999.991417673191
R12753 n_14_6_3 n_14_6_4 466.66746768522626
R12754 n_14_6_4 n_15_6_4 151.51541158610837
R12755 n_14_6_4 n_14_7_4 151.51489144464216
R12756 n_14_6_15 n_15_6_15 10000.017164683064
R12757 n_14_6_15 n_14_7_15 9999.982835346294
R12758 n_14_7_0 n_15_7_0 142.85738806690486
R12759 n_14_7_0 n_14_8_0 4174.885948823989
R12760 n_14_7_0 n_14_7_1 16500.02832172792
R12761 n_14_7_1 n_15_7_1 200.0003432936668
R12762 n_14_7_1 n_14_8_1 5844.840328353585
R12763 n_14_7_1 n_14_7_2 37500.06436756346
R12764 n_14_7_2 n_15_7_2 357.1434701672622
R12765 n_14_7_2 n_14_8_2 10437.214872059973
R12766 n_14_7_2 n_14_7_3 35100.0602480394
R12767 n_14_7_3 n_15_7_3 5000.008582341667
R12768 n_14_7_3 n_14_8_3 146121.00820883946
R12769 n_14_7_3 n_14_7_4 466.66746768523456
R12770 n_14_7_4 n_15_7_4 151.5154115861111
R12771 n_14_7_4 n_14_8_4 4427.909339661803
R12772 n_14_7_15 n_15_7_15 10000.017164683242
R12773 n_14_7_15 n_14_8_15 292242.01641767647
R12774 n_14_8_0 n_15_8_0 2.4867033794435622
R12775 n_14_8_0 n_14_9_0 8206.915000000175
R12776 n_14_8_0 n_14_8_1 287.2142403257385
R12777 n_14_8_1 n_15_8_1 3.4813847312209862
R12778 n_14_8_1 n_14_9_1 11489.681000000248
R12779 n_14_8_1 n_14_8_2 652.7596371039511
R12780 n_14_8_2 n_15_8_2 6.216758448608904
R12781 n_14_8_2 n_14_9_2 20517.287500000442
R12782 n_14_8_2 n_14_8_3 610.9830203292984
R12783 n_14_8_3 n_15_8_3 87.03461828052458
R12784 n_14_8_3 n_14_9_3 287242.02500000584
R12785 n_14_8_3 n_14_8_4 8.123231039515844
R12786 n_14_8_4 n_15_8_4 2.637412675167412
R12787 n_14_8_4 n_14_9_4 8704.303787878967
R12788 n_14_8_15 n_15_8_15 174.0692365610476
R12789 n_14_8_15 n_14_9_15 574484.0500000068
R12790 n_14_9_0 n_15_9_0 2.4867033794435596
R12791 n_14_9_0 n_14_10_0 8206.915000000175
R12792 n_14_9_0 n_14_9_1 287.21424032573833
R12793 n_14_9_1 n_15_9_1 3.4813847312209845
R12794 n_14_9_1 n_14_10_1 11489.681000000248
R12795 n_14_9_1 n_14_9_2 652.7596371039508
R12796 n_14_9_2 n_15_9_2 6.2167584486089
R12797 n_14_9_2 n_14_10_2 20517.287500000442
R12798 n_14_9_2 n_14_9_3 610.983020329298
R12799 n_14_9_3 n_15_9_3 87.03461828052454
R12800 n_14_9_3 n_14_10_3 287242.02500000584
R12801 n_14_9_3 n_14_9_4 8.12323103951584
R12802 n_14_9_4 n_15_9_4 2.6374126751674103
R12803 n_14_9_4 n_14_10_4 8704.303787878967
R12804 n_14_9_15 n_15_9_15 174.06923656104752
R12805 n_14_9_15 n_14_10_15 574484.0500000068
R12806 n_14_10_0 n_15_10_0 2.4867033794435622
R12807 n_14_10_0 n_14_11_0 8206.915000000174
R12808 n_14_10_0 n_14_10_1 287.2142403257385
R12809 n_14_10_1 n_15_10_1 3.4813847312209862
R12810 n_14_10_1 n_14_11_1 11489.681000000244
R12811 n_14_10_1 n_14_10_2 652.7596371039511
R12812 n_14_10_2 n_15_10_2 6.216758448608904
R12813 n_14_10_2 n_14_11_2 20517.287500000435
R12814 n_14_10_2 n_14_10_3 610.9830203292984
R12815 n_14_10_3 n_15_10_3 87.03461828052458
R12816 n_14_10_3 n_14_11_3 287242.0250000058
R12817 n_14_10_3 n_14_10_4 8.123231039515844
R12818 n_14_10_4 n_15_10_4 2.637412675167412
R12819 n_14_10_4 n_14_11_4 8704.303787878966
R12820 n_14_10_15 n_15_10_15 174.0692365610476
R12821 n_14_10_15 n_14_11_15 574484.0500000067
R12822 n_14_11_0 n_15_11_0 2.4867033794435622
R12823 n_14_11_0 n_14_12_0 4174.886071428661
R12824 n_14_11_0 n_14_11_1 287.2142403257385
R12825 n_14_11_1 n_15_11_1 3.4813847312209862
R12826 n_14_11_1 n_14_12_1 5844.840500000126
R12827 n_14_11_1 n_14_11_2 652.7596371039511
R12828 n_14_11_2 n_15_11_2 6.216758448608904
R12829 n_14_11_2 n_14_12_2 10437.215178571652
R12830 n_14_11_2 n_14_11_3 610.9830203292984
R12831 n_14_11_3 n_15_11_3 87.03461828052458
R12832 n_14_11_3 n_14_12_3 146121.01250000298
R12833 n_14_11_3 n_14_11_4 8.123231039515844
R12834 n_14_11_4 n_15_11_4 2.637412675167412
R12835 n_14_11_4 n_14_12_4 4427.9094696970615
R12836 n_14_11_15 n_15_11_15 174.0692365610476
R12837 n_14_11_15 n_14_12_15 292242.02500000346
R12838 n_14_12_0 n_15_12_0 142.85714285714033
R12839 n_14_12_0 n_14_13_0 142.85714285714795
R12840 n_14_12_0 n_14_12_1 16500.000000000116
R12841 n_14_12_1 n_15_12_1 199.99999999999648
R12842 n_14_12_1 n_14_13_1 200.00000000000713
R12843 n_14_12_1 n_14_12_2 37500.00000000026
R12844 n_14_12_2 n_15_12_2 357.14285714285086
R12845 n_14_12_2 n_14_13_2 357.14285714286984
R12846 n_14_12_2 n_14_12_3 35100.00000000025
R12847 n_14_12_3 n_15_12_3 4999.999999999907
R12848 n_14_12_3 n_14_13_3 5000.000000000173
R12849 n_14_12_3 n_14_12_4 466.6666666666704
R12850 n_14_12_4 n_15_12_4 151.51515151514872
R12851 n_14_12_4 n_14_13_4 151.5151515151568
R12852 n_14_12_15 n_15_12_15 9999.999999999727
R12853 n_14_12_15 n_14_13_15 10000.00000000026
R12854 n_14_13_0 n_15_13_0 142.85714285714033
R12855 n_14_13_0 n_14_14_0 142.85714285714795
R12856 n_14_13_0 n_14_13_1 16500.000000000116
R12857 n_14_13_1 n_15_13_1 199.99999999999648
R12858 n_14_13_1 n_14_14_1 200.00000000000713
R12859 n_14_13_1 n_14_13_2 37500.00000000026
R12860 n_14_13_2 n_15_13_2 357.14285714285086
R12861 n_14_13_2 n_14_14_2 357.14285714286984
R12862 n_14_13_2 n_14_13_3 35100.00000000025
R12863 n_14_13_3 n_15_13_3 4999.999999999907
R12864 n_14_13_3 n_14_14_3 5000.000000000173
R12865 n_14_13_3 n_14_13_4 466.6666666666704
R12866 n_14_13_4 n_15_13_4 151.51515151514872
R12867 n_14_13_4 n_14_14_4 151.5151515151568
R12868 n_14_13_15 n_15_13_15 9999.999999999727
R12869 n_14_13_15 n_14_14_15 10000.00000000026
R12870 n_14_14_0 n_15_14_0 142.85714285714033
R12871 n_14_14_0 n_14_15_0 142.85714285714795
R12872 n_14_14_0 n_14_14_1 16500.000000000116
R12873 n_14_14_1 n_15_14_1 199.99999999999648
R12874 n_14_14_1 n_14_15_1 200.00000000000713
R12875 n_14_14_1 n_14_14_2 37500.00000000026
R12876 n_14_14_2 n_15_14_2 357.14285714285086
R12877 n_14_14_2 n_14_15_2 357.14285714286984
R12878 n_14_14_2 n_14_14_3 35100.00000000025
R12879 n_14_14_3 n_15_14_3 4999.999999999907
R12880 n_14_14_3 n_14_15_3 5000.000000000173
R12881 n_14_14_3 n_14_14_4 466.6666666666704
R12882 n_14_14_4 n_15_14_4 151.51515151514872
R12883 n_14_14_4 n_14_15_4 151.5151515151568
R12884 n_14_14_15 n_15_14_15 9999.999999999727
R12885 n_14_14_15 n_14_15_15 10000.00000000026
R12886 n_14_15_0 n_15_15_0 142.85714285714033
R12887 n_14_15_0 n_14_16_0 4174.886071428658
R12888 n_14_15_0 n_14_15_1 16500.000000000116
R12889 n_14_15_1 n_15_15_1 199.99999999999648
R12890 n_14_15_1 n_14_16_1 5844.840500000122
R12891 n_14_15_1 n_14_15_2 37500.00000000026
R12892 n_14_15_2 n_15_15_2 357.14285714285086
R12893 n_14_15_2 n_14_16_2 10437.215178571645
R12894 n_14_15_2 n_14_15_3 35100.00000000025
R12895 n_14_15_3 n_15_15_3 4999.999999999907
R12896 n_14_15_3 n_14_16_3 146121.0125000029
R12897 n_14_15_3 n_14_15_4 466.6666666666704
R12898 n_14_15_4 n_15_15_4 151.51515151514872
R12899 n_14_15_4 n_14_16_4 4427.909469697059
R12900 n_14_15_15 n_15_15_15 9999.999999999727
R12901 n_14_15_15 n_14_16_15 292242.0250000033
R12902 n_14_16_0 n_15_16_0 2.486703379443564
R12903 n_14_16_0 n_14_17_0 8206.915000000174
R12904 n_14_16_0 n_14_16_1 287.2142403257387
R12905 n_14_16_1 n_15_16_1 3.481384731220988
R12906 n_14_16_1 n_14_17_1 11489.681000000244
R12907 n_14_16_1 n_14_16_2 652.7596371039516
R12908 n_14_16_2 n_15_16_2 6.216758448608909
R12909 n_14_16_2 n_14_17_2 20517.287500000435
R12910 n_14_16_2 n_14_16_3 610.9830203292987
R12911 n_14_16_3 n_15_16_3 87.03461828052463
R12912 n_14_16_3 n_14_17_3 287242.0250000058
R12913 n_14_16_3 n_14_16_4 8.123231039515849
R12914 n_14_16_4 n_15_16_4 2.637412675167413
R12915 n_14_16_4 n_14_17_4 8704.303787878966
R12916 n_14_16_15 n_15_16_15 174.06923656104772
R12917 n_14_16_15 n_14_17_15 574484.0500000067
R12918 n_14_17_0 n_15_17_0 2.4867033794435596
R12919 n_14_17_0 n_14_18_0 8206.91500000018
R12920 n_14_17_0 n_14_17_1 287.21424032573833
R12921 n_14_17_1 n_15_17_1 3.4813847312209845
R12922 n_14_17_1 n_14_18_1 11489.681000000252
R12923 n_14_17_1 n_14_17_2 652.7596371039508
R12924 n_14_17_2 n_15_17_2 6.2167584486089
R12925 n_14_17_2 n_14_18_2 20517.287500000446
R12926 n_14_17_2 n_14_17_3 610.983020329298
R12927 n_14_17_3 n_15_17_3 87.03461828052454
R12928 n_14_17_3 n_14_18_3 287242.02500000596
R12929 n_14_17_3 n_14_17_4 8.12323103951584
R12930 n_14_17_4 n_15_17_4 2.6374126751674103
R12931 n_14_17_4 n_14_18_4 8704.30378787897
R12932 n_14_17_15 n_15_17_15 174.06923656104752
R12933 n_14_17_15 n_14_18_15 574484.050000007
R12934 n_14_18_0 n_15_18_0 2.4867033794435596
R12935 n_14_18_0 n_14_19_0 8206.915000000174
R12936 n_14_18_0 n_14_18_1 287.21424032573833
R12937 n_14_18_1 n_15_18_1 3.4813847312209845
R12938 n_14_18_1 n_14_19_1 11489.681000000244
R12939 n_14_18_1 n_14_18_2 652.7596371039508
R12940 n_14_18_2 n_15_18_2 6.2167584486089
R12941 n_14_18_2 n_14_19_2 20517.287500000435
R12942 n_14_18_2 n_14_18_3 610.983020329298
R12943 n_14_18_3 n_15_18_3 87.03461828052454
R12944 n_14_18_3 n_14_19_3 287242.0250000058
R12945 n_14_18_3 n_14_18_4 8.12323103951584
R12946 n_14_18_4 n_15_18_4 2.6374126751674103
R12947 n_14_18_4 n_14_19_4 8704.303787878966
R12948 n_14_18_15 n_15_18_15 174.06923656104752
R12949 n_14_18_15 n_14_19_15 574484.0500000067
R12950 n_14_19_0 n_15_19_0 2.486703379443564
R12951 n_14_19_0 n_14_20_0 4174.886084484277
R12952 n_14_19_0 n_14_19_1 287.2142403257387
R12953 n_14_19_1 n_15_19_1 3.481384731220988
R12954 n_14_19_1 n_14_20_1 5844.840518277988
R12955 n_14_19_1 n_14_19_2 652.7596371039516
R12956 n_14_19_2 n_15_19_2 6.216758448608909
R12957 n_14_19_2 n_14_20_2 10437.215211210692
R12958 n_14_19_2 n_14_19_3 610.9830203292987
R12959 n_14_19_3 n_15_19_3 87.03461828052463
R12960 n_14_19_3 n_14_20_3 146121.01295694956
R12961 n_14_19_3 n_14_19_4 8.123231039515849
R12962 n_14_19_4 n_15_19_4 2.637412675167413
R12963 n_14_19_4 n_14_20_4 4427.909483543926
R12964 n_14_19_15 n_15_19_15 174.06923656104772
R12965 n_14_19_15 n_14_20_15 292242.0259138966
R12966 n_14_20_0 n_15_20_0 142.8571167459075
R12967 n_14_20_0 n_14_21_0 142.85716896838557
R12968 n_14_20_0 n_14_20_1 16499.996984152724
R12969 n_14_20_1 n_15_20_1 199.99996344427046
R12970 n_14_20_1 n_14_21_1 200.0000365557398
R12971 n_14_20_1 n_14_20_2 37499.993145801636
R12972 n_14_20_2 n_15_20_2 357.1427918647688
R12973 n_14_20_2 n_14_21_2 357.1429224209638
R12974 n_14_20_2 n_14_20_3 35099.993584470336
R12975 n_14_20_3 n_15_20_3 4999.999086106758
R12976 n_14_20_3 n_14_21_3 5000.000913893489
R12977 n_14_20_3 n_14_20_4 466.6665813699765
R12978 n_14_20_4 n_15_20_4 151.51512382141692
R12979 n_14_20_4 n_14_21_4 151.51517920889364
R12980 n_14_20_15 n_15_20_15 9999.998172213425
R12981 n_14_20_15 n_14_21_15 10000.001827786893
R12982 n_14_21_0 n_15_21_0 142.8571167459075
R12983 n_14_21_0 n_14_22_0 142.8571689683805
R12984 n_14_21_0 n_14_21_1 16499.996984152724
R12985 n_14_21_1 n_15_21_1 199.99996344427046
R12986 n_14_21_1 n_14_22_1 200.0000365557327
R12987 n_14_21_1 n_14_21_2 37499.993145801636
R12988 n_14_21_2 n_15_21_2 357.1427918647688
R12989 n_14_21_2 n_14_22_2 357.14292242095115
R12990 n_14_21_2 n_14_21_3 35099.993584470336
R12991 n_14_21_3 n_15_21_3 4999.999086106758
R12992 n_14_21_3 n_14_22_3 5000.000913893311
R12993 n_14_21_3 n_14_21_4 466.6665813699765
R12994 n_14_21_4 n_15_21_4 151.51512382141692
R12995 n_14_21_4 n_14_22_4 151.51517920888824
R12996 n_14_21_15 n_15_21_15 9999.998172213425
R12997 n_14_21_15 n_14_22_15 10000.001827786538
R12998 n_14_22_0 n_15_22_0 142.85711674591764
R12999 n_14_22_0 n_14_23_0 142.8571689683805
R13000 n_14_22_0 n_14_22_1 16499.9969841539
R13001 n_14_22_1 n_15_22_1 199.9999634442847
R13002 n_14_22_1 n_14_23_1 200.0000365557327
R13003 n_14_22_1 n_14_22_2 37499.993145804314
R13004 n_14_22_2 n_15_22_2 357.14279186479416
R13005 n_14_22_2 n_14_23_2 357.14292242095115
R13006 n_14_22_2 n_14_22_3 35099.99358447284
R13007 n_14_22_3 n_15_22_3 4999.999086107113
R13008 n_14_22_3 n_14_23_3 5000.000913893311
R13009 n_14_22_3 n_14_22_4 466.6665813700096
R13010 n_14_22_4 n_15_22_4 151.51512382142766
R13011 n_14_22_4 n_14_23_4 151.51517920888824
R13012 n_14_22_15 n_15_22_15 9999.998172214138
R13013 n_14_22_15 n_14_23_15 10000.001827786538
R13014 n_14_23_0 n_15_23_0 142.8571167459075
R13015 n_14_23_0 n_14_24_0 1646.6785714286095
R13016 n_14_23_0 n_14_23_1 16499.996984152724
R13017 n_14_23_1 n_15_23_1 199.99996344427046
R13018 n_14_23_1 n_14_24_1 2305.3500000000536
R13019 n_14_23_1 n_14_23_2 37499.993145801636
R13020 n_14_23_2 n_15_23_2 357.1427918647688
R13021 n_14_23_2 n_14_24_2 4116.696428571524
R13022 n_14_23_2 n_14_23_3 35099.993584470336
R13023 n_14_23_3 n_15_23_3 4999.999086106758
R13024 n_14_23_3 n_14_24_3 57633.75000000127
R13025 n_14_23_3 n_14_23_4 466.6665813699765
R13026 n_14_23_4 n_15_23_4 151.51512382141692
R13027 n_14_23_4 n_14_24_4 1746.4772727273116
R13028 n_14_23_15 n_15_23_15 9999.998172213425
R13029 n_14_23_15 n_14_24_15 115267.50000000156
R13030 n_14_24_0 n_15_24_0 6.477753827788668
R13031 n_14_24_0 n_14_25_0 3150.4999738888287
R13032 n_14_24_0 n_14_24_1 748.1805671096096
R13033 n_14_24_1 n_15_24_1 9.068855358904134
R13034 n_14_24_1 n_14_25_1 4410.69996344436
R13035 n_14_24_1 n_14_24_2 1700.4103797945672
R13036 n_14_24_2 n_15_24_2 16.19438456947167
R13037 n_14_24_2 n_14_25_2 7876.249934722071
R13038 n_14_24_2 n_14_24_3 1591.5841154877148
R13039 n_14_24_3 n_15_24_3 226.72138397260318
R13040 n_14_24_3 n_14_25_3 110267.49908610889
R13041 n_14_24_3 n_14_24_4 21.16066250411019
R13042 n_14_24_4 n_15_24_4 6.870344968866762
R13043 n_14_24_4 n_14_25_4 3341.439366245724
R13044 n_14_24_4 n_14_24_5 17.489935335029852
R13045 n_14_24_5 n_15_24_5 43.18502551859108
R13046 n_14_24_5 n_14_25_5 21003.333159258837
R13047 n_14_24_5 n_14_24_6 6.045903572602913
R13048 n_14_24_6 n_15_24_6 7.197504253098513
R13049 n_14_24_6 n_14_25_6 3500.55552654314
R13050 n_14_24_6 n_14_24_7 8.205154848532514
R13051 n_14_24_7 n_15_24_7 12.33857871959749
R13052 n_14_24_7 n_14_25_7 6000.952331216831
R13053 n_14_24_7 n_14_24_8 6.045903572602893
R13054 n_14_24_8 n_15_24_8 12.33857871959749
R13055 n_14_24_8 n_14_25_8 6000.952331216831
R13056 n_14_24_8 n_14_24_9 6.045903572602893
R13057 n_14_24_9 n_15_24_9 12.33857871959749
R13058 n_14_24_9 n_14_25_9 6000.952331216831
R13059 n_14_24_9 n_14_24_10 6.045903572602893
R13060 n_14_24_10 n_15_24_10 12.33857871959749
R13061 n_14_24_10 n_14_25_10 6000.952331216831
R13062 n_14_24_10 n_14_24_11 6.045903572602855
R13063 n_14_24_11 n_15_24_11 12.338578719597646
R13064 n_14_24_11 n_14_25_11 6000.952331216906
R13065 n_14_24_11 n_14_24_12 6.045903572602835
R13066 n_14_24_12 n_15_24_12 12.338578719597567
R13067 n_14_24_12 n_14_25_12 6000.9523312168685
R13068 n_14_24_12 n_14_24_13 6.045903572602892
R13069 n_14_24_13 n_15_24_13 12.338578719597411
R13070 n_14_24_13 n_14_25_13 6000.952331216793
R13071 n_14_24_13 n_14_24_14 30.22951786301454
R13072 n_14_24_14 n_15_24_14 1.3709531910663846
R13073 n_14_24_14 n_14_25_14 666.7724812463132
R13074 n_14_24_14 n_14_24_15 934.0921019671579
R13075 n_14_24_15 n_15_24_15 453.44276794520226
R13076 n_14_24_15 n_14_25_15 220534.99817221588
R13077 n_14_25_0 n_15_25_0 6.477753827788689
R13078 n_14_25_0 n_14_26_0 3150.4999738888287
R13079 n_14_25_0 n_14_25_1 748.180567109612
R13080 n_14_25_1 n_15_25_1 9.068855358904163
R13081 n_14_25_1 n_14_26_1 4410.69996344436
R13082 n_14_25_1 n_14_25_2 1700.4103797945727
R13083 n_14_25_2 n_15_25_2 16.194384569471723
R13084 n_14_25_2 n_14_26_2 7876.249934722071
R13085 n_14_25_2 n_14_25_3 1591.58411548772
R13086 n_14_25_3 n_15_25_3 226.72138397260392
R13087 n_14_25_3 n_14_26_3 110267.49908610889
R13088 n_14_25_3 n_14_25_4 21.160662504110256
R13089 n_14_25_4 n_15_25_4 6.870344968866785
R13090 n_14_25_4 n_14_26_4 3341.439366245724
R13091 n_14_25_4 n_14_25_5 17.489935335029905
R13092 n_14_25_5 n_15_25_5 43.18502551859122
R13093 n_14_25_5 n_14_26_5 21003.333159258837
R13094 n_14_25_5 n_14_25_6 6.045903572602931
R13095 n_14_25_6 n_15_25_6 7.197504253098536
R13096 n_14_25_6 n_14_26_6 3500.55552654314
R13097 n_14_25_6 n_14_25_7 8.20515484853254
R13098 n_14_25_7 n_15_25_7 12.33857871959753
R13099 n_14_25_7 n_14_26_7 6000.952331216831
R13100 n_14_25_7 n_14_25_8 6.045903572602913
R13101 n_14_25_8 n_15_25_8 12.33857871959753
R13102 n_14_25_8 n_14_26_8 6000.952331216831
R13103 n_14_25_8 n_14_25_9 6.045903572602913
R13104 n_14_25_9 n_15_25_9 12.33857871959753
R13105 n_14_25_9 n_14_26_9 6000.952331216831
R13106 n_14_25_9 n_14_25_10 6.045903572602913
R13107 n_14_25_10 n_15_25_10 12.33857871959753
R13108 n_14_25_10 n_14_26_10 6000.952331216831
R13109 n_14_25_10 n_14_25_11 6.0459035726028745
R13110 n_14_25_11 n_15_25_11 12.338578719597688
R13111 n_14_25_11 n_14_26_11 6000.952331216906
R13112 n_14_25_11 n_14_25_12 6.045903572602855
R13113 n_14_25_12 n_15_25_12 12.338578719597605
R13114 n_14_25_12 n_14_26_12 6000.9523312168685
R13115 n_14_25_12 n_14_25_13 6.045903572602912
R13116 n_14_25_13 n_15_25_13 12.338578719597454
R13117 n_14_25_13 n_14_26_13 6000.952331216793
R13118 n_14_25_13 n_14_25_14 30.22951786301464
R13119 n_14_25_14 n_15_25_14 1.370953191066389
R13120 n_14_25_14 n_14_26_14 666.7724812463132
R13121 n_14_25_14 n_14_25_15 934.0921019671609
R13122 n_14_25_15 n_15_25_15 453.44276794520374
R13123 n_14_25_15 n_14_26_15 220534.99817221588
R13124 n_14_26_0 n_15_26_0 6.477753827788668
R13125 n_14_26_0 n_14_27_0 3150.4999738888337
R13126 n_14_26_0 n_14_26_1 748.1805671096096
R13127 n_14_26_1 n_15_26_1 9.068855358904134
R13128 n_14_26_1 n_14_27_1 4410.699963444367
R13129 n_14_26_1 n_14_26_2 1700.4103797945672
R13130 n_14_26_2 n_15_26_2 16.19438456947167
R13131 n_14_26_2 n_14_27_2 7876.249934722084
R13132 n_14_26_2 n_14_26_3 1591.5841154877148
R13133 n_14_26_3 n_15_26_3 226.72138397260318
R13134 n_14_26_3 n_14_27_3 110267.49908610906
R13135 n_14_26_3 n_14_26_4 21.16066250411019
R13136 n_14_26_4 n_15_26_4 6.870344968866762
R13137 n_14_26_4 n_14_27_4 3341.4393662457296
R13138 n_14_26_4 n_14_26_5 17.489935335029852
R13139 n_14_26_5 n_15_26_5 43.18502551859108
R13140 n_14_26_5 n_14_27_5 21003.33315925887
R13141 n_14_26_5 n_14_26_6 6.045903572602913
R13142 n_14_26_6 n_15_26_6 7.197504253098513
R13143 n_14_26_6 n_14_27_6 3500.5555265431453
R13144 n_14_26_6 n_14_26_7 8.205154848532514
R13145 n_14_26_7 n_15_26_7 12.33857871959749
R13146 n_14_26_7 n_14_27_7 6000.95233121684
R13147 n_14_26_7 n_14_26_8 6.045903572602893
R13148 n_14_26_8 n_15_26_8 12.33857871959749
R13149 n_14_26_8 n_14_27_8 6000.95233121684
R13150 n_14_26_8 n_14_26_9 6.045903572602893
R13151 n_14_26_9 n_15_26_9 12.33857871959749
R13152 n_14_26_9 n_14_27_9 6000.95233121684
R13153 n_14_26_9 n_14_26_10 6.045903572602893
R13154 n_14_26_10 n_15_26_10 12.33857871959749
R13155 n_14_26_10 n_14_27_10 6000.95233121684
R13156 n_14_26_10 n_14_26_11 6.045903572602855
R13157 n_14_26_11 n_15_26_11 12.338578719597646
R13158 n_14_26_11 n_14_27_11 6000.952331216916
R13159 n_14_26_11 n_14_26_12 6.045903572602835
R13160 n_14_26_12 n_15_26_12 12.338578719597567
R13161 n_14_26_12 n_14_27_12 6000.952331216878
R13162 n_14_26_12 n_14_26_13 6.045903572602892
R13163 n_14_26_13 n_15_26_13 12.338578719597411
R13164 n_14_26_13 n_14_27_13 6000.952331216802
R13165 n_14_26_13 n_14_26_14 30.22951786301454
R13166 n_14_26_14 n_15_26_14 1.3709531910663846
R13167 n_14_26_14 n_14_27_14 666.7724812463142
R13168 n_14_26_14 n_14_26_15 934.0921019671579
R13169 n_14_26_15 n_15_26_15 453.44276794520226
R13170 n_14_26_15 n_14_27_15 220534.99817221623
R13171 n_14_27_0 n_15_27_0 6.477753827788668
R13172 n_14_27_0 n_14_27_1 748.1805671096096
R13173 n_14_27_1 n_15_27_1 9.068855358904134
R13174 n_14_27_1 n_14_27_2 1700.4103797945672
R13175 n_14_27_2 n_15_27_2 16.19438456947167
R13176 n_14_27_2 n_14_27_3 1591.5841154877148
R13177 n_14_27_3 n_15_27_3 226.72138397260318
R13178 n_14_27_3 n_14_27_4 21.16066250411019
R13179 n_14_27_4 n_15_27_4 6.870344968866762
R13180 n_14_27_4 n_14_27_5 17.489935335029852
R13181 n_14_27_5 n_15_27_5 43.18502551859108
R13182 n_14_27_5 n_14_27_6 6.045903572602913
R13183 n_14_27_6 n_15_27_6 7.197504253098513
R13184 n_14_27_6 n_14_27_7 8.205154848532514
R13185 n_14_27_7 n_15_27_7 12.33857871959749
R13186 n_14_27_7 n_14_27_8 6.045903572602893
R13187 n_14_27_8 n_15_27_8 12.33857871959749
R13188 n_14_27_8 n_14_27_9 6.045903572602893
R13189 n_14_27_9 n_15_27_9 12.33857871959749
R13190 n_14_27_9 n_14_27_10 6.045903572602893
R13191 n_14_27_10 n_15_27_10 12.33857871959749
R13192 n_14_27_10 n_14_27_11 6.045903572602855
R13193 n_14_27_11 n_15_27_11 12.338578719597646
R13194 n_14_27_11 n_14_27_12 6.045903572602835
R13195 n_14_27_12 n_15_27_12 12.338578719597567
R13196 n_14_27_12 n_14_27_13 6.045903572602892
R13197 n_14_27_13 n_15_27_13 12.338578719597411
R13198 n_14_27_13 n_14_27_14 30.22951786301454
R13199 n_14_27_14 n_15_27_14 1.3709531910663846
R13200 n_14_27_14 n_14_27_15 934.0921019671579
R13201 n_14_27_15 n_15_27_15 453.44276794520226
R13202 n_15_0_0 n_16_0_0 125.67181420979068
R13203 n_15_0_0 n_15_1_0 3150.5002452092954
R13204 n_15_0_0 n_15_0_1 748.1805026763932
R13205 n_15_0_1 n_16_0_1 175.9405398937069
R13206 n_15_0_1 n_15_1_1 4410.700343293014
R13207 n_15_0_1 n_15_0_2 1700.4102333554388
R13208 n_15_0_2 n_16_0_2 314.1795355244767
R13209 n_15_0_2 n_15_1_2 7876.25061302324
R13210 n_15_0_2 n_15_0_3 1591.5839784206908
R13211 n_15_0_3 n_16_0_3 4398.513497342668
R13212 n_15_0_3 n_15_1_3 110267.50858232524
R13213 n_15_0_3 n_15_0_4 21.160660681756593
R13214 n_15_0_4 n_16_0_4 133.2882877982627
R13215 n_15_0_4 n_15_1_4 3341.4396540098564
R13216 n_15_0_4 n_15_0_5 17.489933828798815
R13217 n_15_0_5 n_16_0_5 837.8120947319369
R13218 n_15_0_5 n_15_1_5 21003.33496806195
R13219 n_15_0_5 n_15_0_6 6.045903051930455
R13220 n_15_0_6 n_16_0_6 139.6353491219895
R13221 n_15_0_6 n_15_1_6 3500.5558280103255
R13222 n_15_0_6 n_15_0_7 8.205154141905608
R13223 n_15_0_7 n_16_0_7 239.37488420912558
R13224 n_15_0_7 n_15_1_7 6000.95284801772
R13225 n_15_0_7 n_15_0_8 6.045903051930436
R13226 n_15_0_8 n_16_0_8 239.37488420912558
R13227 n_15_0_8 n_15_1_8 6000.95284801772
R13228 n_15_0_8 n_15_0_9 6.045903051930436
R13229 n_15_0_9 n_16_0_9 239.37488420912558
R13230 n_15_0_9 n_15_1_9 6000.95284801772
R13231 n_15_0_9 n_15_0_10 6.045903051930436
R13232 n_15_0_10 n_16_0_10 239.37488420912558
R13233 n_15_0_10 n_15_1_10 6000.95284801772
R13234 n_15_0_10 n_15_0_11 6.045903051930397
R13235 n_15_0_11 n_16_0_11 239.37488420912865
R13236 n_15_0_11 n_15_1_11 6000.952848017796
R13237 n_15_0_11 n_15_0_12 6.045903051930377
R13238 n_15_0_12 n_16_0_12 239.3748842091272
R13239 n_15_0_12 n_15_1_12 6000.952848017758
R13240 n_15_0_12 n_15_0_13 6.045903051930436
R13241 n_15_0_13 n_16_0_13 239.3748842091241
R13242 n_15_0_13 n_15_1_13 6000.952848017681
R13243 n_15_0_13 n_15_0_14 30.229515259652253
R13244 n_15_0_14 n_16_0_14 26.597209356569458
R13245 n_15_0_14 n_15_1_14 666.7725386686341
R13246 n_15_0_14 n_15_0_15 934.0920215232634
R13247 n_15_0_15 n_16_0_15 8797.02699468526
R13248 n_15_0_15 n_15_1_15 220535.01716464857
R13249 n_15_1_0 n_16_1_0 125.67181420979068
R13250 n_15_1_0 n_15_2_0 3150.5002452092954
R13251 n_15_1_0 n_15_1_1 748.1805026763932
R13252 n_15_1_1 n_16_1_1 175.9405398937069
R13253 n_15_1_1 n_15_2_1 4410.700343293014
R13254 n_15_1_1 n_15_1_2 1700.4102333554388
R13255 n_15_1_2 n_16_1_2 314.1795355244767
R13256 n_15_1_2 n_15_2_2 7876.25061302324
R13257 n_15_1_2 n_15_1_3 1591.5839784206908
R13258 n_15_1_3 n_16_1_3 4398.513497342668
R13259 n_15_1_3 n_15_2_3 110267.50858232524
R13260 n_15_1_3 n_15_1_4 21.160660681756593
R13261 n_15_1_4 n_16_1_4 133.2882877982627
R13262 n_15_1_4 n_15_2_4 3341.4396540098564
R13263 n_15_1_4 n_15_1_5 17.489933828798815
R13264 n_15_1_5 n_16_1_5 837.8120947319369
R13265 n_15_1_5 n_15_2_5 21003.33496806195
R13266 n_15_1_5 n_15_1_6 6.045903051930455
R13267 n_15_1_6 n_16_1_6 139.6353491219895
R13268 n_15_1_6 n_15_2_6 3500.5558280103255
R13269 n_15_1_6 n_15_1_7 8.205154141905608
R13270 n_15_1_7 n_16_1_7 239.37488420912558
R13271 n_15_1_7 n_15_2_7 6000.95284801772
R13272 n_15_1_7 n_15_1_8 6.045903051930436
R13273 n_15_1_8 n_16_1_8 239.37488420912558
R13274 n_15_1_8 n_15_2_8 6000.95284801772
R13275 n_15_1_8 n_15_1_9 6.045903051930436
R13276 n_15_1_9 n_16_1_9 239.37488420912558
R13277 n_15_1_9 n_15_2_9 6000.95284801772
R13278 n_15_1_9 n_15_1_10 6.045903051930436
R13279 n_15_1_10 n_16_1_10 239.37488420912558
R13280 n_15_1_10 n_15_2_10 6000.95284801772
R13281 n_15_1_10 n_15_1_11 6.045903051930397
R13282 n_15_1_11 n_16_1_11 239.37488420912865
R13283 n_15_1_11 n_15_2_11 6000.952848017796
R13284 n_15_1_11 n_15_1_12 6.045903051930377
R13285 n_15_1_12 n_16_1_12 239.3748842091272
R13286 n_15_1_12 n_15_2_12 6000.952848017758
R13287 n_15_1_12 n_15_1_13 6.045903051930436
R13288 n_15_1_13 n_16_1_13 239.3748842091241
R13289 n_15_1_13 n_15_2_13 6000.952848017681
R13290 n_15_1_13 n_15_1_14 30.229515259652253
R13291 n_15_1_14 n_16_1_14 26.597209356569458
R13292 n_15_1_14 n_15_2_14 666.7725386686341
R13293 n_15_1_14 n_15_1_15 934.0920215232634
R13294 n_15_1_15 n_16_1_15 8797.02699468526
R13295 n_15_1_15 n_15_2_15 220535.01716464857
R13296 n_15_2_0 n_16_2_0 125.67181420979068
R13297 n_15_2_0 n_15_3_0 3150.5002452092954
R13298 n_15_2_0 n_15_2_1 748.1805026763932
R13299 n_15_2_1 n_16_2_1 175.9405398937069
R13300 n_15_2_1 n_15_3_1 4410.700343293014
R13301 n_15_2_1 n_15_2_2 1700.4102333554388
R13302 n_15_2_2 n_16_2_2 314.1795355244767
R13303 n_15_2_2 n_15_3_2 7876.25061302324
R13304 n_15_2_2 n_15_2_3 1591.5839784206908
R13305 n_15_2_3 n_16_2_3 4398.513497342668
R13306 n_15_2_3 n_15_3_3 110267.50858232524
R13307 n_15_2_3 n_15_2_4 21.160660681756593
R13308 n_15_2_4 n_16_2_4 133.2882877982627
R13309 n_15_2_4 n_15_3_4 3341.4396540098564
R13310 n_15_2_4 n_15_2_5 17.489933828798815
R13311 n_15_2_5 n_16_2_5 837.8120947319369
R13312 n_15_2_5 n_15_3_5 21003.33496806195
R13313 n_15_2_5 n_15_2_6 6.045903051930455
R13314 n_15_2_6 n_16_2_6 139.6353491219895
R13315 n_15_2_6 n_15_3_6 3500.5558280103255
R13316 n_15_2_6 n_15_2_7 8.205154141905608
R13317 n_15_2_7 n_16_2_7 239.37488420912558
R13318 n_15_2_7 n_15_3_7 6000.95284801772
R13319 n_15_2_7 n_15_2_8 6.045903051930436
R13320 n_15_2_8 n_16_2_8 239.37488420912558
R13321 n_15_2_8 n_15_3_8 6000.95284801772
R13322 n_15_2_8 n_15_2_9 6.045903051930436
R13323 n_15_2_9 n_16_2_9 239.37488420912558
R13324 n_15_2_9 n_15_3_9 6000.95284801772
R13325 n_15_2_9 n_15_2_10 6.045903051930436
R13326 n_15_2_10 n_16_2_10 239.37488420912558
R13327 n_15_2_10 n_15_3_10 6000.95284801772
R13328 n_15_2_10 n_15_2_11 6.045903051930397
R13329 n_15_2_11 n_16_2_11 239.37488420912865
R13330 n_15_2_11 n_15_3_11 6000.952848017796
R13331 n_15_2_11 n_15_2_12 6.045903051930377
R13332 n_15_2_12 n_16_2_12 239.3748842091272
R13333 n_15_2_12 n_15_3_12 6000.952848017758
R13334 n_15_2_12 n_15_2_13 6.045903051930436
R13335 n_15_2_13 n_16_2_13 239.3748842091241
R13336 n_15_2_13 n_15_3_13 6000.952848017681
R13337 n_15_2_13 n_15_2_14 30.229515259652253
R13338 n_15_2_14 n_16_2_14 26.597209356569458
R13339 n_15_2_14 n_15_3_14 666.7725386686341
R13340 n_15_2_14 n_15_2_15 934.0920215232634
R13341 n_15_2_15 n_16_2_15 8797.02699468526
R13342 n_15_2_15 n_15_3_15 220535.01716464857
R13343 n_15_3_0 n_16_3_0 125.67181420979068
R13344 n_15_3_0 n_15_4_0 1646.6785714285472
R13345 n_15_3_0 n_15_3_1 748.1805026763932
R13346 n_15_3_1 n_16_3_1 175.9405398937069
R13347 n_15_3_1 n_15_4_1 2305.3499999999667
R13348 n_15_3_1 n_15_3_2 1700.4102333554388
R13349 n_15_3_2 n_16_3_2 314.1795355244767
R13350 n_15_3_2 n_15_4_2 4116.696428571369
R13351 n_15_3_2 n_15_3_3 1591.5839784206908
R13352 n_15_3_3 n_16_3_3 4398.513497342668
R13353 n_15_3_3 n_15_4_3 57633.749999999105
R13354 n_15_3_3 n_15_3_4 21.160660681756593
R13355 n_15_3_4 n_16_3_4 133.2882877982627
R13356 n_15_3_4 n_15_4_4 1746.477272727246
R13357 n_15_3_4 n_15_3_5 17.489933828798815
R13358 n_15_3_5 n_16_3_5 837.8120947319369
R13359 n_15_3_5 n_15_3_6 6.045903051930455
R13360 n_15_3_6 n_16_3_6 139.6353491219895
R13361 n_15_3_6 n_15_3_7 8.205154141905608
R13362 n_15_3_7 n_16_3_7 239.37488420912558
R13363 n_15_3_7 n_15_3_8 6.045903051930436
R13364 n_15_3_8 n_16_3_8 239.37488420912558
R13365 n_15_3_8 n_15_3_9 6.045903051930436
R13366 n_15_3_9 n_16_3_9 239.37488420912558
R13367 n_15_3_9 n_15_3_10 6.045903051930436
R13368 n_15_3_10 n_16_3_10 239.37488420912558
R13369 n_15_3_10 n_15_3_11 6.045903051930397
R13370 n_15_3_11 n_16_3_11 239.37488420912865
R13371 n_15_3_11 n_15_3_12 6.045903051930377
R13372 n_15_3_12 n_16_3_12 239.3748842091272
R13373 n_15_3_12 n_15_3_13 6.045903051930436
R13374 n_15_3_13 n_16_3_13 239.3748842091241
R13375 n_15_3_13 n_15_3_14 30.229515259652253
R13376 n_15_3_14 n_16_3_14 26.597209356569458
R13377 n_15_3_14 n_15_3_15 934.0920215232634
R13378 n_15_3_15 n_16_3_15 8797.02699468526
R13379 n_15_3_15 n_15_4_15 115267.4999999972
R13380 n_15_4_0 n_16_4_0 2771.508327585062
R13381 n_15_4_0 n_15_5_0 142.8568976478005
R13382 n_15_4_0 n_15_4_1 16500.028321727335
R13383 n_15_4_1 n_16_4_1 3880.111658619087
R13384 n_15_4_1 n_15_5_1 199.99965670692075
R13385 n_15_4_1 n_15_4_2 37500.064367562125
R13386 n_15_4_2 n_16_4_2 6928.7708189626555
R13387 n_15_4_2 n_15_5_2 357.14224411950136
R13388 n_15_4_2 n_15_4_3 35100.06024803815
R13389 n_15_4_3 n_16_4_3 97002.7914654771
R13390 n_15_4_3 n_15_5_3 4999.9914176730135
R13391 n_15_4_3 n_15_4_4 466.66746768521796
R13392 n_15_4_4 n_16_4_4 2939.4785292568818
R13393 n_15_4_4 n_15_5_4 151.5148914446368
R13394 n_15_4_15 n_16_4_15 194005.58293095249
R13395 n_15_4_15 n_15_5_15 9999.982835345938
R13396 n_15_5_0 n_16_5_0 2771.5083275850134
R13397 n_15_5_0 n_15_6_0 142.8568976478018
R13398 n_15_5_0 n_15_5_1 16500.02832172704
R13399 n_15_5_1 n_16_5_1 3880.111658619018
R13400 n_15_5_1 n_15_6_1 199.9996567069225
R13401 n_15_5_1 n_15_5_2 37500.06436756146
R13402 n_15_5_2 n_16_5_2 6928.770818962533
R13403 n_15_5_2 n_15_6_2 357.1422441195045
R13404 n_15_5_2 n_15_5_3 35100.06024803753
R13405 n_15_5_3 n_16_5_3 97002.79146547537
R13406 n_15_5_3 n_15_6_3 4999.991417673058
R13407 n_15_5_3 n_15_5_4 466.66746768520966
R13408 n_15_5_4 n_16_5_4 2939.4785292568295
R13409 n_15_5_4 n_15_6_4 151.51489144463812
R13410 n_15_5_15 n_16_5_15 194005.58293094902
R13411 n_15_5_15 n_15_6_15 9999.982835346027
R13412 n_15_6_0 n_16_6_0 2771.5083275850134
R13413 n_15_6_0 n_15_7_0 142.8568976478005
R13414 n_15_6_0 n_15_6_1 16500.02832172704
R13415 n_15_6_1 n_16_6_1 3880.111658619018
R13416 n_15_6_1 n_15_7_1 199.99965670692075
R13417 n_15_6_1 n_15_6_2 37500.06436756146
R13418 n_15_6_2 n_16_6_2 6928.770818962533
R13419 n_15_6_2 n_15_7_2 357.14224411950136
R13420 n_15_6_2 n_15_6_3 35100.06024803753
R13421 n_15_6_3 n_16_6_3 97002.79146547537
R13422 n_15_6_3 n_15_7_3 4999.9914176730135
R13423 n_15_6_3 n_15_6_4 466.66746768520966
R13424 n_15_6_4 n_16_6_4 2939.4785292568295
R13425 n_15_6_4 n_15_7_4 151.5148914446368
R13426 n_15_6_15 n_16_6_15 194005.58293094902
R13427 n_15_6_15 n_15_7_15 9999.982835345938
R13428 n_15_7_0 n_16_7_0 2771.508327585062
R13429 n_15_7_0 n_15_8_0 4174.885948823841
R13430 n_15_7_0 n_15_7_1 16500.028321727335
R13431 n_15_7_1 n_16_7_1 3880.111658619087
R13432 n_15_7_1 n_15_8_1 5844.840328353377
R13433 n_15_7_1 n_15_7_2 37500.064367562125
R13434 n_15_7_2 n_16_7_2 6928.7708189626555
R13435 n_15_7_2 n_15_8_2 10437.214872059603
R13436 n_15_7_2 n_15_7_3 35100.06024803815
R13437 n_15_7_3 n_16_7_3 97002.7914654771
R13438 n_15_7_3 n_15_8_3 146121.00820883428
R13439 n_15_7_3 n_15_7_4 466.66746768521796
R13440 n_15_7_4 n_16_7_4 2939.4785292568818
R13441 n_15_7_4 n_15_8_4 4427.909339661646
R13442 n_15_7_15 n_16_7_15 194005.58293095249
R13443 n_15_7_15 n_15_8_15 292242.01641766605
R13444 n_15_8_0 n_16_8_0 48.24335106234782
R13445 n_15_8_0 n_15_9_0 8206.914999999884
R13446 n_15_8_0 n_15_8_1 287.21424032572827
R13447 n_15_8_1 n_16_8_1 67.54069148728694
R13448 n_15_8_1 n_15_9_1 11489.680999999839
R13449 n_15_8_1 n_15_8_2 652.759637103928
R13450 n_15_8_2 n_16_8_2 120.60837765586953
R13451 n_15_8_2 n_15_9_2 20517.287499999715
R13452 n_15_8_2 n_15_8_3 610.9830203292765
R13453 n_15_8_3 n_16_8_3 1688.517287182172
R13454 n_15_8_3 n_15_9_3 287242.0249999957
R13455 n_15_8_3 n_15_8_4 8.123231039515554
R13456 n_15_8_4 n_16_8_4 51.16719052067188
R13457 n_15_8_4 n_15_9_4 8704.30378787866
R13458 n_15_8_15 n_16_8_15 3377.034574364314
R13459 n_15_8_15 n_15_9_15 574484.0499999863
R13460 n_15_9_0 n_16_9_0 48.243351062347784
R13461 n_15_9_0 n_15_10_0 8206.914999999884
R13462 n_15_9_0 n_15_9_1 287.2142403257281
R13463 n_15_9_1 n_16_9_1 67.5406914872869
R13464 n_15_9_1 n_15_10_1 11489.680999999839
R13465 n_15_9_1 n_15_9_2 652.7596371039276
R13466 n_15_9_2 n_16_9_2 120.60837765586945
R13467 n_15_9_2 n_15_10_2 20517.287499999715
R13468 n_15_9_2 n_15_9_3 610.9830203292762
R13469 n_15_9_3 n_16_9_3 1688.517287182171
R13470 n_15_9_3 n_15_10_3 287242.0249999957
R13471 n_15_9_3 n_15_9_4 8.123231039515549
R13472 n_15_9_4 n_16_9_4 51.167190520671845
R13473 n_15_9_4 n_15_10_4 8704.30378787866
R13474 n_15_9_15 n_16_9_15 3377.034574364312
R13475 n_15_9_15 n_15_10_15 574484.0499999863
R13476 n_15_10_0 n_16_10_0 48.24335106234782
R13477 n_15_10_0 n_15_11_0 8206.914999999883
R13478 n_15_10_0 n_15_10_1 287.21424032572827
R13479 n_15_10_1 n_16_10_1 67.54069148728694
R13480 n_15_10_1 n_15_11_1 11489.680999999835
R13481 n_15_10_1 n_15_10_2 652.759637103928
R13482 n_15_10_2 n_16_10_2 120.60837765586953
R13483 n_15_10_2 n_15_11_2 20517.287499999708
R13484 n_15_10_2 n_15_10_3 610.9830203292765
R13485 n_15_10_3 n_16_10_3 1688.517287182172
R13486 n_15_10_3 n_15_11_3 287242.0249999956
R13487 n_15_10_3 n_15_10_4 8.123231039515554
R13488 n_15_10_4 n_16_10_4 51.16719052067188
R13489 n_15_10_4 n_15_11_4 8704.303787878656
R13490 n_15_10_15 n_16_10_15 3377.034574364314
R13491 n_15_10_15 n_15_11_15 574484.0499999862
R13492 n_15_11_0 n_16_11_0 48.24335106234782
R13493 n_15_11_0 n_15_12_0 4174.886071428513
R13494 n_15_11_0 n_15_11_1 287.21424032572827
R13495 n_15_11_1 n_16_11_1 67.54069148728694
R13496 n_15_11_1 n_15_12_1 5844.8404999999175
R13497 n_15_11_1 n_15_11_2 652.759637103928
R13498 n_15_11_2 n_16_11_2 120.60837765586953
R13499 n_15_11_2 n_15_12_2 10437.215178571283
R13500 n_15_11_2 n_15_11_3 610.9830203292765
R13501 n_15_11_3 n_16_11_3 1688.517287182172
R13502 n_15_11_3 n_15_12_3 146121.0124999978
R13503 n_15_11_3 n_15_11_4 8.123231039515554
R13504 n_15_11_4 n_16_11_4 51.16719052067188
R13505 n_15_11_4 n_15_12_4 4427.909469696904
R13506 n_15_11_15 n_16_11_15 3377.034574364314
R13507 n_15_11_15 n_15_12_15 292242.02499999304
R13508 n_15_12_0 n_16_12_0 2771.5035703868975
R13509 n_15_12_0 n_15_13_0 142.85714285714286
R13510 n_15_12_0 n_15_12_1 16499.99999999953
R13511 n_15_12_1 n_16_12_1 3880.104998541656
R13512 n_15_12_1 n_15_13_1 200.00000000000003
R13513 n_15_12_1 n_15_12_2 37499.99999999893
R13514 n_15_12_2 n_16_12_2 6928.758925967244
R13515 n_15_12_2 n_15_13_2 357.1428571428572
R13516 n_15_12_2 n_15_12_3 35099.999999999
R13517 n_15_12_3 n_16_12_3 97002.62496354131
R13518 n_15_12_3 n_15_13_3 4999.999999999996
R13519 n_15_12_3 n_15_12_4 466.66666666665384
R13520 n_15_12_4 n_16_12_4 2939.4734837436763
R13521 n_15_12_4 n_15_13_4 151.51515151515142
R13522 n_15_12_15 n_16_12_15 194005.2499270809
R13523 n_15_12_15 n_15_13_15 9999.999999999904
R13524 n_15_13_0 n_16_13_0 2771.5035703868975
R13525 n_15_13_0 n_15_14_0 142.85714285714286
R13526 n_15_13_0 n_15_13_1 16499.99999999953
R13527 n_15_13_1 n_16_13_1 3880.104998541656
R13528 n_15_13_1 n_15_14_1 200.00000000000003
R13529 n_15_13_1 n_15_13_2 37499.99999999893
R13530 n_15_13_2 n_16_13_2 6928.758925967244
R13531 n_15_13_2 n_15_14_2 357.1428571428572
R13532 n_15_13_2 n_15_13_3 35099.999999999
R13533 n_15_13_3 n_16_13_3 97002.62496354131
R13534 n_15_13_3 n_15_14_3 4999.999999999996
R13535 n_15_13_3 n_15_13_4 466.66666666665384
R13536 n_15_13_4 n_16_13_4 2939.4734837436763
R13537 n_15_13_4 n_15_14_4 151.51515151515142
R13538 n_15_13_15 n_16_13_15 194005.2499270809
R13539 n_15_13_15 n_15_14_15 9999.999999999904
R13540 n_15_14_0 n_16_14_0 2771.5035703868975
R13541 n_15_14_0 n_15_15_0 142.85714285714286
R13542 n_15_14_0 n_15_14_1 16499.99999999953
R13543 n_15_14_1 n_16_14_1 3880.104998541656
R13544 n_15_14_1 n_15_15_1 200.00000000000003
R13545 n_15_14_1 n_15_14_2 37499.99999999893
R13546 n_15_14_2 n_16_14_2 6928.758925967244
R13547 n_15_14_2 n_15_15_2 357.1428571428572
R13548 n_15_14_2 n_15_14_3 35099.999999999
R13549 n_15_14_3 n_16_14_3 97002.62496354131
R13550 n_15_14_3 n_15_15_3 4999.999999999996
R13551 n_15_14_3 n_15_14_4 466.66666666665384
R13552 n_15_14_4 n_16_14_4 2939.4734837436763
R13553 n_15_14_4 n_15_15_4 151.51515151515142
R13554 n_15_14_15 n_16_14_15 194005.2499270809
R13555 n_15_14_15 n_15_15_15 9999.999999999904
R13556 n_15_15_0 n_16_15_0 2771.5035703868975
R13557 n_15_15_0 n_15_16_0 4174.88607142851
R13558 n_15_15_0 n_15_15_1 16499.99999999953
R13559 n_15_15_1 n_16_15_1 3880.104998541656
R13560 n_15_15_1 n_15_16_1 5844.840499999915
R13561 n_15_15_1 n_15_15_2 37499.99999999893
R13562 n_15_15_2 n_16_15_2 6928.758925967244
R13563 n_15_15_2 n_15_16_2 10437.215178571278
R13564 n_15_15_2 n_15_15_3 35099.999999999
R13565 n_15_15_3 n_16_15_3 97002.62496354131
R13566 n_15_15_3 n_15_16_3 146121.0124999977
R13567 n_15_15_3 n_15_15_4 466.66666666665384
R13568 n_15_15_4 n_16_15_4 2939.4734837436763
R13569 n_15_15_4 n_15_16_4 4427.909469696901
R13570 n_15_15_15 n_16_15_15 194005.2499270809
R13571 n_15_15_15 n_15_16_15 292242.02499999286
R13572 n_15_16_0 n_16_16_0 48.243351062347855
R13573 n_15_16_0 n_15_17_0 8206.914999999883
R13574 n_15_16_0 n_15_16_1 287.21424032572844
R13575 n_15_16_1 n_16_16_1 67.54069148728698
R13576 n_15_16_1 n_15_17_1 11489.680999999837
R13577 n_15_16_1 n_15_16_2 652.7596371039283
R13578 n_15_16_2 n_16_16_2 120.60837765586962
R13579 n_15_16_2 n_15_17_2 20517.287499999708
R13580 n_15_16_2 n_15_16_3 610.9830203292769
R13581 n_15_16_3 n_16_16_3 1688.5172871821728
R13582 n_15_16_3 n_15_17_3 287242.0249999956
R13583 n_15_16_3 n_15_16_4 8.12323103951556
R13584 n_15_16_4 n_16_16_4 51.167190520671895
R13585 n_15_16_4 n_15_17_4 8704.303787878656
R13586 n_15_16_15 n_16_16_15 3377.034574364316
R13587 n_15_16_15 n_15_17_15 574484.0499999862
R13588 n_15_17_0 n_16_17_0 48.243351062347784
R13589 n_15_17_0 n_15_18_0 8206.914999999888
R13590 n_15_17_0 n_15_17_1 287.2142403257281
R13591 n_15_17_1 n_16_17_1 67.5406914872869
R13592 n_15_17_1 n_15_18_1 11489.680999999842
R13593 n_15_17_1 n_15_17_2 652.7596371039276
R13594 n_15_17_2 n_16_17_2 120.60837765586945
R13595 n_15_17_2 n_15_18_2 20517.287499999722
R13596 n_15_17_2 n_15_17_3 610.9830203292762
R13597 n_15_17_3 n_16_17_3 1688.517287182171
R13598 n_15_17_3 n_15_18_3 287242.0249999958
R13599 n_15_17_3 n_15_17_4 8.123231039515549
R13600 n_15_17_4 n_16_17_4 51.167190520671845
R13601 n_15_17_4 n_15_18_4 8704.303787878662
R13602 n_15_17_15 n_16_17_15 3377.034574364312
R13603 n_15_17_15 n_15_18_15 574484.0499999865
R13604 n_15_18_0 n_16_18_0 48.243351062347784
R13605 n_15_18_0 n_15_19_0 8206.914999999883
R13606 n_15_18_0 n_15_18_1 287.2142403257281
R13607 n_15_18_1 n_16_18_1 67.5406914872869
R13608 n_15_18_1 n_15_19_1 11489.680999999837
R13609 n_15_18_1 n_15_18_2 652.7596371039276
R13610 n_15_18_2 n_16_18_2 120.60837765586945
R13611 n_15_18_2 n_15_19_2 20517.287499999708
R13612 n_15_18_2 n_15_18_3 610.9830203292762
R13613 n_15_18_3 n_16_18_3 1688.517287182171
R13614 n_15_18_3 n_15_19_3 287242.0249999956
R13615 n_15_18_3 n_15_18_4 8.123231039515549
R13616 n_15_18_4 n_16_18_4 51.167190520671845
R13617 n_15_18_4 n_15_19_4 8704.303787878656
R13618 n_15_18_15 n_16_18_15 3377.034574364312
R13619 n_15_18_15 n_15_19_15 574484.0499999862
R13620 n_15_19_0 n_16_19_0 48.243351062347855
R13621 n_15_19_0 n_15_20_0 4174.886084484129
R13622 n_15_19_0 n_15_19_1 287.21424032572844
R13623 n_15_19_1 n_16_19_1 67.54069148728698
R13624 n_15_19_1 n_15_20_1 5844.8405182777815
R13625 n_15_19_1 n_15_19_2 652.7596371039283
R13626 n_15_19_2 n_16_19_2 120.60837765586962
R13627 n_15_19_2 n_15_20_2 10437.215211210323
R13628 n_15_19_2 n_15_19_3 610.9830203292769
R13629 n_15_19_3 n_16_19_3 1688.5172871821728
R13630 n_15_19_3 n_15_20_3 146121.01295694438
R13631 n_15_19_3 n_15_19_4 8.12323103951556
R13632 n_15_19_4 n_16_19_4 51.167190520671895
R13633 n_15_19_4 n_15_20_4 4427.90948354377
R13634 n_15_19_15 n_16_19_15 3377.034574364316
R13635 n_15_19_15 n_15_20_15 292242.0259138862
R13636 n_15_20_0 n_16_20_0 2771.5030638152725
R13637 n_15_20_0 n_15_21_0 142.85716896838048
R13638 n_15_20_0 n_15_20_1 16499.996984152138
R13639 n_15_20_1 n_16_20_1 3880.10428934138
R13640 n_15_20_1 n_15_21_1 200.00003655573266
R13641 n_15_20_1 n_15_20_2 37499.99314580031
R13642 n_15_20_2 n_16_20_2 6928.757659538181
R13643 n_15_20_2 n_15_21_2 357.1429224209512
R13644 n_15_20_2 n_15_20_3 35099.99358446909
R13645 n_15_20_3 n_16_20_3 97002.60723353442
R13646 n_15_20_3 n_15_21_3 5000.000913893312
R13647 n_15_20_3 n_15_20_4 466.66658136996
R13648 n_15_20_4 n_16_20_4 2939.47294647074
R13649 n_15_20_4 n_15_21_4 151.51517920888827
R13650 n_15_20_15 n_16_20_15 194005.21446706713
R13651 n_15_20_15 n_15_21_15 10000.001827786537
R13652 n_15_21_0 n_16_21_0 2771.5030638152725
R13653 n_15_21_0 n_15_22_0 142.8571689683754
R13654 n_15_21_0 n_15_21_1 16499.996984152138
R13655 n_15_21_1 n_16_21_1 3880.10428934138
R13656 n_15_21_1 n_15_22_1 200.00003655572556
R13657 n_15_21_1 n_15_21_2 37499.99314580031
R13658 n_15_21_2 n_16_21_2 6928.757659538181
R13659 n_15_21_2 n_15_22_2 357.14292242093853
R13660 n_15_21_2 n_15_21_3 35099.99358446909
R13661 n_15_21_3 n_16_21_3 97002.60723353442
R13662 n_15_21_3 n_15_22_3 5000.000913893135
R13663 n_15_21_3 n_15_21_4 466.66658136996
R13664 n_15_21_4 n_16_21_4 2939.47294647074
R13665 n_15_21_4 n_15_22_4 151.5151792088829
R13666 n_15_21_15 n_16_21_15 194005.21446706713
R13667 n_15_21_15 n_15_22_15 10000.001827786182
R13668 n_15_22_0 n_16_22_0 2771.503063815469
R13669 n_15_22_0 n_15_23_0 142.8571689683754
R13670 n_15_22_0 n_15_22_1 16499.99698415331
R13671 n_15_22_1 n_16_22_1 3880.1042893416566
R13672 n_15_22_1 n_15_23_1 200.00003655572556
R13673 n_15_22_1 n_15_22_2 37499.99314580298
R13674 n_15_22_2 n_16_22_2 6928.757659538673
R13675 n_15_22_2 n_15_23_2 357.14292242093853
R13676 n_15_22_2 n_15_22_3 35099.99358447159
R13677 n_15_22_3 n_16_22_3 97002.60723354133
R13678 n_15_22_3 n_15_23_3 5000.000913893135
R13679 n_15_22_3 n_15_22_4 466.66658136999297
R13680 n_15_22_4 n_16_22_4 2939.472946470949
R13681 n_15_22_4 n_15_23_4 151.5151792088829
R13682 n_15_22_15 n_16_22_15 194005.21446708092
R13683 n_15_22_15 n_15_23_15 10000.001827786182
R13684 n_15_23_0 n_16_23_0 2771.5030638152725
R13685 n_15_23_0 n_15_24_0 1646.678571428551
R13686 n_15_23_0 n_15_23_1 16499.996984152138
R13687 n_15_23_1 n_16_23_1 3880.10428934138
R13688 n_15_23_1 n_15_24_1 2305.3499999999717
R13689 n_15_23_1 n_15_23_2 37499.99314580031
R13690 n_15_23_2 n_16_23_2 6928.757659538181
R13691 n_15_23_2 n_15_24_2 4116.696428571378
R13692 n_15_23_2 n_15_23_3 35099.99358446909
R13693 n_15_23_3 n_16_23_3 97002.60723353442
R13694 n_15_23_3 n_15_24_3 57633.749999999236
R13695 n_15_23_3 n_15_23_4 466.66658136996
R13696 n_15_23_4 n_16_23_4 2939.47294647074
R13697 n_15_23_4 n_15_24_4 1746.4772727272498
R13698 n_15_23_15 n_16_23_15 194005.21446706713
R13699 n_15_23_15 n_15_24_15 115267.49999999745
R13700 n_15_24_0 n_16_24_0 125.67182503262799
R13701 n_15_24_0 n_15_25_0 3150.499973888717
R13702 n_15_24_0 n_15_24_1 748.1805671095831
R13703 n_15_24_1 n_16_24_1 175.94055504567916
R13704 n_15_24_1 n_15_25_1 4410.699963444204
R13705 n_15_24_1 n_15_24_2 1700.410379794507
R13706 n_15_24_2 n_16_24_2 314.17956258157
R13707 n_15_24_2 n_15_25_2 7876.249934721793
R13708 n_15_24_2 n_15_24_3 1591.5841154876584
R13709 n_15_24_3 n_16_24_3 4398.513876141976
R13710 n_15_24_3 n_15_25_3 110267.49908610499
R13711 n_15_24_3 n_15_24_4 21.16066250410944
R13712 n_15_24_4 n_16_24_4 133.28829927702958
R13713 n_15_24_4 n_15_25_4 3341.439366245606
R13714 n_15_24_4 n_15_24_5 17.48993533502923
R13715 n_15_24_5 n_16_24_5 837.8121668841859
R13716 n_15_24_5 n_15_25_5 21003.33315925809
R13717 n_15_24_5 n_15_24_6 6.045903572602696
R13718 n_15_24_6 n_16_24_6 139.6353611473643
R13719 n_15_24_6 n_15_25_6 3500.5555265430157
R13720 n_15_24_6 n_15_24_7 8.20515484853222
R13721 n_15_24_7 n_16_24_7 239.37490482405383
R13722 n_15_24_7 n_15_25_7 6000.952331216617
R13723 n_15_24_7 n_15_24_8 6.045903572602677
R13724 n_15_24_8 n_16_24_8 239.37490482405383
R13725 n_15_24_8 n_15_25_8 6000.952331216617
R13726 n_15_24_8 n_15_24_9 6.045903572602677
R13727 n_15_24_9 n_16_24_9 239.37490482405383
R13728 n_15_24_9 n_15_25_9 6000.952331216617
R13729 n_15_24_9 n_15_24_10 6.045903572602677
R13730 n_15_24_10 n_16_24_10 239.37490482405383
R13731 n_15_24_10 n_15_25_10 6000.952331216617
R13732 n_15_24_10 n_15_24_11 6.045903572602638
R13733 n_15_24_11 n_16_24_11 239.3749048240569
R13734 n_15_24_11 n_15_25_11 6000.952331216693
R13735 n_15_24_11 n_15_24_12 6.045903572602619
R13736 n_15_24_12 n_16_24_12 239.37490482405536
R13737 n_15_24_12 n_15_25_12 6000.952331216655
R13738 n_15_24_12 n_15_24_13 6.045903572602677
R13739 n_15_24_13 n_16_24_13 239.37490482405235
R13740 n_15_24_13 n_15_25_13 6000.952331216578
R13741 n_15_24_13 n_15_24_14 30.229517863013463
R13742 n_15_24_14 n_16_24_14 26.597211647117035
R13743 n_15_24_14 n_15_25_14 666.7724812462893
R13744 n_15_24_14 n_15_24_15 934.0921019671247
R13745 n_15_24_15 n_16_24_15 8797.027752283871
R13746 n_15_24_15 n_15_25_15 220534.99817220803
R13747 n_15_25_0 n_16_25_0 125.6718250326284
R13748 n_15_25_0 n_15_26_0 3150.499973888717
R13749 n_15_25_0 n_15_25_1 748.1805671095855
R13750 n_15_25_1 n_16_25_1 175.94055504567976
R13751 n_15_25_1 n_15_26_1 4410.699963444204
R13752 n_15_25_1 n_15_25_2 1700.4103797945122
R13753 n_15_25_2 n_16_25_2 314.179562581571
R13754 n_15_25_2 n_15_26_2 7876.249934721793
R13755 n_15_25_2 n_15_25_3 1591.5841154876634
R13756 n_15_25_3 n_16_25_3 4398.51387614199
R13757 n_15_25_3 n_15_26_3 110267.49908610499
R13758 n_15_25_3 n_15_25_4 21.160662504109506
R13759 n_15_25_4 n_16_25_4 133.28829927703
R13760 n_15_25_4 n_15_26_4 3341.439366245606
R13761 n_15_25_4 n_15_25_5 17.489935335029287
R13762 n_15_25_5 n_16_25_5 837.8121668841885
R13763 n_15_25_5 n_15_26_5 21003.33315925809
R13764 n_15_25_5 n_15_25_6 6.0459035726027155
R13765 n_15_25_6 n_16_25_6 139.63536114736476
R13766 n_15_25_6 n_15_26_6 3500.5555265430157
R13767 n_15_25_6 n_15_25_7 8.205154848532247
R13768 n_15_25_7 n_16_25_7 239.37490482405465
R13769 n_15_25_7 n_15_26_7 6000.952331216617
R13770 n_15_25_7 n_15_25_8 6.045903572602697
R13771 n_15_25_8 n_16_25_8 239.37490482405465
R13772 n_15_25_8 n_15_26_8 6000.952331216617
R13773 n_15_25_8 n_15_25_9 6.045903572602697
R13774 n_15_25_9 n_16_25_9 239.37490482405465
R13775 n_15_25_9 n_15_26_9 6000.952331216617
R13776 n_15_25_9 n_15_25_10 6.045903572602697
R13777 n_15_25_10 n_16_25_10 239.37490482405465
R13778 n_15_25_10 n_15_26_10 6000.952331216617
R13779 n_15_25_10 n_15_25_11 6.045903572602658
R13780 n_15_25_11 n_16_25_11 239.3749048240577
R13781 n_15_25_11 n_15_26_11 6000.952331216693
R13782 n_15_25_11 n_15_25_12 6.045903572602638
R13783 n_15_25_12 n_16_25_12 239.37490482405607
R13784 n_15_25_12 n_15_26_12 6000.952331216655
R13785 n_15_25_12 n_15_25_13 6.045903572602697
R13786 n_15_25_13 n_16_25_13 239.37490482405312
R13787 n_15_25_13 n_15_26_13 6000.952331216578
R13788 n_15_25_13 n_15_25_14 30.22951786301356
R13789 n_15_25_14 n_16_25_14 26.59721164711712
R13790 n_15_25_14 n_15_26_14 666.7724812462893
R13791 n_15_25_14 n_15_25_15 934.0921019671276
R13792 n_15_25_15 n_16_25_15 8797.027752283902
R13793 n_15_25_15 n_15_26_15 220534.99817220803
R13794 n_15_26_0 n_16_26_0 125.67182503262799
R13795 n_15_26_0 n_15_27_0 3150.499973888722
R13796 n_15_26_0 n_15_26_1 748.1805671095831
R13797 n_15_26_1 n_16_26_1 175.94055504567916
R13798 n_15_26_1 n_15_27_1 4410.699963444211
R13799 n_15_26_1 n_15_26_2 1700.410379794507
R13800 n_15_26_2 n_16_26_2 314.17956258157
R13801 n_15_26_2 n_15_27_2 7876.249934721805
R13802 n_15_26_2 n_15_26_3 1591.5841154876584
R13803 n_15_26_3 n_16_26_3 4398.513876141976
R13804 n_15_26_3 n_15_27_3 110267.49908610516
R13805 n_15_26_3 n_15_26_4 21.16066250410944
R13806 n_15_26_4 n_16_26_4 133.28829927702958
R13807 n_15_26_4 n_15_27_4 3341.4393662456114
R13808 n_15_26_4 n_15_26_5 17.48993533502923
R13809 n_15_26_5 n_16_26_5 837.8121668841859
R13810 n_15_26_5 n_15_27_5 21003.333159258123
R13811 n_15_26_5 n_15_26_6 6.045903572602696
R13812 n_15_26_6 n_16_26_6 139.6353611473643
R13813 n_15_26_6 n_15_27_6 3500.555526543021
R13814 n_15_26_6 n_15_26_7 8.20515484853222
R13815 n_15_26_7 n_16_26_7 239.37490482405383
R13816 n_15_26_7 n_15_27_7 6000.952331216627
R13817 n_15_26_7 n_15_26_8 6.045903572602677
R13818 n_15_26_8 n_16_26_8 239.37490482405383
R13819 n_15_26_8 n_15_27_8 6000.952331216627
R13820 n_15_26_8 n_15_26_9 6.045903572602677
R13821 n_15_26_9 n_16_26_9 239.37490482405383
R13822 n_15_26_9 n_15_27_9 6000.952331216627
R13823 n_15_26_9 n_15_26_10 6.045903572602677
R13824 n_15_26_10 n_16_26_10 239.37490482405383
R13825 n_15_26_10 n_15_27_10 6000.952331216627
R13826 n_15_26_10 n_15_26_11 6.045903572602638
R13827 n_15_26_11 n_16_26_11 239.3749048240569
R13828 n_15_26_11 n_15_27_11 6000.952331216702
R13829 n_15_26_11 n_15_26_12 6.045903572602619
R13830 n_15_26_12 n_16_26_12 239.37490482405536
R13831 n_15_26_12 n_15_27_12 6000.952331216665
R13832 n_15_26_12 n_15_26_13 6.045903572602677
R13833 n_15_26_13 n_16_26_13 239.37490482405235
R13834 n_15_26_13 n_15_27_13 6000.952331216588
R13835 n_15_26_13 n_15_26_14 30.229517863013463
R13836 n_15_26_14 n_16_26_14 26.597211647117035
R13837 n_15_26_14 n_15_27_14 666.7724812462903
R13838 n_15_26_14 n_15_26_15 934.0921019671247
R13839 n_15_26_15 n_16_26_15 8797.027752283871
R13840 n_15_26_15 n_15_27_15 220534.99817220838
R13841 n_15_27_0 n_16_27_0 125.67182503262799
R13842 n_15_27_0 n_15_27_1 748.1805671095831
R13843 n_15_27_1 n_16_27_1 175.94055504567916
R13844 n_15_27_1 n_15_27_2 1700.410379794507
R13845 n_15_27_2 n_16_27_2 314.17956258157
R13846 n_15_27_2 n_15_27_3 1591.5841154876584
R13847 n_15_27_3 n_16_27_3 4398.513876141976
R13848 n_15_27_3 n_15_27_4 21.16066250410944
R13849 n_15_27_4 n_16_27_4 133.28829927702958
R13850 n_15_27_4 n_15_27_5 17.48993533502923
R13851 n_15_27_5 n_16_27_5 837.8121668841859
R13852 n_15_27_5 n_15_27_6 6.045903572602696
R13853 n_15_27_6 n_16_27_6 139.6353611473643
R13854 n_15_27_6 n_15_27_7 8.20515484853222
R13855 n_15_27_7 n_16_27_7 239.37490482405383
R13856 n_15_27_7 n_15_27_8 6.045903572602677
R13857 n_15_27_8 n_16_27_8 239.37490482405383
R13858 n_15_27_8 n_15_27_9 6.045903572602677
R13859 n_15_27_9 n_16_27_9 239.37490482405383
R13860 n_15_27_9 n_15_27_10 6.045903572602677
R13861 n_15_27_10 n_16_27_10 239.37490482405383
R13862 n_15_27_10 n_15_27_11 6.045903572602638
R13863 n_15_27_11 n_16_27_11 239.3749048240569
R13864 n_15_27_11 n_15_27_12 6.045903572602619
R13865 n_15_27_12 n_16_27_12 239.37490482405536
R13866 n_15_27_12 n_15_27_13 6.045903572602677
R13867 n_15_27_13 n_16_27_13 239.37490482405235
R13868 n_15_27_13 n_15_27_14 30.229517863013463
R13869 n_15_27_14 n_16_27_14 26.597211647117035
R13870 n_15_27_14 n_15_27_15 934.0921019671247
R13871 n_15_27_15 n_16_27_15 8797.027752283871
R13872 n_16_0_0 n_17_0_0 244.86587514965555
R13873 n_16_0_0 n_16_1_0 83.34425224761593
R13874 n_16_0_0 n_16_0_1 19.792585205041586
R13875 n_16_0_1 n_17_0_1 342.8122252095177
R13876 n_16_0_1 n_16_1_1 116.6819531466623
R13877 n_16_0_1 n_16_0_2 44.98314819327633
R13878 n_16_0_2 n_17_0_2 612.1646878741388
R13879 n_16_0_2 n_16_1_2 208.3606306190398
R13880 n_16_0_2 n_16_0_3 42.104226708906644
R13881 n_16_0_3 n_17_0_3 8570.305630237934
R13882 n_16_0_3 n_16_1_3 2917.048828666555
R13883 n_16_0_3 n_16_0_4 0.5597902886274392
R13884 n_16_0_4 n_17_0_4 259.70623121933136
R13885 n_16_0_4 n_16_1_4 88.39541905050166
R13886 n_16_0_4 n_16_0_5 0.4626838099879854
R13887 n_16_0_5 n_17_0_5 1632.4391676643686
R13888 n_16_0_5 n_16_1_5 555.6283483174391
R13889 n_16_0_5 n_16_0_6 0.15994008246498265
R13890 n_16_0_6 n_17_0_6 272.07319461072814
R13891 n_16_0_6 n_16_1_6 92.60472471957317
R13892 n_16_0_6 n_16_0_7 0.21706154048819049
R13893 n_16_0_7 n_17_0_7 466.41119076124966
R13894 n_16_0_7 n_16_1_7 158.75095666212593
R13895 n_16_0_7 n_16_0_8 0.15994008246498215
R13896 n_16_0_8 n_17_0_8 466.41119076124966
R13897 n_16_0_8 n_16_1_8 158.75095666212593
R13898 n_16_0_8 n_16_0_9 0.15994008246498215
R13899 n_16_0_9 n_17_0_9 466.41119076124966
R13900 n_16_0_9 n_16_1_9 158.75095666212593
R13901 n_16_0_9 n_16_0_10 0.15994008246498215
R13902 n_16_0_10 n_17_0_10 466.41119076124966
R13903 n_16_0_10 n_16_1_10 158.75095666212593
R13904 n_16_0_10 n_16_0_11 0.15994008246498112
R13905 n_16_0_11 n_17_0_11 466.4111907612556
R13906 n_16_0_11 n_16_1_11 158.75095666212795
R13907 n_16_0_11 n_16_0_12 0.1599400824649806
R13908 n_16_0_12 n_17_0_12 466.4111907612528
R13909 n_16_0_12 n_16_1_12 158.7509566621269
R13910 n_16_0_12 n_16_0_13 0.15994008246498215
R13911 n_16_0_13 n_17_0_13 466.41119076124676
R13912 n_16_0_13 n_16_1_13 158.75095666212493
R13913 n_16_0_13 n_16_0_14 0.7997004123249127
R13914 n_16_0_14 n_17_0_14 51.82346564013874
R13915 n_16_0_14 n_16_1_14 17.638995184680617
R13916 n_16_0_14 n_16_0_15 24.710742740840033
R13917 n_16_0_15 n_17_0_15 17140.61126047572
R13918 n_16_0_15 n_16_1_15 5834.097657333058
R13919 n_16_1_0 n_17_1_0 244.86587514965555
R13920 n_16_1_0 n_16_2_0 83.34425224761593
R13921 n_16_1_0 n_16_1_1 19.792585205041586
R13922 n_16_1_1 n_17_1_1 342.8122252095177
R13923 n_16_1_1 n_16_2_1 116.6819531466623
R13924 n_16_1_1 n_16_1_2 44.98314819327633
R13925 n_16_1_2 n_17_1_2 612.1646878741388
R13926 n_16_1_2 n_16_2_2 208.3606306190398
R13927 n_16_1_2 n_16_1_3 42.104226708906644
R13928 n_16_1_3 n_17_1_3 8570.305630237934
R13929 n_16_1_3 n_16_2_3 2917.048828666555
R13930 n_16_1_3 n_16_1_4 0.5597902886274392
R13931 n_16_1_4 n_17_1_4 259.70623121933136
R13932 n_16_1_4 n_16_2_4 88.39541905050166
R13933 n_16_1_4 n_16_1_5 0.4626838099879854
R13934 n_16_1_5 n_17_1_5 1632.4391676643686
R13935 n_16_1_5 n_16_2_5 555.6283483174391
R13936 n_16_1_5 n_16_1_6 0.15994008246498265
R13937 n_16_1_6 n_17_1_6 272.07319461072814
R13938 n_16_1_6 n_16_2_6 92.60472471957317
R13939 n_16_1_6 n_16_1_7 0.21706154048819049
R13940 n_16_1_7 n_17_1_7 466.41119076124966
R13941 n_16_1_7 n_16_2_7 158.75095666212593
R13942 n_16_1_7 n_16_1_8 0.15994008246498215
R13943 n_16_1_8 n_17_1_8 466.41119076124966
R13944 n_16_1_8 n_16_2_8 158.75095666212593
R13945 n_16_1_8 n_16_1_9 0.15994008246498215
R13946 n_16_1_9 n_17_1_9 466.41119076124966
R13947 n_16_1_9 n_16_2_9 158.75095666212593
R13948 n_16_1_9 n_16_1_10 0.15994008246498215
R13949 n_16_1_10 n_17_1_10 466.41119076124966
R13950 n_16_1_10 n_16_2_10 158.75095666212593
R13951 n_16_1_10 n_16_1_11 0.15994008246498112
R13952 n_16_1_11 n_17_1_11 466.4111907612556
R13953 n_16_1_11 n_16_2_11 158.75095666212795
R13954 n_16_1_11 n_16_1_12 0.1599400824649806
R13955 n_16_1_12 n_17_1_12 466.4111907612528
R13956 n_16_1_12 n_16_2_12 158.7509566621269
R13957 n_16_1_12 n_16_1_13 0.15994008246498215
R13958 n_16_1_13 n_17_1_13 466.41119076124676
R13959 n_16_1_13 n_16_2_13 158.75095666212493
R13960 n_16_1_13 n_16_1_14 0.7997004123249127
R13961 n_16_1_14 n_17_1_14 51.82346564013874
R13962 n_16_1_14 n_16_2_14 17.638995184680617
R13963 n_16_1_14 n_16_1_15 24.710742740840033
R13964 n_16_1_15 n_17_1_15 17140.61126047572
R13965 n_16_1_15 n_16_2_15 5834.097657333058
R13966 n_16_2_0 n_17_2_0 244.86587514965555
R13967 n_16_2_0 n_16_3_0 83.34425224761593
R13968 n_16_2_0 n_16_2_1 19.792585205041586
R13969 n_16_2_1 n_17_2_1 342.8122252095177
R13970 n_16_2_1 n_16_3_1 116.6819531466623
R13971 n_16_2_1 n_16_2_2 44.98314819327633
R13972 n_16_2_2 n_17_2_2 612.1646878741388
R13973 n_16_2_2 n_16_3_2 208.3606306190398
R13974 n_16_2_2 n_16_2_3 42.104226708906644
R13975 n_16_2_3 n_17_2_3 8570.305630237934
R13976 n_16_2_3 n_16_3_3 2917.048828666555
R13977 n_16_2_3 n_16_2_4 0.5597902886274392
R13978 n_16_2_4 n_17_2_4 259.70623121933136
R13979 n_16_2_4 n_16_3_4 88.39541905050166
R13980 n_16_2_4 n_16_2_5 0.4626838099879854
R13981 n_16_2_5 n_17_2_5 1632.4391676643686
R13982 n_16_2_5 n_16_3_5 555.6283483174391
R13983 n_16_2_5 n_16_2_6 0.15994008246498265
R13984 n_16_2_6 n_17_2_6 272.07319461072814
R13985 n_16_2_6 n_16_3_6 92.60472471957317
R13986 n_16_2_6 n_16_2_7 0.21706154048819049
R13987 n_16_2_7 n_17_2_7 466.41119076124966
R13988 n_16_2_7 n_16_3_7 158.75095666212593
R13989 n_16_2_7 n_16_2_8 0.15994008246498215
R13990 n_16_2_8 n_17_2_8 466.41119076124966
R13991 n_16_2_8 n_16_3_8 158.75095666212593
R13992 n_16_2_8 n_16_2_9 0.15994008246498215
R13993 n_16_2_9 n_17_2_9 466.41119076124966
R13994 n_16_2_9 n_16_3_9 158.75095666212593
R13995 n_16_2_9 n_16_2_10 0.15994008246498215
R13996 n_16_2_10 n_17_2_10 466.41119076124966
R13997 n_16_2_10 n_16_3_10 158.75095666212593
R13998 n_16_2_10 n_16_2_11 0.15994008246498112
R13999 n_16_2_11 n_17_2_11 466.4111907612556
R14000 n_16_2_11 n_16_3_11 158.75095666212795
R14001 n_16_2_11 n_16_2_12 0.1599400824649806
R14002 n_16_2_12 n_17_2_12 466.4111907612528
R14003 n_16_2_12 n_16_3_12 158.7509566621269
R14004 n_16_2_12 n_16_2_13 0.15994008246498215
R14005 n_16_2_13 n_17_2_13 466.41119076124676
R14006 n_16_2_13 n_16_3_13 158.75095666212493
R14007 n_16_2_13 n_16_2_14 0.7997004123249127
R14008 n_16_2_14 n_17_2_14 51.82346564013874
R14009 n_16_2_14 n_16_3_14 17.638995184680617
R14010 n_16_2_14 n_16_2_15 24.710742740840033
R14011 n_16_2_15 n_17_2_15 17140.61126047572
R14012 n_16_2_15 n_16_3_15 5834.097657333058
R14013 n_16_3_0 n_17_3_0 244.86587514965555
R14014 n_16_3_0 n_16_4_0 43.561715139230984
R14015 n_16_3_0 n_16_3_1 19.792585205041586
R14016 n_16_3_1 n_17_3_1 342.8122252095177
R14017 n_16_3_1 n_16_4_1 60.986401194923374
R14018 n_16_3_1 n_16_3_2 44.98314819327633
R14019 n_16_3_2 n_17_3_2 612.1646878741388
R14020 n_16_3_2 n_16_4_2 108.90428784807744
R14021 n_16_3_2 n_16_3_3 42.104226708906644
R14022 n_16_3_3 n_17_3_3 8570.305630237934
R14023 n_16_3_3 n_16_4_3 1524.6600298730832
R14024 n_16_3_3 n_16_3_4 0.5597902886274392
R14025 n_16_3_4 n_17_3_4 259.70623121933136
R14026 n_16_3_4 n_16_4_4 46.20181908706312
R14027 n_16_3_4 n_16_3_5 0.4626838099879854
R14028 n_16_3_5 n_17_3_5 1632.4391676643686
R14029 n_16_3_5 n_16_3_6 0.15994008246498265
R14030 n_16_3_6 n_17_3_6 272.07319461072814
R14031 n_16_3_6 n_16_3_7 0.21706154048819049
R14032 n_16_3_7 n_17_3_7 466.41119076124966
R14033 n_16_3_7 n_16_3_8 0.15994008246498215
R14034 n_16_3_8 n_17_3_8 466.41119076124966
R14035 n_16_3_8 n_16_3_9 0.15994008246498215
R14036 n_16_3_9 n_17_3_9 466.41119076124966
R14037 n_16_3_9 n_16_3_10 0.15994008246498215
R14038 n_16_3_10 n_17_3_10 466.41119076124966
R14039 n_16_3_10 n_16_3_11 0.15994008246498112
R14040 n_16_3_11 n_17_3_11 466.4111907612556
R14041 n_16_3_11 n_16_3_12 0.1599400824649806
R14042 n_16_3_12 n_17_3_12 466.4111907612528
R14043 n_16_3_12 n_16_3_13 0.15994008246498215
R14044 n_16_3_13 n_17_3_13 466.41119076124676
R14045 n_16_3_13 n_16_3_14 0.7997004123249127
R14046 n_16_3_14 n_17_3_14 51.82346564013874
R14047 n_16_3_14 n_16_3_15 24.710742740840033
R14048 n_16_3_15 n_17_3_15 17140.61126047572
R14049 n_16_3_15 n_16_4_15 3049.320059746139
R14050 n_16_4_0 n_17_4_0 5400.159267103214
R14051 n_16_4_0 n_16_5_0 3.779178030846073
R14052 n_16_4_0 n_16_4_1 436.49656102391225
R14053 n_16_4_1 n_17_4_1 7560.222973944499
R14054 n_16_4_1 n_16_5_1 5.290849243184502
R14055 n_16_4_1 n_16_4_2 992.0376386907095
R14056 n_16_4_2 n_17_4_2 13500.398167758036
R14057 n_16_4_2 n_16_5_2 9.447945077115182
R14058 n_16_4_2 n_16_4_3 928.547229814504
R14059 n_16_4_3 n_17_4_3 189005.57434861234
R14060 n_16_4_3 n_16_5_3 132.27123107961245
R14061 n_16_4_3 n_16_4_4 12.345357281484397
R14062 n_16_4_4 n_17_4_4 5727.441646927647
R14063 n_16_4_4 n_16_5_4 4.008219123624619
R14064 n_16_4_15 n_17_4_15 378011.1486972213
R14065 n_16_4_15 n_16_5_15 264.5424621592225
R14066 n_16_5_0 n_17_5_0 5400.159267103119
R14067 n_16_5_0 n_16_6_0 3.7791780308461065
R14068 n_16_5_0 n_16_5_1 436.49656102390446
R14069 n_16_5_1 n_17_5_1 7560.222973944365
R14070 n_16_5_1 n_16_6_1 5.290849243184549
R14071 n_16_5_1 n_16_5_2 992.0376386906918
R14072 n_16_5_2 n_17_5_2 13500.398167757798
R14073 n_16_5_2 n_16_6_2 9.447945077115266
R14074 n_16_5_2 n_16_5_3 928.5472298144875
R14075 n_16_5_3 n_17_5_3 189005.57434860896
R14076 n_16_5_3 n_16_6_3 132.2712310796136
R14077 n_16_5_3 n_16_5_4 12.345357281484178
R14078 n_16_5_4 n_17_5_4 5727.441646927545
R14079 n_16_5_4 n_16_6_4 4.008219123624655
R14080 n_16_5_15 n_17_5_15 378011.14869721455
R14081 n_16_5_15 n_16_6_15 264.5424621592249
R14082 n_16_6_0 n_17_6_0 5400.159267103119
R14083 n_16_6_0 n_16_7_0 3.779178030846073
R14084 n_16_6_0 n_16_6_1 436.49656102390446
R14085 n_16_6_1 n_17_6_1 7560.222973944365
R14086 n_16_6_1 n_16_7_1 5.290849243184502
R14087 n_16_6_1 n_16_6_2 992.0376386906918
R14088 n_16_6_2 n_17_6_2 13500.398167757798
R14089 n_16_6_2 n_16_7_2 9.447945077115182
R14090 n_16_6_2 n_16_6_3 928.5472298144875
R14091 n_16_6_3 n_17_6_3 189005.57434860896
R14092 n_16_6_3 n_16_7_3 132.27123107961245
R14093 n_16_6_3 n_16_6_4 12.345357281484178
R14094 n_16_6_4 n_17_6_4 5727.441646927545
R14095 n_16_6_4 n_16_7_4 4.008219123624619
R14096 n_16_6_15 n_17_6_15 378011.14869721455
R14097 n_16_6_15 n_16_7_15 264.5424621592225
R14098 n_16_7_0 n_17_7_0 5400.159267103214
R14099 n_16_7_0 n_16_8_0 110.44365038628528
R14100 n_16_7_0 n_16_7_1 436.49656102391225
R14101 n_16_7_1 n_17_7_1 7560.222973944499
R14102 n_16_7_1 n_16_8_1 154.62111054079944
R14103 n_16_7_1 n_16_7_2 992.0376386907095
R14104 n_16_7_2 n_17_7_2 13500.398167758036
R14105 n_16_7_2 n_16_8_2 276.10912596571325
R14106 n_16_7_2 n_16_7_3 928.547229814504
R14107 n_16_7_3 n_17_7_3 189005.57434861234
R14108 n_16_7_3 n_16_8_3 3865.5277635199823
R14109 n_16_7_3 n_16_7_4 12.345357281484397
R14110 n_16_7_4 n_17_7_4 5727.441646927647
R14111 n_16_7_4 n_16_8_4 117.13720495515096
R14112 n_16_7_15 n_17_7_15 378011.1486972213
R14113 n_16_7_15 n_16_8_15 7731.055527039895
R14114 n_16_8_0 n_17_8_0 93.99999874525199
R14115 n_16_8_0 n_16_9_0 217.10812274172463
R14116 n_16_8_0 n_16_8_1 7.598049272084611
R14117 n_16_8_1 n_17_8_1 131.59999824335273
R14118 n_16_8_1 n_16_9_1 303.9513718384145
R14119 n_16_8_1 n_16_8_2 17.268293800192296
R14120 n_16_8_2 n_17_8_2 234.99999686312992
R14121 n_16_8_2 n_16_9_2 542.7703068543115
R14122 n_16_8_2 n_16_8_3 16.16312299697999
R14123 n_16_8_3 n_17_8_3 3289.999956083816
R14124 n_16_8_3 n_16_9_3 7598.784295960355
R14125 n_16_8_3 n_16_8_4 0.2148943228468377
R14126 n_16_8_4 n_17_8_4 99.69696836617626
R14127 n_16_8_4 n_16_9_4 230.26619078667744
R14128 n_16_8_4 n_16_8_5 0.2148943228468377
R14129 n_16_8_5 n_17_8_5 3289.999956083816
R14130 n_16_8_5 n_16_9_5 7598.784295960355
R14131 n_16_8_5 n_16_8_6 0.4144390512046156
R14132 n_16_8_6 n_17_8_6 731.1111013519591
R14133 n_16_8_6 n_16_9_6 1688.6187324356342
R14134 n_16_8_6 n_16_8_7 0.5832845905842732
R14135 n_16_8_7 n_17_8_7 1253.3333166033626
R14136 n_16_8_7 n_16_9_7 2894.774969889668
R14137 n_16_8_7 n_16_8_8 0.4297886456936741
R14138 n_16_8_8 n_17_8_8 1253.3333166033626
R14139 n_16_8_8 n_16_9_8 2894.774969889668
R14140 n_16_8_8 n_16_8_9 0.4297886456936741
R14141 n_16_8_9 n_17_8_9 1253.3333166033626
R14142 n_16_8_9 n_16_9_9 2894.774969889668
R14143 n_16_8_9 n_16_8_10 0.4297886456936741
R14144 n_16_8_10 n_17_8_10 1253.3333166033626
R14145 n_16_8_10 n_16_9_10 2894.774969889668
R14146 n_16_8_10 n_16_8_11 0.42978864569367137
R14147 n_16_8_11 n_17_8_11 1253.3333166033783
R14148 n_16_8_11 n_16_9_11 2894.774969889705
R14149 n_16_8_11 n_16_8_12 0.4297886456936699
R14150 n_16_8_12 n_17_8_12 1253.3333166033703
R14151 n_16_8_12 n_16_9_12 2894.7749698896864
R14152 n_16_8_12 n_16_8_13 0.42978864569367403
R14153 n_16_8_13 n_17_8_13 1253.3333166033544
R14154 n_16_8_13 n_16_9_13 2894.77496988965
R14155 n_16_8_13 n_16_8_14 2.148943228468376
R14156 n_16_8_14 n_17_8_14 139.25925740037331
R14157 n_16_8_14 n_16_9_14 321.64166332107345
R14158 n_16_8_14 n_16_8_15 11.14380559905752
R14159 n_16_8_15 n_17_8_15 6579.999912167574
R14160 n_16_8_15 n_16_9_15 15197.568591920575
R14161 n_16_9_0 n_17_9_0 93.9999987452519
R14162 n_16_9_0 n_16_10_0 217.10812274172463
R14163 n_16_9_0 n_16_9_1 7.598049272084607
R14164 n_16_9_1 n_17_9_1 131.59999824335267
R14165 n_16_9_1 n_16_10_1 303.9513718384145
R14166 n_16_9_1 n_16_9_2 17.268293800192286
R14167 n_16_9_2 n_17_9_2 234.99999686312978
R14168 n_16_9_2 n_16_10_2 542.7703068543115
R14169 n_16_9_2 n_16_9_3 16.16312299697998
R14170 n_16_9_3 n_17_9_3 3289.999956083814
R14171 n_16_9_3 n_16_10_3 7598.784295960355
R14172 n_16_9_3 n_16_9_4 0.21489432284683754
R14173 n_16_9_4 n_17_9_4 99.69696836617618
R14174 n_16_9_4 n_16_10_4 230.26619078667744
R14175 n_16_9_4 n_16_9_5 0.21489432284683754
R14176 n_16_9_5 n_17_9_5 3289.999956083814
R14177 n_16_9_5 n_16_10_5 7598.784295960355
R14178 n_16_9_5 n_16_9_6 0.41443905120461527
R14179 n_16_9_6 n_17_9_6 731.1111013519586
R14180 n_16_9_6 n_16_10_6 1688.6187324356342
R14181 n_16_9_6 n_16_9_7 0.5832845905842726
R14182 n_16_9_7 n_17_9_7 1253.3333166033615
R14183 n_16_9_7 n_16_10_7 2894.774969889668
R14184 n_16_9_7 n_16_9_8 0.4297886456936737
R14185 n_16_9_8 n_17_9_8 1253.3333166033615
R14186 n_16_9_8 n_16_10_8 2894.774969889668
R14187 n_16_9_8 n_16_9_9 0.4297886456936737
R14188 n_16_9_9 n_17_9_9 1253.3333166033615
R14189 n_16_9_9 n_16_10_9 2894.774969889668
R14190 n_16_9_9 n_16_9_10 0.4297886456936737
R14191 n_16_9_10 n_17_9_10 1253.3333166033615
R14192 n_16_9_10 n_16_10_10 2894.774969889668
R14193 n_16_9_10 n_16_9_11 0.429788645693671
R14194 n_16_9_11 n_17_9_11 1253.3333166033776
R14195 n_16_9_11 n_16_10_11 2894.774969889705
R14196 n_16_9_11 n_16_9_12 0.4297886456936696
R14197 n_16_9_12 n_17_9_12 1253.3333166033697
R14198 n_16_9_12 n_16_10_12 2894.7749698896864
R14199 n_16_9_12 n_16_9_13 0.4297886456936737
R14200 n_16_9_13 n_17_9_13 1253.3333166033535
R14201 n_16_9_13 n_16_10_13 2894.77496988965
R14202 n_16_9_13 n_16_9_14 2.148943228468374
R14203 n_16_9_14 n_17_9_14 139.2592574003732
R14204 n_16_9_14 n_16_10_14 321.64166332107345
R14205 n_16_9_14 n_16_9_15 11.143805599057513
R14206 n_16_9_15 n_17_9_15 6579.99991216757
R14207 n_16_9_15 n_16_10_15 15197.568591920575
R14208 n_16_10_0 n_17_10_0 93.99999874525199
R14209 n_16_10_0 n_16_11_0 217.10812274172454
R14210 n_16_10_0 n_16_10_1 7.598049272084611
R14211 n_16_10_1 n_17_10_1 131.59999824335273
R14212 n_16_10_1 n_16_11_1 303.9513718384144
R14213 n_16_10_1 n_16_10_2 17.268293800192296
R14214 n_16_10_2 n_17_10_2 234.99999686312992
R14215 n_16_10_2 n_16_11_2 542.7703068543113
R14216 n_16_10_2 n_16_10_3 16.16312299697999
R14217 n_16_10_3 n_17_10_3 3289.999956083816
R14218 n_16_10_3 n_16_11_3 7598.784295960353
R14219 n_16_10_3 n_16_10_4 0.2148943228468377
R14220 n_16_10_4 n_17_10_4 99.69696836617626
R14221 n_16_10_4 n_16_11_4 230.26619078667736
R14222 n_16_10_4 n_16_10_5 0.2148943228468377
R14223 n_16_10_5 n_17_10_5 3289.999956083816
R14224 n_16_10_5 n_16_11_5 7598.784295960353
R14225 n_16_10_5 n_16_10_6 0.4144390512046156
R14226 n_16_10_6 n_17_10_6 731.1111013519591
R14227 n_16_10_6 n_16_11_6 1688.6187324356338
R14228 n_16_10_6 n_16_10_7 0.5832845905842732
R14229 n_16_10_7 n_17_10_7 1253.3333166033626
R14230 n_16_10_7 n_16_11_7 2894.774969889667
R14231 n_16_10_7 n_16_10_8 0.4297886456936741
R14232 n_16_10_8 n_17_10_8 1253.3333166033626
R14233 n_16_10_8 n_16_11_8 2894.774969889667
R14234 n_16_10_8 n_16_10_9 0.4297886456936741
R14235 n_16_10_9 n_17_10_9 1253.3333166033626
R14236 n_16_10_9 n_16_11_9 2894.774969889667
R14237 n_16_10_9 n_16_10_10 0.4297886456936741
R14238 n_16_10_10 n_17_10_10 1253.3333166033626
R14239 n_16_10_10 n_16_11_10 2894.774969889667
R14240 n_16_10_10 n_16_10_11 0.42978864569367137
R14241 n_16_10_11 n_17_10_11 1253.3333166033783
R14242 n_16_10_11 n_16_11_11 2894.774969889704
R14243 n_16_10_11 n_16_10_12 0.4297886456936699
R14244 n_16_10_12 n_17_10_12 1253.3333166033703
R14245 n_16_10_12 n_16_11_12 2894.7749698896855
R14246 n_16_10_12 n_16_10_13 0.42978864569367403
R14247 n_16_10_13 n_17_10_13 1253.3333166033544
R14248 n_16_10_13 n_16_11_13 2894.774969889649
R14249 n_16_10_13 n_16_10_14 2.148943228468376
R14250 n_16_10_14 n_17_10_14 139.25925740037331
R14251 n_16_10_14 n_16_11_14 321.6416633210734
R14252 n_16_10_14 n_16_10_15 11.14380559905752
R14253 n_16_10_15 n_17_10_15 6579.999912167574
R14254 n_16_10_15 n_16_11_15 15197.56859192057
R14255 n_16_11_0 n_17_11_0 93.99999874525199
R14256 n_16_11_0 n_16_12_0 110.44365362970504
R14257 n_16_11_0 n_16_11_1 7.598049272084611
R14258 n_16_11_1 n_17_11_1 131.59999824335273
R14259 n_16_11_1 n_16_12_1 154.62111508158705
R14260 n_16_11_1 n_16_11_2 17.268293800192296
R14261 n_16_11_2 n_17_11_2 234.99999686312992
R14262 n_16_11_2 n_16_12_2 276.10913407426256
R14263 n_16_11_2 n_16_11_3 16.16312299697999
R14264 n_16_11_3 n_17_11_3 3289.999956083816
R14265 n_16_11_3 n_16_12_3 3865.527877039673
R14266 n_16_11_3 n_16_11_4 0.2148943228468377
R14267 n_16_11_4 n_17_11_4 99.69696836617626
R14268 n_16_11_4 n_16_12_4 117.13720839514161
R14269 n_16_11_4 n_16_11_5 0.2148943228468377
R14270 n_16_11_5 n_17_11_5 3289.999956083816
R14271 n_16_11_5 n_16_11_6 0.4144390512046156
R14272 n_16_11_6 n_17_11_6 731.1111013519591
R14273 n_16_11_6 n_16_11_7 0.5832845905842732
R14274 n_16_11_7 n_17_11_7 1253.3333166033626
R14275 n_16_11_7 n_16_11_8 0.4297886456936741
R14276 n_16_11_8 n_17_11_8 1253.3333166033626
R14277 n_16_11_8 n_16_11_9 0.4297886456936741
R14278 n_16_11_9 n_17_11_9 1253.3333166033626
R14279 n_16_11_9 n_16_11_10 0.4297886456936741
R14280 n_16_11_10 n_17_11_10 1253.3333166033626
R14281 n_16_11_10 n_16_11_11 0.42978864569367137
R14282 n_16_11_11 n_17_11_11 1253.3333166033783
R14283 n_16_11_11 n_16_11_12 0.4297886456936699
R14284 n_16_11_12 n_17_11_12 1253.3333166033703
R14285 n_16_11_12 n_16_11_13 0.42978864569367403
R14286 n_16_11_13 n_17_11_13 1253.3333166033544
R14287 n_16_11_13 n_16_11_14 2.148943228468376
R14288 n_16_11_14 n_17_11_14 139.25925740037331
R14289 n_16_11_14 n_16_11_15 11.14380559905752
R14290 n_16_11_15 n_17_11_15 6579.999912167574
R14291 n_16_11_15 n_16_12_15 7731.055754079277
R14292 n_16_12_0 n_17_12_0 5400.149997916649
R14293 n_16_12_0 n_16_13_0 3.7791845176855245
R14294 n_16_12_0 n_16_12_1 436.4958117926656
R14295 n_16_12_1 n_17_12_1 7560.209997083308
R14296 n_16_12_1 n_16_13_1 5.290858324759735
R14297 n_16_12_1 n_16_12_2 992.0359358924218
R14298 n_16_12_2 n_17_12_2 13500.374994791624
R14299 n_16_12_2 n_16_13_2 9.447961294213812
R14300 n_16_12_2 n_16_12_3 928.5456359953067
R14301 n_16_12_3 n_17_12_3 189005.24992708254
R14302 n_16_12_3 n_16_13_3 132.27145811899325
R14303 n_16_12_3 n_16_12_4 12.345336091105704
R14304 n_16_12_4 n_17_12_4 5727.431815972199
R14305 n_16_12_4 n_16_13_4 4.008226003605856
R14306 n_16_12_15 n_17_12_15 378010.49985416175
R14307 n_16_12_15 n_16_13_15 264.5429162379842
R14308 n_16_13_0 n_17_13_0 5400.149997916649
R14309 n_16_13_0 n_16_14_0 3.7791845176855245
R14310 n_16_13_0 n_16_13_1 436.4958117926656
R14311 n_16_13_1 n_17_13_1 7560.209997083308
R14312 n_16_13_1 n_16_14_1 5.290858324759735
R14313 n_16_13_1 n_16_13_2 992.0359358924218
R14314 n_16_13_2 n_17_13_2 13500.374994791624
R14315 n_16_13_2 n_16_14_2 9.447961294213812
R14316 n_16_13_2 n_16_13_3 928.5456359953067
R14317 n_16_13_3 n_17_13_3 189005.24992708254
R14318 n_16_13_3 n_16_14_3 132.27145811899325
R14319 n_16_13_3 n_16_13_4 12.345336091105704
R14320 n_16_13_4 n_17_13_4 5727.431815972199
R14321 n_16_13_4 n_16_14_4 4.008226003605856
R14322 n_16_13_15 n_17_13_15 378010.49985416175
R14323 n_16_13_15 n_16_14_15 264.5429162379842
R14324 n_16_14_0 n_17_14_0 5400.149997916649
R14325 n_16_14_0 n_16_15_0 3.7791845176855245
R14326 n_16_14_0 n_16_14_1 436.4958117926656
R14327 n_16_14_1 n_17_14_1 7560.209997083308
R14328 n_16_14_1 n_16_15_1 5.290858324759735
R14329 n_16_14_1 n_16_14_2 992.0359358924218
R14330 n_16_14_2 n_17_14_2 13500.374994791624
R14331 n_16_14_2 n_16_15_2 9.447961294213812
R14332 n_16_14_2 n_16_14_3 928.5456359953067
R14333 n_16_14_3 n_17_14_3 189005.24992708254
R14334 n_16_14_3 n_16_15_3 132.27145811899325
R14335 n_16_14_3 n_16_14_4 12.345336091105704
R14336 n_16_14_4 n_17_14_4 5727.431815972199
R14337 n_16_14_4 n_16_15_4 4.008226003605856
R14338 n_16_14_15 n_17_14_15 378010.49985416175
R14339 n_16_14_15 n_16_15_15 264.5429162379842
R14340 n_16_15_0 n_17_15_0 5400.149997916649
R14341 n_16_15_0 n_16_16_0 110.44365362970498
R14342 n_16_15_0 n_16_15_1 436.4958117926656
R14343 n_16_15_1 n_17_15_1 7560.209997083308
R14344 n_16_15_1 n_16_16_1 154.62111508158694
R14345 n_16_15_1 n_16_15_2 992.0359358924218
R14346 n_16_15_2 n_17_15_2 13500.374994791624
R14347 n_16_15_2 n_16_16_2 276.1091340742624
R14348 n_16_15_2 n_16_15_3 928.5456359953067
R14349 n_16_15_3 n_17_15_3 189005.24992708254
R14350 n_16_15_3 n_16_16_3 3865.527877039671
R14351 n_16_15_3 n_16_15_4 12.345336091105704
R14352 n_16_15_4 n_17_15_4 5727.431815972199
R14353 n_16_15_4 n_16_16_4 117.13720839514153
R14354 n_16_15_15 n_17_15_15 378010.49985416175
R14355 n_16_15_15 n_16_16_15 7731.055754079272
R14356 n_16_16_0 n_17_16_0 93.99999874525204
R14357 n_16_16_0 n_16_17_0 217.10812274172457
R14358 n_16_16_0 n_16_16_1 7.598049272084617
R14359 n_16_16_1 n_17_16_1 131.59999824335284
R14360 n_16_16_1 n_16_17_1 303.9513718384144
R14361 n_16_16_1 n_16_16_2 17.26829380019231
R14362 n_16_16_2 n_17_16_2 234.9999968631301
R14363 n_16_16_2 n_16_17_2 542.7703068543113
R14364 n_16_16_2 n_16_16_3 16.16312299698
R14365 n_16_16_3 n_17_16_3 3289.999956083818
R14366 n_16_16_3 n_16_17_3 7598.784295960353
R14367 n_16_16_3 n_16_16_4 0.21489432284683782
R14368 n_16_16_4 n_17_16_4 99.69696836617629
R14369 n_16_16_4 n_16_17_4 230.26619078667736
R14370 n_16_16_4 n_16_16_5 0.21489432284683782
R14371 n_16_16_5 n_17_16_5 3289.999956083818
R14372 n_16_16_5 n_16_17_5 7598.784295960353
R14373 n_16_16_5 n_16_16_6 0.4144390512046158
R14374 n_16_16_6 n_17_16_6 731.1111013519596
R14375 n_16_16_6 n_16_17_6 1688.6187324356338
R14376 n_16_16_6 n_16_16_7 0.5832845905842734
R14377 n_16_16_7 n_17_16_7 1253.333316603363
R14378 n_16_16_7 n_16_17_7 2894.774969889667
R14379 n_16_16_7 n_16_16_8 0.4297886456936743
R14380 n_16_16_8 n_17_16_8 1253.333316603363
R14381 n_16_16_8 n_16_17_8 2894.774969889667
R14382 n_16_16_8 n_16_16_9 0.4297886456936743
R14383 n_16_16_9 n_17_16_9 1253.333316603363
R14384 n_16_16_9 n_16_17_9 2894.774969889667
R14385 n_16_16_9 n_16_16_10 0.4297886456936743
R14386 n_16_16_10 n_17_16_10 1253.333316603363
R14387 n_16_16_10 n_16_17_10 2894.774969889667
R14388 n_16_16_10 n_16_16_11 0.4297886456936716
R14389 n_16_16_11 n_17_16_11 1253.333316603379
R14390 n_16_16_11 n_16_17_11 2894.774969889704
R14391 n_16_16_11 n_16_16_12 0.42978864569367015
R14392 n_16_16_12 n_17_16_12 1253.3333166033713
R14393 n_16_16_12 n_16_17_12 2894.7749698896855
R14394 n_16_16_12 n_16_16_13 0.42978864569367425
R14395 n_16_16_13 n_17_16_13 1253.3333166033553
R14396 n_16_16_13 n_16_17_13 2894.774969889649
R14397 n_16_16_13 n_16_16_14 2.1489432284683767
R14398 n_16_16_14 n_17_16_14 139.25925740037337
R14399 n_16_16_14 n_16_17_14 321.6416633210734
R14400 n_16_16_14 n_16_16_15 11.143805599057526
R14401 n_16_16_15 n_17_16_15 6579.999912167577
R14402 n_16_16_15 n_16_17_15 15197.56859192057
R14403 n_16_17_0 n_17_17_0 93.9999987452519
R14404 n_16_17_0 n_16_18_0 217.10812274172469
R14405 n_16_17_0 n_16_17_1 7.598049272084607
R14406 n_16_17_1 n_17_17_1 131.59999824335267
R14407 n_16_17_1 n_16_18_1 303.95137183841456
R14408 n_16_17_1 n_16_17_2 17.268293800192286
R14409 n_16_17_2 n_17_17_2 234.99999686312978
R14410 n_16_17_2 n_16_18_2 542.7703068543117
R14411 n_16_17_2 n_16_17_3 16.16312299697998
R14412 n_16_17_3 n_17_17_3 3289.999956083814
R14413 n_16_17_3 n_16_18_3 7598.784295960358
R14414 n_16_17_3 n_16_17_4 0.21489432284683754
R14415 n_16_17_4 n_17_17_4 99.69696836617618
R14416 n_16_17_4 n_16_18_4 230.2661907866775
R14417 n_16_17_4 n_16_17_5 0.21489432284683754
R14418 n_16_17_5 n_17_17_5 3289.999956083814
R14419 n_16_17_5 n_16_18_5 7598.784295960358
R14420 n_16_17_5 n_16_17_6 0.41443905120461527
R14421 n_16_17_6 n_17_17_6 731.1111013519586
R14422 n_16_17_6 n_16_18_6 1688.6187324356347
R14423 n_16_17_6 n_16_17_7 0.5832845905842726
R14424 n_16_17_7 n_17_17_7 1253.3333166033615
R14425 n_16_17_7 n_16_18_7 2894.7749698896687
R14426 n_16_17_7 n_16_17_8 0.4297886456936737
R14427 n_16_17_8 n_17_17_8 1253.3333166033615
R14428 n_16_17_8 n_16_18_8 2894.7749698896687
R14429 n_16_17_8 n_16_17_9 0.4297886456936737
R14430 n_16_17_9 n_17_17_9 1253.3333166033615
R14431 n_16_17_9 n_16_18_9 2894.7749698896687
R14432 n_16_17_9 n_16_17_10 0.4297886456936737
R14433 n_16_17_10 n_17_17_10 1253.3333166033615
R14434 n_16_17_10 n_16_18_10 2894.7749698896687
R14435 n_16_17_10 n_16_17_11 0.429788645693671
R14436 n_16_17_11 n_17_17_11 1253.3333166033776
R14437 n_16_17_11 n_16_18_11 2894.774969889706
R14438 n_16_17_11 n_16_17_12 0.4297886456936696
R14439 n_16_17_12 n_17_17_12 1253.3333166033697
R14440 n_16_17_12 n_16_18_12 2894.7749698896873
R14441 n_16_17_12 n_16_17_13 0.4297886456936737
R14442 n_16_17_13 n_17_17_13 1253.3333166033535
R14443 n_16_17_13 n_16_18_13 2894.774969889651
R14444 n_16_17_13 n_16_17_14 2.148943228468374
R14445 n_16_17_14 n_17_17_14 139.2592574003732
R14446 n_16_17_14 n_16_18_14 321.64166332107357
R14447 n_16_17_14 n_16_17_15 11.143805599057513
R14448 n_16_17_15 n_17_17_15 6579.99991216757
R14449 n_16_17_15 n_16_18_15 15197.568591920579
R14450 n_16_18_0 n_17_18_0 93.9999987452519
R14451 n_16_18_0 n_16_19_0 217.10812274172457
R14452 n_16_18_0 n_16_18_1 7.598049272084607
R14453 n_16_18_1 n_17_18_1 131.59999824335267
R14454 n_16_18_1 n_16_19_1 303.9513718384144
R14455 n_16_18_1 n_16_18_2 17.268293800192286
R14456 n_16_18_2 n_17_18_2 234.99999686312978
R14457 n_16_18_2 n_16_19_2 542.7703068543113
R14458 n_16_18_2 n_16_18_3 16.16312299697998
R14459 n_16_18_3 n_17_18_3 3289.999956083814
R14460 n_16_18_3 n_16_19_3 7598.784295960353
R14461 n_16_18_3 n_16_18_4 0.21489432284683754
R14462 n_16_18_4 n_17_18_4 99.69696836617618
R14463 n_16_18_4 n_16_19_4 230.26619078667736
R14464 n_16_18_4 n_16_18_5 0.21489432284683754
R14465 n_16_18_5 n_17_18_5 3289.999956083814
R14466 n_16_18_5 n_16_19_5 7598.784295960353
R14467 n_16_18_5 n_16_18_6 0.41443905120461527
R14468 n_16_18_6 n_17_18_6 731.1111013519586
R14469 n_16_18_6 n_16_19_6 1688.6187324356338
R14470 n_16_18_6 n_16_18_7 0.5832845905842726
R14471 n_16_18_7 n_17_18_7 1253.3333166033615
R14472 n_16_18_7 n_16_19_7 2894.774969889667
R14473 n_16_18_7 n_16_18_8 0.4297886456936737
R14474 n_16_18_8 n_17_18_8 1253.3333166033615
R14475 n_16_18_8 n_16_19_8 2894.774969889667
R14476 n_16_18_8 n_16_18_9 0.4297886456936737
R14477 n_16_18_9 n_17_18_9 1253.3333166033615
R14478 n_16_18_9 n_16_19_9 2894.774969889667
R14479 n_16_18_9 n_16_18_10 0.4297886456936737
R14480 n_16_18_10 n_17_18_10 1253.3333166033615
R14481 n_16_18_10 n_16_19_10 2894.774969889667
R14482 n_16_18_10 n_16_18_11 0.429788645693671
R14483 n_16_18_11 n_17_18_11 1253.3333166033776
R14484 n_16_18_11 n_16_19_11 2894.774969889704
R14485 n_16_18_11 n_16_18_12 0.4297886456936696
R14486 n_16_18_12 n_17_18_12 1253.3333166033697
R14487 n_16_18_12 n_16_19_12 2894.7749698896855
R14488 n_16_18_12 n_16_18_13 0.4297886456936737
R14489 n_16_18_13 n_17_18_13 1253.3333166033535
R14490 n_16_18_13 n_16_19_13 2894.774969889649
R14491 n_16_18_13 n_16_18_14 2.148943228468374
R14492 n_16_18_14 n_17_18_14 139.2592574003732
R14493 n_16_18_14 n_16_19_14 321.6416633210734
R14494 n_16_18_14 n_16_18_15 11.143805599057513
R14495 n_16_18_15 n_17_18_15 6579.99991216757
R14496 n_16_18_15 n_16_19_15 15197.56859192057
R14497 n_16_19_0 n_17_19_0 93.99999874525204
R14498 n_16_19_0 n_16_20_0 110.44365397508213
R14499 n_16_19_0 n_16_19_1 7.598049272084617
R14500 n_16_19_1 n_17_19_1 131.59999824335284
R14501 n_16_19_1 n_16_20_1 154.62111556511496
R14502 n_16_19_1 n_16_19_2 17.26829380019231
R14503 n_16_19_2 n_17_19_2 234.9999968631301
R14504 n_16_19_2 n_16_20_2 276.1091349377053
R14505 n_16_19_2 n_16_19_3 16.16312299698
R14506 n_16_19_3 n_17_19_3 3289.999956083818
R14507 n_16_19_3 n_16_20_3 3865.5278891278713
R14508 n_16_19_3 n_16_19_4 0.21489432284683782
R14509 n_16_19_4 n_17_19_4 99.69696836617629
R14510 n_16_19_4 n_16_20_4 117.13720876145064
R14511 n_16_19_4 n_16_19_5 0.21489432284683782
R14512 n_16_19_5 n_17_19_5 3289.999956083818
R14513 n_16_19_5 n_16_19_6 0.4144390512046158
R14514 n_16_19_6 n_17_19_6 731.1111013519596
R14515 n_16_19_6 n_16_19_7 0.5832845905842734
R14516 n_16_19_7 n_17_19_7 1253.333316603363
R14517 n_16_19_7 n_16_19_8 0.4297886456936743
R14518 n_16_19_8 n_17_19_8 1253.333316603363
R14519 n_16_19_8 n_16_19_9 0.4297886456936743
R14520 n_16_19_9 n_17_19_9 1253.333316603363
R14521 n_16_19_9 n_16_19_10 0.4297886456936743
R14522 n_16_19_10 n_17_19_10 1253.333316603363
R14523 n_16_19_10 n_16_19_11 0.4297886456936716
R14524 n_16_19_11 n_17_19_11 1253.333316603379
R14525 n_16_19_11 n_16_19_12 0.42978864569367015
R14526 n_16_19_12 n_17_19_12 1253.3333166033713
R14527 n_16_19_12 n_16_19_13 0.42978864569367425
R14528 n_16_19_13 n_17_19_13 1253.3333166033553
R14529 n_16_19_13 n_16_19_14 2.1489432284683767
R14530 n_16_19_14 n_17_19_14 139.25925740037337
R14531 n_16_19_14 n_16_19_15 11.143805599057526
R14532 n_16_19_15 n_17_19_15 6579.999912167577
R14533 n_16_19_15 n_16_20_15 7731.0557782556725
R14534 n_16_20_0 n_17_20_0 5400.149010884632
R14535 n_16_20_0 n_16_21_0 3.7791852084398188
R14536 n_16_20_0 n_16_20_1 436.4957320105592
R14537 n_16_20_1 n_17_20_1 7560.208615238482
R14538 n_16_20_1 n_16_21_1 5.290859291815746
R14539 n_16_20_1 n_16_20_2 992.0357545694527
R14540 n_16_20_2 n_17_20_2 13500.37252721158
R14541 n_16_20_2 n_16_21_2 9.447963021099547
R14542 n_16_20_2 n_16_20_3 928.5454662770078
R14543 n_16_20_3 n_17_20_3 189005.2153809619
R14544 n_16_20_3 n_16_21_3 132.27148229539355
R14545 n_16_20_3 n_16_20_4 12.34533383464209
R14546 n_16_20_4 n_17_20_4 5727.430769120058
R14547 n_16_20_4 n_16_21_4 4.008226736224047
R14548 n_16_20_15 n_17_20_15 378010.4307619204
R14549 n_16_20_15 n_16_21_15 264.5429645907847
R14550 n_16_21_0 n_17_21_0 5400.149010884632
R14551 n_16_21_0 n_16_22_0 3.7791852084396846
R14552 n_16_21_0 n_16_21_1 436.4957320105592
R14553 n_16_21_1 n_17_21_1 7560.208615238482
R14554 n_16_21_1 n_16_22_1 5.290859291815558
R14555 n_16_21_1 n_16_21_2 992.0357545694527
R14556 n_16_21_2 n_17_21_2 13500.37252721158
R14557 n_16_21_2 n_16_22_2 9.447963021099211
R14558 n_16_21_2 n_16_21_3 928.5454662770078
R14559 n_16_21_3 n_17_21_3 189005.2153809619
R14560 n_16_21_3 n_16_22_3 132.27148229538886
R14561 n_16_21_3 n_16_21_4 12.34533383464209
R14562 n_16_21_4 n_17_21_4 5727.430769120058
R14563 n_16_21_4 n_16_22_4 4.008226736223905
R14564 n_16_21_15 n_17_21_15 378010.4307619204
R14565 n_16_21_15 n_16_22_15 264.54296459077534
R14566 n_16_22_0 n_17_22_0 5400.149010885015
R14567 n_16_22_0 n_16_23_0 3.7791852084396846
R14568 n_16_22_0 n_16_22_1 436.49573201059025
R14569 n_16_22_1 n_17_22_1 7560.20861523902
R14570 n_16_22_1 n_16_23_1 5.290859291815558
R14571 n_16_22_1 n_16_22_2 992.0357545695232
R14572 n_16_22_2 n_17_22_2 13500.372527212538
R14573 n_16_22_2 n_16_23_2 9.447963021099211
R14574 n_16_22_2 n_16_22_3 928.5454662770737
R14575 n_16_22_3 n_17_22_3 189005.21538097534
R14576 n_16_22_3 n_16_23_3 132.27148229538886
R14577 n_16_22_3 n_16_22_4 12.345333834642968
R14578 n_16_22_4 n_17_22_4 5727.430769120465
R14579 n_16_22_4 n_16_23_4 4.008226736223905
R14580 n_16_22_15 n_17_22_15 378010.4307619473
R14581 n_16_22_15 n_16_23_15 264.54296459077534
R14582 n_16_23_0 n_17_23_0 5400.149010884632
R14583 n_16_23_0 n_16_24_0 43.561715139231076
R14584 n_16_23_0 n_16_23_1 436.4957320105592
R14585 n_16_23_1 n_17_23_1 7560.208615238482
R14586 n_16_23_1 n_16_24_1 60.98640119492351
R14587 n_16_23_1 n_16_23_2 992.0357545694527
R14588 n_16_23_2 n_17_23_2 13500.37252721158
R14589 n_16_23_2 n_16_24_2 108.90428784807769
R14590 n_16_23_2 n_16_23_3 928.5454662770078
R14591 n_16_23_3 n_17_23_3 189005.2153809619
R14592 n_16_23_3 n_16_24_3 1524.6600298730866
R14593 n_16_23_3 n_16_23_4 12.34533383464209
R14594 n_16_23_4 n_17_23_4 5727.430769120058
R14595 n_16_23_4 n_16_24_4 46.20181908706322
R14596 n_16_23_15 n_17_23_15 378010.4307619204
R14597 n_16_23_15 n_16_24_15 3049.3200597461455
R14598 n_16_24_0 n_17_24_0 244.8658962374671
R14599 n_16_24_0 n_16_25_0 83.3442450700222
R14600 n_16_24_0 n_16_24_1 19.79258690957598
R14601 n_16_24_1 n_17_24_1 342.8122547324539
R14602 n_16_24_1 n_16_25_1 116.68194309803108
R14603 n_16_24_1 n_16_24_2 44.983152067218136
R14604 n_16_24_2 n_17_24_2 612.1647405936677
R14605 n_16_24_2 n_16_25_2 208.3606126750555
R14606 n_16_24_2 n_16_24_3 42.10423033491618
R14607 n_16_24_3 n_17_24_3 8570.30636831134
R14608 n_16_24_3 n_16_25_3 2917.048577450775
R14609 n_16_24_3 n_16_24_4 0.5597903368364929
R14610 n_16_24_4 n_17_24_4 259.70625358519214
R14611 n_16_24_4 n_16_25_4 88.39541143790225
R14612 n_16_24_4 n_16_24_5 0.46268384983424415
R14613 n_16_24_5 n_17_24_5 1632.439308249779
R14614 n_16_24_5 n_16_25_5 555.6283004668143
R14615 n_16_24_5 n_16_24_6 0.15994009623899796
R14616 n_16_24_6 n_17_24_6 272.07321804162984
R14617 n_16_24_6 n_16_25_6 92.60471674446904
R14618 n_16_24_6 n_16_24_7 0.217061559181497
R14619 n_16_24_7 n_17_24_7 466.4112309285097
R14620 n_16_24_7 n_16_25_7 158.75094299051884
R14621 n_16_24_7 n_16_24_8 0.15994009623899746
R14622 n_16_24_8 n_17_24_8 466.4112309285097
R14623 n_16_24_8 n_16_25_8 158.75094299051884
R14624 n_16_24_8 n_16_24_9 0.15994009623899746
R14625 n_16_24_9 n_17_24_9 466.4112309285097
R14626 n_16_24_9 n_16_25_9 158.75094299051884
R14627 n_16_24_9 n_16_24_10 0.15994009623899746
R14628 n_16_24_10 n_17_24_10 466.4112309285097
R14629 n_16_24_10 n_16_25_10 158.75094299051884
R14630 n_16_24_10 n_16_24_11 0.15994009623899644
R14631 n_16_24_11 n_17_24_11 466.4112309285157
R14632 n_16_24_11 n_16_25_11 158.75094299052085
R14633 n_16_24_11 n_16_24_12 0.1599400962389959
R14634 n_16_24_12 n_17_24_12 466.41123092851274
R14635 n_16_24_12 n_16_25_12 158.75094299051983
R14636 n_16_24_12 n_16_24_13 0.15994009623899746
R14637 n_16_24_13 n_17_24_13 466.4112309285068
R14638 n_16_24_13 n_16_25_13 158.75094299051784
R14639 n_16_24_13 n_16_24_14 0.7997004811949894
R14640 n_16_24_14 n_17_24_14 51.82347010316764
R14641 n_16_24_14 n_16_25_14 17.638993665613164
R14642 n_16_24_14 n_16_24_15 24.7107448689254
R14643 n_16_24_15 n_17_24_15 17140.612736622526
R14644 n_16_24_15 n_16_25_15 5834.097154901498
R14645 n_16_25_0 n_17_25_0 244.8658962374679
R14646 n_16_25_0 n_16_26_0 83.3442450700222
R14647 n_16_25_0 n_16_25_1 19.792586909576038
R14648 n_16_25_1 n_17_25_1 342.812254732455
R14649 n_16_25_1 n_16_26_1 116.68194309803108
R14650 n_16_25_1 n_16_25_2 44.983152067218285
R14651 n_16_25_2 n_17_25_2 612.1647405936696
R14652 n_16_25_2 n_16_26_2 208.3606126750555
R14653 n_16_25_2 n_16_25_3 42.104230334916316
R14654 n_16_25_3 n_17_25_3 8570.306368311369
R14655 n_16_25_3 n_16_26_3 2917.048577450775
R14656 n_16_25_3 n_16_25_4 0.5597903368364947
R14657 n_16_25_4 n_17_25_4 259.70625358519294
R14658 n_16_25_4 n_16_26_4 88.39541143790225
R14659 n_16_25_4 n_16_25_5 0.46268384983424565
R14660 n_16_25_5 n_17_25_5 1632.439308249784
R14661 n_16_25_5 n_16_26_5 555.6283004668143
R14662 n_16_25_5 n_16_25_6 0.1599400962389985
R14663 n_16_25_6 n_17_25_6 272.07321804163075
R14664 n_16_25_6 n_16_26_6 92.60471674446904
R14665 n_16_25_6 n_16_25_7 0.21706155918149772
R14666 n_16_25_7 n_17_25_7 466.41123092851126
R14667 n_16_25_7 n_16_26_7 158.75094299051884
R14668 n_16_25_7 n_16_25_8 0.159940096238998
R14669 n_16_25_8 n_17_25_8 466.41123092851126
R14670 n_16_25_8 n_16_26_8 158.75094299051884
R14671 n_16_25_8 n_16_25_9 0.159940096238998
R14672 n_16_25_9 n_17_25_9 466.41123092851126
R14673 n_16_25_9 n_16_26_9 158.75094299051884
R14674 n_16_25_9 n_16_25_10 0.159940096238998
R14675 n_16_25_10 n_17_25_10 466.41123092851126
R14676 n_16_25_10 n_16_26_10 158.75094299051884
R14677 n_16_25_10 n_16_25_11 0.15994009623899696
R14678 n_16_25_11 n_17_25_11 466.4112309285172
R14679 n_16_25_11 n_16_26_11 158.75094299052085
R14680 n_16_25_11 n_16_25_12 0.15994009623899647
R14681 n_16_25_12 n_17_25_12 466.4112309285141
R14682 n_16_25_12 n_16_26_12 158.75094299051983
R14683 n_16_25_12 n_16_25_13 0.15994009623899796
R14684 n_16_25_13 n_17_25_13 466.41123092850836
R14685 n_16_25_13 n_16_26_13 158.75094299051784
R14686 n_16_25_13 n_16_25_14 0.7997004811949919
R14687 n_16_25_14 n_17_25_14 51.8234701031678
R14688 n_16_25_14 n_16_26_14 17.638993665613164
R14689 n_16_25_14 n_16_25_15 24.71074486892548
R14690 n_16_25_15 n_17_25_15 17140.612736622585
R14691 n_16_25_15 n_16_26_15 5834.097154901498
R14692 n_16_26_0 n_17_26_0 244.8658962374671
R14693 n_16_26_0 n_16_27_0 83.34424507002234
R14694 n_16_26_0 n_16_26_1 19.79258690957598
R14695 n_16_26_1 n_17_26_1 342.8122547324539
R14696 n_16_26_1 n_16_27_1 116.68194309803127
R14697 n_16_26_1 n_16_26_2 44.983152067218136
R14698 n_16_26_2 n_17_26_2 612.1647405936677
R14699 n_16_26_2 n_16_27_2 208.36061267505582
R14700 n_16_26_2 n_16_26_3 42.10423033491618
R14701 n_16_26_3 n_17_26_3 8570.30636831134
R14702 n_16_26_3 n_16_27_3 2917.0485774507797
R14703 n_16_26_3 n_16_26_4 0.5597903368364929
R14704 n_16_26_4 n_17_26_4 259.70625358519214
R14705 n_16_26_4 n_16_27_4 88.3954114379024
R14706 n_16_26_4 n_16_26_5 0.46268384983424415
R14707 n_16_26_5 n_17_26_5 1632.439308249779
R14708 n_16_26_5 n_16_27_5 555.6283004668152
R14709 n_16_26_5 n_16_26_6 0.15994009623899796
R14710 n_16_26_6 n_17_26_6 272.07321804162984
R14711 n_16_26_6 n_16_27_6 92.60471674446919
R14712 n_16_26_6 n_16_26_7 0.217061559181497
R14713 n_16_26_7 n_17_26_7 466.4112309285097
R14714 n_16_26_7 n_16_27_7 158.7509429905191
R14715 n_16_26_7 n_16_26_8 0.15994009623899746
R14716 n_16_26_8 n_17_26_8 466.4112309285097
R14717 n_16_26_8 n_16_27_8 158.7509429905191
R14718 n_16_26_8 n_16_26_9 0.15994009623899746
R14719 n_16_26_9 n_17_26_9 466.4112309285097
R14720 n_16_26_9 n_16_27_9 158.7509429905191
R14721 n_16_26_9 n_16_26_10 0.15994009623899746
R14722 n_16_26_10 n_17_26_10 466.4112309285097
R14723 n_16_26_10 n_16_27_10 158.7509429905191
R14724 n_16_26_10 n_16_26_11 0.15994009623899644
R14725 n_16_26_11 n_17_26_11 466.4112309285157
R14726 n_16_26_11 n_16_27_11 158.7509429905211
R14727 n_16_26_11 n_16_26_12 0.1599400962389959
R14728 n_16_26_12 n_17_26_12 466.41123092851274
R14729 n_16_26_12 n_16_27_12 158.7509429905201
R14730 n_16_26_12 n_16_26_13 0.15994009623899746
R14731 n_16_26_13 n_17_26_13 466.4112309285068
R14732 n_16_26_13 n_16_27_13 158.7509429905181
R14733 n_16_26_13 n_16_26_14 0.7997004811949894
R14734 n_16_26_14 n_17_26_14 51.82347010316764
R14735 n_16_26_14 n_16_27_14 17.638993665613192
R14736 n_16_26_14 n_16_26_15 24.7107448689254
R14737 n_16_26_15 n_17_26_15 17140.612736622526
R14738 n_16_26_15 n_16_27_15 5834.097154901507
R14739 n_16_27_0 n_17_27_0 244.8658962374671
R14740 n_16_27_0 n_16_27_1 19.79258690957598
R14741 n_16_27_1 n_17_27_1 342.8122547324539
R14742 n_16_27_1 n_16_27_2 44.983152067218136
R14743 n_16_27_2 n_17_27_2 612.1647405936677
R14744 n_16_27_2 n_16_27_3 42.10423033491618
R14745 n_16_27_3 n_17_27_3 8570.30636831134
R14746 n_16_27_3 n_16_27_4 0.5597903368364929
R14747 n_16_27_4 n_17_27_4 259.70625358519214
R14748 n_16_27_4 n_16_27_5 0.46268384983424415
R14749 n_16_27_5 n_17_27_5 1632.439308249779
R14750 n_16_27_5 n_16_27_6 0.15994009623899796
R14751 n_16_27_6 n_17_27_6 272.07321804162984
R14752 n_16_27_6 n_16_27_7 0.217061559181497
R14753 n_16_27_7 n_17_27_7 466.4112309285097
R14754 n_16_27_7 n_16_27_8 0.15994009623899746
R14755 n_16_27_8 n_17_27_8 466.4112309285097
R14756 n_16_27_8 n_16_27_9 0.15994009623899746
R14757 n_16_27_9 n_17_27_9 466.4112309285097
R14758 n_16_27_9 n_16_27_10 0.15994009623899746
R14759 n_16_27_10 n_17_27_10 466.4112309285097
R14760 n_16_27_10 n_16_27_11 0.15994009623899644
R14761 n_16_27_11 n_17_27_11 466.4112309285157
R14762 n_16_27_11 n_16_27_12 0.1599400962389959
R14763 n_16_27_12 n_17_27_12 466.41123092851274
R14764 n_16_27_12 n_16_27_13 0.15994009623899746
R14765 n_16_27_13 n_17_27_13 466.4112309285068
R14766 n_16_27_13 n_16_27_14 0.7997004811949894
R14767 n_16_27_14 n_17_27_14 51.82347010316764
R14768 n_16_27_14 n_16_27_15 24.7107448689254
R14769 n_16_27_15 n_17_27_15 17140.612736622526
R14770 n_17_0_0 n_18_0_0 244.86587514965544
R14771 n_17_0_0 n_17_1_0 83.34425224761601
R14772 n_17_0_0 n_17_0_1 19.792585205041597
R14773 n_17_0_1 n_18_0_1 342.8122252095175
R14774 n_17_0_1 n_17_1_1 116.6819531466624
R14775 n_17_0_1 n_17_0_2 44.98314819327637
R14776 n_17_0_2 n_18_0_2 612.1646878741385
R14777 n_17_0_2 n_17_1_2 208.36063061904002
R14778 n_17_0_2 n_17_0_3 42.10422670890668
R14779 n_17_0_3 n_18_0_3 8570.30563023793
R14780 n_17_0_3 n_17_1_3 2917.0488286665573
R14781 n_17_0_3 n_17_0_4 0.5597902886274397
R14782 n_17_0_4 n_18_0_4 259.70623121933124
R14783 n_17_0_4 n_17_1_4 88.39541905050173
R14784 n_17_0_4 n_17_0_5 0.4626838099879859
R14785 n_17_0_5 n_18_0_5 1632.4391676643677
R14786 n_17_0_5 n_17_1_5 555.6283483174395
R14787 n_17_0_5 n_17_0_6 0.15994008246498279
R14788 n_17_0_6 n_18_0_6 272.073194610728
R14789 n_17_0_6 n_17_1_6 92.60472471957324
R14790 n_17_0_6 n_17_0_7 0.21706154048819065
R14791 n_17_0_7 n_18_0_7 466.41119076124943
R14792 n_17_0_7 n_17_1_7 158.75095666212607
R14793 n_17_0_7 n_17_0_8 0.15994008246498229
R14794 n_17_0_8 n_18_0_8 466.41119076124943
R14795 n_17_0_8 n_17_1_8 158.75095666212607
R14796 n_17_0_8 n_17_0_9 0.15994008246498229
R14797 n_17_0_9 n_18_0_9 466.41119076124943
R14798 n_17_0_9 n_17_1_9 158.75095666212607
R14799 n_17_0_9 n_17_0_10 0.15994008246498229
R14800 n_17_0_10 n_18_0_10 466.41119076124943
R14801 n_17_0_10 n_17_1_10 158.75095666212607
R14802 n_17_0_10 n_17_0_11 0.15994008246498126
R14803 n_17_0_11 n_18_0_11 466.41119076125534
R14804 n_17_0_11 n_17_1_11 158.7509566621281
R14805 n_17_0_11 n_17_0_12 0.15994008246498076
R14806 n_17_0_12 n_18_0_12 466.41119076125256
R14807 n_17_0_12 n_17_1_12 158.75095666212707
R14808 n_17_0_12 n_17_0_13 0.15994008246498226
R14809 n_17_0_13 n_18_0_13 466.4111907612465
R14810 n_17_0_13 n_17_1_13 158.75095666212505
R14811 n_17_0_13 n_17_0_14 0.7997004123249134
R14812 n_17_0_14 n_18_0_14 51.823465640138714
R14813 n_17_0_14 n_17_1_14 17.638995184680635
R14814 n_17_0_14 n_17_0_15 24.71074274084005
R14815 n_17_0_15 n_18_0_15 17140.61126047571
R14816 n_17_0_15 n_17_1_15 5834.097657333063
R14817 n_17_1_0 n_18_1_0 244.86587514965544
R14818 n_17_1_0 n_17_2_0 83.34425224761601
R14819 n_17_1_0 n_17_1_1 19.792585205041597
R14820 n_17_1_1 n_18_1_1 342.8122252095175
R14821 n_17_1_1 n_17_2_1 116.6819531466624
R14822 n_17_1_1 n_17_1_2 44.98314819327637
R14823 n_17_1_2 n_18_1_2 612.1646878741385
R14824 n_17_1_2 n_17_2_2 208.36063061904002
R14825 n_17_1_2 n_17_1_3 42.10422670890668
R14826 n_17_1_3 n_18_1_3 8570.30563023793
R14827 n_17_1_3 n_17_2_3 2917.0488286665573
R14828 n_17_1_3 n_17_1_4 0.5597902886274397
R14829 n_17_1_4 n_18_1_4 259.70623121933124
R14830 n_17_1_4 n_17_2_4 88.39541905050173
R14831 n_17_1_4 n_17_1_5 0.4626838099879859
R14832 n_17_1_5 n_18_1_5 1632.4391676643677
R14833 n_17_1_5 n_17_2_5 555.6283483174395
R14834 n_17_1_5 n_17_1_6 0.15994008246498279
R14835 n_17_1_6 n_18_1_6 272.073194610728
R14836 n_17_1_6 n_17_2_6 92.60472471957324
R14837 n_17_1_6 n_17_1_7 0.21706154048819065
R14838 n_17_1_7 n_18_1_7 466.41119076124943
R14839 n_17_1_7 n_17_2_7 158.75095666212607
R14840 n_17_1_7 n_17_1_8 0.15994008246498229
R14841 n_17_1_8 n_18_1_8 466.41119076124943
R14842 n_17_1_8 n_17_2_8 158.75095666212607
R14843 n_17_1_8 n_17_1_9 0.15994008246498229
R14844 n_17_1_9 n_18_1_9 466.41119076124943
R14845 n_17_1_9 n_17_2_9 158.75095666212607
R14846 n_17_1_9 n_17_1_10 0.15994008246498229
R14847 n_17_1_10 n_18_1_10 466.41119076124943
R14848 n_17_1_10 n_17_2_10 158.75095666212607
R14849 n_17_1_10 n_17_1_11 0.15994008246498126
R14850 n_17_1_11 n_18_1_11 466.41119076125534
R14851 n_17_1_11 n_17_2_11 158.7509566621281
R14852 n_17_1_11 n_17_1_12 0.15994008246498076
R14853 n_17_1_12 n_18_1_12 466.41119076125256
R14854 n_17_1_12 n_17_2_12 158.75095666212707
R14855 n_17_1_12 n_17_1_13 0.15994008246498226
R14856 n_17_1_13 n_18_1_13 466.4111907612465
R14857 n_17_1_13 n_17_2_13 158.75095666212505
R14858 n_17_1_13 n_17_1_14 0.7997004123249134
R14859 n_17_1_14 n_18_1_14 51.823465640138714
R14860 n_17_1_14 n_17_2_14 17.638995184680635
R14861 n_17_1_14 n_17_1_15 24.71074274084005
R14862 n_17_1_15 n_18_1_15 17140.61126047571
R14863 n_17_1_15 n_17_2_15 5834.097657333063
R14864 n_17_2_0 n_18_2_0 244.86587514965544
R14865 n_17_2_0 n_17_3_0 83.34425224761601
R14866 n_17_2_0 n_17_2_1 19.792585205041597
R14867 n_17_2_1 n_18_2_1 342.8122252095175
R14868 n_17_2_1 n_17_3_1 116.6819531466624
R14869 n_17_2_1 n_17_2_2 44.98314819327637
R14870 n_17_2_2 n_18_2_2 612.1646878741385
R14871 n_17_2_2 n_17_3_2 208.36063061904002
R14872 n_17_2_2 n_17_2_3 42.10422670890668
R14873 n_17_2_3 n_18_2_3 8570.30563023793
R14874 n_17_2_3 n_17_3_3 2917.0488286665573
R14875 n_17_2_3 n_17_2_4 0.5597902886274397
R14876 n_17_2_4 n_18_2_4 259.70623121933124
R14877 n_17_2_4 n_17_3_4 88.39541905050173
R14878 n_17_2_4 n_17_2_5 0.4626838099879859
R14879 n_17_2_5 n_18_2_5 1632.4391676643677
R14880 n_17_2_5 n_17_3_5 555.6283483174395
R14881 n_17_2_5 n_17_2_6 0.15994008246498279
R14882 n_17_2_6 n_18_2_6 272.073194610728
R14883 n_17_2_6 n_17_3_6 92.60472471957324
R14884 n_17_2_6 n_17_2_7 0.21706154048819065
R14885 n_17_2_7 n_18_2_7 466.41119076124943
R14886 n_17_2_7 n_17_3_7 158.75095666212607
R14887 n_17_2_7 n_17_2_8 0.15994008246498229
R14888 n_17_2_8 n_18_2_8 466.41119076124943
R14889 n_17_2_8 n_17_3_8 158.75095666212607
R14890 n_17_2_8 n_17_2_9 0.15994008246498229
R14891 n_17_2_9 n_18_2_9 466.41119076124943
R14892 n_17_2_9 n_17_3_9 158.75095666212607
R14893 n_17_2_9 n_17_2_10 0.15994008246498229
R14894 n_17_2_10 n_18_2_10 466.41119076124943
R14895 n_17_2_10 n_17_3_10 158.75095666212607
R14896 n_17_2_10 n_17_2_11 0.15994008246498126
R14897 n_17_2_11 n_18_2_11 466.41119076125534
R14898 n_17_2_11 n_17_3_11 158.7509566621281
R14899 n_17_2_11 n_17_2_12 0.15994008246498076
R14900 n_17_2_12 n_18_2_12 466.41119076125256
R14901 n_17_2_12 n_17_3_12 158.75095666212707
R14902 n_17_2_12 n_17_2_13 0.15994008246498226
R14903 n_17_2_13 n_18_2_13 466.4111907612465
R14904 n_17_2_13 n_17_3_13 158.75095666212505
R14905 n_17_2_13 n_17_2_14 0.7997004123249134
R14906 n_17_2_14 n_18_2_14 51.823465640138714
R14907 n_17_2_14 n_17_3_14 17.638995184680635
R14908 n_17_2_14 n_17_2_15 24.71074274084005
R14909 n_17_2_15 n_18_2_15 17140.61126047571
R14910 n_17_2_15 n_17_3_15 5834.097657333063
R14911 n_17_3_0 n_18_3_0 244.86587514965544
R14912 n_17_3_0 n_17_4_0 43.561715139231026
R14913 n_17_3_0 n_17_3_1 19.792585205041597
R14914 n_17_3_1 n_18_3_1 342.8122252095175
R14915 n_17_3_1 n_17_4_1 60.986401194923424
R14916 n_17_3_1 n_17_3_2 44.98314819327637
R14917 n_17_3_2 n_18_3_2 612.1646878741385
R14918 n_17_3_2 n_17_4_2 108.90428784807756
R14919 n_17_3_2 n_17_3_3 42.10422670890668
R14920 n_17_3_3 n_18_3_3 8570.30563023793
R14921 n_17_3_3 n_17_4_3 1524.6600298730843
R14922 n_17_3_3 n_17_3_4 0.5597902886274397
R14923 n_17_3_4 n_18_3_4 259.70623121933124
R14924 n_17_3_4 n_17_4_4 46.20181908706316
R14925 n_17_3_4 n_17_3_5 0.4626838099879859
R14926 n_17_3_5 n_18_3_5 1632.4391676643677
R14927 n_17_3_5 n_17_3_6 0.15994008246498279
R14928 n_17_3_6 n_18_3_6 272.073194610728
R14929 n_17_3_6 n_17_3_7 0.21706154048819065
R14930 n_17_3_7 n_18_3_7 466.41119076124943
R14931 n_17_3_7 n_17_3_8 0.15994008246498229
R14932 n_17_3_8 n_18_3_8 466.41119076124943
R14933 n_17_3_8 n_17_3_9 0.15994008246498229
R14934 n_17_3_9 n_18_3_9 466.41119076124943
R14935 n_17_3_9 n_17_3_10 0.15994008246498229
R14936 n_17_3_10 n_18_3_10 466.41119076124943
R14937 n_17_3_10 n_17_3_11 0.15994008246498126
R14938 n_17_3_11 n_18_3_11 466.41119076125534
R14939 n_17_3_11 n_17_3_12 0.15994008246498076
R14940 n_17_3_12 n_18_3_12 466.41119076125256
R14941 n_17_3_12 n_17_3_13 0.15994008246498226
R14942 n_17_3_13 n_18_3_13 466.4111907612465
R14943 n_17_3_13 n_17_3_14 0.7997004123249134
R14944 n_17_3_14 n_18_3_14 51.823465640138714
R14945 n_17_3_14 n_17_3_15 24.71074274084005
R14946 n_17_3_15 n_18_3_15 17140.61126047571
R14947 n_17_3_15 n_17_4_15 3049.3200597461414
R14948 n_17_4_0 n_18_4_0 5400.159267103211
R14949 n_17_4_0 n_17_5_0 3.7791780308460767
R14950 n_17_4_0 n_17_4_1 436.4965610239126
R14951 n_17_4_1 n_18_4_1 7560.222973944496
R14952 n_17_4_1 n_17_5_1 5.290849243184507
R14953 n_17_4_1 n_17_4_2 992.0376386907103
R14954 n_17_4_2 n_18_4_2 13500.398167758029
R14955 n_17_4_2 n_17_5_2 9.447945077115193
R14956 n_17_4_2 n_17_4_3 928.5472298145049
R14957 n_17_4_3 n_18_4_3 189005.57434861225
R14958 n_17_4_3 n_17_5_3 132.27123107961256
R14959 n_17_4_3 n_17_4_4 12.345357281484407
R14960 n_17_4_4 n_18_4_4 5727.441646927644
R14961 n_17_4_4 n_17_5_4 4.008219123624623
R14962 n_17_4_15 n_18_4_15 378011.1486972211
R14963 n_17_4_15 n_17_5_15 264.54246215922274
R14964 n_17_5_0 n_18_5_0 5400.159267103117
R14965 n_17_5_0 n_17_6_0 3.7791780308461105
R14966 n_17_5_0 n_17_5_1 436.49656102390486
R14967 n_17_5_1 n_18_5_1 7560.222973944361
R14968 n_17_5_1 n_17_6_1 5.290849243184554
R14969 n_17_5_1 n_17_5_2 992.0376386906928
R14970 n_17_5_2 n_18_5_2 13500.39816775779
R14971 n_17_5_2 n_17_6_2 9.447945077115277
R14972 n_17_5_2 n_17_5_3 928.5472298144884
R14973 n_17_5_3 n_18_5_3 189005.57434860888
R14974 n_17_5_3 n_17_6_3 132.27123107961373
R14975 n_17_5_3 n_17_5_4 12.34535728148419
R14976 n_17_5_4 n_18_5_4 5727.441646927542
R14977 n_17_5_4 n_17_6_4 4.0082191236246585
R14978 n_17_5_15 n_18_5_15 378011.1486972144
R14979 n_17_5_15 n_17_6_15 264.5424621592251
R14980 n_17_6_0 n_18_6_0 5400.159267103117
R14981 n_17_6_0 n_17_7_0 3.7791780308460767
R14982 n_17_6_0 n_17_6_1 436.49656102390486
R14983 n_17_6_1 n_18_6_1 7560.222973944361
R14984 n_17_6_1 n_17_7_1 5.290849243184507
R14985 n_17_6_1 n_17_6_2 992.0376386906928
R14986 n_17_6_2 n_18_6_2 13500.39816775779
R14987 n_17_6_2 n_17_7_2 9.447945077115193
R14988 n_17_6_2 n_17_6_3 928.5472298144884
R14989 n_17_6_3 n_18_6_3 189005.57434860888
R14990 n_17_6_3 n_17_7_3 132.27123107961256
R14991 n_17_6_3 n_17_6_4 12.34535728148419
R14992 n_17_6_4 n_18_6_4 5727.441646927542
R14993 n_17_6_4 n_17_7_4 4.008219123624623
R14994 n_17_6_15 n_18_6_15 378011.1486972144
R14995 n_17_6_15 n_17_7_15 264.54246215922274
R14996 n_17_7_0 n_18_7_0 5400.159267103211
R14997 n_17_7_0 n_17_8_0 110.44365038628541
R14998 n_17_7_0 n_17_7_1 436.4965610239126
R14999 n_17_7_1 n_18_7_1 7560.222973944496
R15000 n_17_7_1 n_17_8_1 154.62111054079955
R15001 n_17_7_1 n_17_7_2 992.0376386907103
R15002 n_17_7_2 n_18_7_2 13500.398167758029
R15003 n_17_7_2 n_17_8_2 276.10912596571353
R15004 n_17_7_2 n_17_7_3 928.5472298145049
R15005 n_17_7_3 n_18_7_3 189005.57434861225
R15006 n_17_7_3 n_17_8_3 3865.5277635199855
R15007 n_17_7_3 n_17_7_4 12.345357281484407
R15008 n_17_7_4 n_18_7_4 5727.441646927644
R15009 n_17_7_4 n_17_8_4 117.13720495515106
R15010 n_17_7_15 n_18_7_15 378011.1486972211
R15011 n_17_7_15 n_17_8_15 7731.055527039902
R15012 n_17_8_0 n_18_8_0 93.99999874525193
R15013 n_17_8_0 n_17_9_0 217.10812274172486
R15014 n_17_8_0 n_17_8_1 7.5980492720846176
R15015 n_17_8_1 n_18_8_1 131.59999824335267
R15016 n_17_8_1 n_17_9_1 303.95137183841473
R15017 n_17_8_1 n_17_8_2 17.268293800192314
R15018 n_17_8_2 n_18_8_2 234.9999968631298
R15019 n_17_8_2 n_17_9_2 542.7703068543121
R15020 n_17_8_2 n_17_8_3 16.163122996980004
R15021 n_17_8_3 n_18_8_3 3289.999956083814
R15022 n_17_8_3 n_17_9_3 7598.784295960362
R15023 n_17_8_3 n_17_8_4 0.2148943228468379
R15024 n_17_8_4 n_18_8_4 99.69696836617621
R15025 n_17_8_4 n_17_9_4 230.2661907866776
R15026 n_17_8_4 n_17_8_5 0.2148943228468379
R15027 n_17_8_5 n_18_8_5 3289.999956083814
R15028 n_17_8_5 n_17_9_5 7598.784295960362
R15029 n_17_8_5 n_17_8_6 0.41443905120461594
R15030 n_17_8_6 n_18_8_6 731.1111013519587
R15031 n_17_8_6 n_17_9_6 1688.618732435636
R15032 n_17_8_6 n_17_8_7 0.5832845905842736
R15033 n_17_8_7 n_18_8_7 1253.333316603362
R15034 n_17_8_7 n_17_9_7 2894.774969889671
R15035 n_17_8_7 n_17_8_8 0.4297886456936744
R15036 n_17_8_8 n_18_8_8 1253.333316603362
R15037 n_17_8_8 n_17_9_8 2894.774969889671
R15038 n_17_8_8 n_17_8_9 0.4297886456936744
R15039 n_17_8_9 n_18_8_9 1253.333316603362
R15040 n_17_8_9 n_17_9_9 2894.774969889671
R15041 n_17_8_9 n_17_8_10 0.4297886456936744
R15042 n_17_8_10 n_18_8_10 1253.333316603362
R15043 n_17_8_10 n_17_9_10 2894.774969889671
R15044 n_17_8_10 n_17_8_11 0.4297886456936717
R15045 n_17_8_11 n_18_8_11 1253.3333166033776
R15046 n_17_8_11 n_17_9_11 2894.7749698897073
R15047 n_17_8_11 n_17_8_12 0.4297886456936703
R15048 n_17_8_12 n_18_8_12 1253.3333166033697
R15049 n_17_8_12 n_17_9_12 2894.7749698896896
R15050 n_17_8_12 n_17_8_13 0.4297886456936745
R15051 n_17_8_13 n_18_8_13 1253.333316603354
R15052 n_17_8_13 n_17_9_13 2894.7749698896523
R15053 n_17_8_13 n_17_8_14 2.1489432284683776
R15054 n_17_8_14 n_18_8_14 139.25925740037323
R15055 n_17_8_14 n_17_9_14 321.64166332107385
R15056 n_17_8_14 n_17_8_15 11.143805599057531
R15057 n_17_8_15 n_18_8_15 6579.99991216757
R15058 n_17_8_15 n_17_9_15 15197.568591920586
R15059 n_17_9_0 n_18_9_0 93.99999874525186
R15060 n_17_9_0 n_17_10_0 217.10812274172486
R15061 n_17_9_0 n_17_9_1 7.598049272084614
R15062 n_17_9_1 n_18_9_1 131.59999824335262
R15063 n_17_9_1 n_17_10_1 303.95137183841473
R15064 n_17_9_1 n_17_9_2 17.268293800192303
R15065 n_17_9_2 n_18_9_2 234.99999686312967
R15066 n_17_9_2 n_17_10_2 542.7703068543121
R15067 n_17_9_2 n_17_9_3 16.163122996979993
R15068 n_17_9_3 n_18_9_3 3289.9999560838123
R15069 n_17_9_3 n_17_10_3 7598.784295960362
R15070 n_17_9_3 n_17_9_4 0.21489432284683777
R15071 n_17_9_4 n_18_9_4 99.69696836617614
R15072 n_17_9_4 n_17_10_4 230.2661907866776
R15073 n_17_9_4 n_17_9_5 0.21489432284683777
R15074 n_17_9_5 n_18_9_5 3289.9999560838123
R15075 n_17_9_5 n_17_10_5 7598.784295960362
R15076 n_17_9_5 n_17_9_6 0.41443905120461566
R15077 n_17_9_6 n_18_9_6 731.1111013519583
R15078 n_17_9_6 n_17_10_6 1688.618732435636
R15079 n_17_9_6 n_17_9_7 0.5832845905842732
R15080 n_17_9_7 n_18_9_7 1253.3333166033608
R15081 n_17_9_7 n_17_10_7 2894.774969889671
R15082 n_17_9_7 n_17_9_8 0.42978864569367414
R15083 n_17_9_8 n_18_9_8 1253.3333166033608
R15084 n_17_9_8 n_17_10_8 2894.774969889671
R15085 n_17_9_8 n_17_9_9 0.42978864569367414
R15086 n_17_9_9 n_18_9_9 1253.3333166033608
R15087 n_17_9_9 n_17_10_9 2894.774969889671
R15088 n_17_9_9 n_17_9_10 0.42978864569367414
R15089 n_17_9_10 n_18_9_10 1253.3333166033608
R15090 n_17_9_10 n_17_10_10 2894.774969889671
R15091 n_17_9_10 n_17_9_11 0.42978864569367137
R15092 n_17_9_11 n_18_9_11 1253.333316603377
R15093 n_17_9_11 n_17_10_11 2894.7749698897073
R15094 n_17_9_11 n_17_9_12 0.42978864569367004
R15095 n_17_9_12 n_18_9_12 1253.333316603369
R15096 n_17_9_12 n_17_10_12 2894.7749698896896
R15097 n_17_9_12 n_17_9_13 0.42978864569367414
R15098 n_17_9_13 n_18_9_13 1253.3333166033528
R15099 n_17_9_13 n_17_10_13 2894.7749698896523
R15100 n_17_9_13 n_17_9_14 2.1489432284683763
R15101 n_17_9_14 n_18_9_14 139.25925740037314
R15102 n_17_9_14 n_17_10_14 321.64166332107385
R15103 n_17_9_14 n_17_9_15 11.143805599057522
R15104 n_17_9_15 n_18_9_15 6579.999912167566
R15105 n_17_9_15 n_17_10_15 15197.568591920586
R15106 n_17_10_0 n_18_10_0 93.99999874525193
R15107 n_17_10_0 n_17_11_0 217.10812274172477
R15108 n_17_10_0 n_17_10_1 7.5980492720846176
R15109 n_17_10_1 n_18_10_1 131.59999824335267
R15110 n_17_10_1 n_17_11_1 303.9513718384146
R15111 n_17_10_1 n_17_10_2 17.268293800192314
R15112 n_17_10_2 n_18_10_2 234.9999968631298
R15113 n_17_10_2 n_17_11_2 542.7703068543119
R15114 n_17_10_2 n_17_10_3 16.163122996980004
R15115 n_17_10_3 n_18_10_3 3289.999956083814
R15116 n_17_10_3 n_17_11_3 7598.7842959603595
R15117 n_17_10_3 n_17_10_4 0.2148943228468379
R15118 n_17_10_4 n_18_10_4 99.69696836617621
R15119 n_17_10_4 n_17_11_4 230.26619078667753
R15120 n_17_10_4 n_17_10_5 0.2148943228468379
R15121 n_17_10_5 n_18_10_5 3289.999956083814
R15122 n_17_10_5 n_17_11_5 7598.7842959603595
R15123 n_17_10_5 n_17_10_6 0.41443905120461594
R15124 n_17_10_6 n_18_10_6 731.1111013519587
R15125 n_17_10_6 n_17_11_6 1688.6187324356354
R15126 n_17_10_6 n_17_10_7 0.5832845905842736
R15127 n_17_10_7 n_18_10_7 1253.333316603362
R15128 n_17_10_7 n_17_11_7 2894.77496988967
R15129 n_17_10_7 n_17_10_8 0.4297886456936744
R15130 n_17_10_8 n_18_10_8 1253.333316603362
R15131 n_17_10_8 n_17_11_8 2894.77496988967
R15132 n_17_10_8 n_17_10_9 0.4297886456936744
R15133 n_17_10_9 n_18_10_9 1253.333316603362
R15134 n_17_10_9 n_17_11_9 2894.77496988967
R15135 n_17_10_9 n_17_10_10 0.4297886456936744
R15136 n_17_10_10 n_18_10_10 1253.333316603362
R15137 n_17_10_10 n_17_11_10 2894.77496988967
R15138 n_17_10_10 n_17_10_11 0.4297886456936717
R15139 n_17_10_11 n_18_10_11 1253.3333166033776
R15140 n_17_10_11 n_17_11_11 2894.7749698897064
R15141 n_17_10_11 n_17_10_12 0.4297886456936703
R15142 n_17_10_12 n_18_10_12 1253.3333166033697
R15143 n_17_10_12 n_17_11_12 2894.7749698896887
R15144 n_17_10_12 n_17_10_13 0.4297886456936745
R15145 n_17_10_13 n_18_10_13 1253.333316603354
R15146 n_17_10_13 n_17_11_13 2894.7749698896514
R15147 n_17_10_13 n_17_10_14 2.1489432284683776
R15148 n_17_10_14 n_18_10_14 139.25925740037323
R15149 n_17_10_14 n_17_11_14 321.64166332107374
R15150 n_17_10_14 n_17_10_15 11.143805599057531
R15151 n_17_10_15 n_18_10_15 6579.99991216757
R15152 n_17_10_15 n_17_11_15 15197.568591920583
R15153 n_17_11_0 n_18_11_0 93.99999874525193
R15154 n_17_11_0 n_17_12_0 110.44365362970515
R15155 n_17_11_0 n_17_11_1 7.5980492720846176
R15156 n_17_11_1 n_18_11_1 131.59999824335267
R15157 n_17_11_1 n_17_12_1 154.62111508158716
R15158 n_17_11_1 n_17_11_2 17.268293800192314
R15159 n_17_11_2 n_18_11_2 234.9999968631298
R15160 n_17_11_2 n_17_12_2 276.10913407426284
R15161 n_17_11_2 n_17_11_3 16.163122996980004
R15162 n_17_11_3 n_18_11_3 3289.999956083814
R15163 n_17_11_3 n_17_12_3 3865.5278770396762
R15164 n_17_11_3 n_17_11_4 0.2148943228468379
R15165 n_17_11_4 n_18_11_4 99.69696836617621
R15166 n_17_11_4 n_17_12_4 117.1372083951417
R15167 n_17_11_4 n_17_11_5 0.2148943228468379
R15168 n_17_11_5 n_18_11_5 3289.999956083814
R15169 n_17_11_5 n_17_11_6 0.41443905120461594
R15170 n_17_11_6 n_18_11_6 731.1111013519587
R15171 n_17_11_6 n_17_11_7 0.5832845905842736
R15172 n_17_11_7 n_18_11_7 1253.333316603362
R15173 n_17_11_7 n_17_11_8 0.4297886456936744
R15174 n_17_11_8 n_18_11_8 1253.333316603362
R15175 n_17_11_8 n_17_11_9 0.4297886456936744
R15176 n_17_11_9 n_18_11_9 1253.333316603362
R15177 n_17_11_9 n_17_11_10 0.4297886456936744
R15178 n_17_11_10 n_18_11_10 1253.333316603362
R15179 n_17_11_10 n_17_11_11 0.4297886456936717
R15180 n_17_11_11 n_18_11_11 1253.3333166033776
R15181 n_17_11_11 n_17_11_12 0.4297886456936703
R15182 n_17_11_12 n_18_11_12 1253.3333166033697
R15183 n_17_11_12 n_17_11_13 0.4297886456936745
R15184 n_17_11_13 n_18_11_13 1253.333316603354
R15185 n_17_11_13 n_17_11_14 2.1489432284683776
R15186 n_17_11_14 n_18_11_14 139.25925740037323
R15187 n_17_11_14 n_17_11_15 11.143805599057531
R15188 n_17_11_15 n_18_11_15 6579.99991216757
R15189 n_17_11_15 n_17_12_15 7731.055754079283
R15190 n_17_12_0 n_18_12_0 5400.149997916646
R15191 n_17_12_0 n_17_13_0 3.7791845176855285
R15192 n_17_12_0 n_17_12_1 436.495811792666
R15193 n_17_12_1 n_18_12_1 7560.209997083304
R15194 n_17_12_1 n_17_13_1 5.290858324759739
R15195 n_17_12_1 n_17_12_2 992.0359358924229
R15196 n_17_12_2 n_18_12_2 13500.374994791617
R15197 n_17_12_2 n_17_13_2 9.447961294213822
R15198 n_17_12_2 n_17_12_3 928.5456359953077
R15199 n_17_12_3 n_18_12_3 189005.24992708245
R15200 n_17_12_3 n_17_13_3 132.27145811899337
R15201 n_17_12_3 n_17_12_4 12.345336091105716
R15202 n_17_12_4 n_18_12_4 5727.431815972196
R15203 n_17_12_4 n_17_13_4 4.008226003605859
R15204 n_17_12_15 n_18_12_15 378010.4998541616
R15205 n_17_12_15 n_17_13_15 264.54291623798434
R15206 n_17_13_0 n_18_13_0 5400.149997916646
R15207 n_17_13_0 n_17_14_0 3.7791845176855285
R15208 n_17_13_0 n_17_13_1 436.495811792666
R15209 n_17_13_1 n_18_13_1 7560.209997083304
R15210 n_17_13_1 n_17_14_1 5.290858324759739
R15211 n_17_13_1 n_17_13_2 992.0359358924229
R15212 n_17_13_2 n_18_13_2 13500.374994791617
R15213 n_17_13_2 n_17_14_2 9.447961294213822
R15214 n_17_13_2 n_17_13_3 928.5456359953077
R15215 n_17_13_3 n_18_13_3 189005.24992708245
R15216 n_17_13_3 n_17_14_3 132.27145811899337
R15217 n_17_13_3 n_17_13_4 12.345336091105716
R15218 n_17_13_4 n_18_13_4 5727.431815972196
R15219 n_17_13_4 n_17_14_4 4.008226003605859
R15220 n_17_13_15 n_18_13_15 378010.4998541616
R15221 n_17_13_15 n_17_14_15 264.54291623798434
R15222 n_17_14_0 n_18_14_0 5400.149997916646
R15223 n_17_14_0 n_17_15_0 3.7791845176855285
R15224 n_17_14_0 n_17_14_1 436.495811792666
R15225 n_17_14_1 n_18_14_1 7560.209997083304
R15226 n_17_14_1 n_17_15_1 5.290858324759739
R15227 n_17_14_1 n_17_14_2 992.0359358924229
R15228 n_17_14_2 n_18_14_2 13500.374994791617
R15229 n_17_14_2 n_17_15_2 9.447961294213822
R15230 n_17_14_2 n_17_14_3 928.5456359953077
R15231 n_17_14_3 n_18_14_3 189005.24992708245
R15232 n_17_14_3 n_17_15_3 132.27145811899337
R15233 n_17_14_3 n_17_14_4 12.345336091105716
R15234 n_17_14_4 n_18_14_4 5727.431815972196
R15235 n_17_14_4 n_17_15_4 4.008226003605859
R15236 n_17_14_15 n_18_14_15 378010.4998541616
R15237 n_17_14_15 n_17_15_15 264.54291623798434
R15238 n_17_15_0 n_18_15_0 5400.149997916646
R15239 n_17_15_0 n_17_16_0 110.44365362970508
R15240 n_17_15_0 n_17_15_1 436.495811792666
R15241 n_17_15_1 n_18_15_1 7560.209997083304
R15242 n_17_15_1 n_17_16_1 154.6211150815871
R15243 n_17_15_1 n_17_15_2 992.0359358924229
R15244 n_17_15_2 n_18_15_2 13500.374994791617
R15245 n_17_15_2 n_17_16_2 276.10913407426267
R15246 n_17_15_2 n_17_15_3 928.5456359953077
R15247 n_17_15_3 n_18_15_3 189005.24992708245
R15248 n_17_15_3 n_17_16_3 3865.527877039674
R15249 n_17_15_3 n_17_15_4 12.345336091105716
R15250 n_17_15_4 n_18_15_4 5727.431815972196
R15251 n_17_15_4 n_17_16_4 117.13720839514164
R15252 n_17_15_15 n_18_15_15 378010.4998541616
R15253 n_17_15_15 n_17_16_15 7731.055754079279
R15254 n_17_16_0 n_18_16_0 93.999998745252
R15255 n_17_16_0 n_17_17_0 217.10812274172477
R15256 n_17_16_0 n_17_16_1 7.598049272084623
R15257 n_17_16_1 n_18_16_1 131.59999824335276
R15258 n_17_16_1 n_17_17_1 303.9513718384146
R15259 n_17_16_1 n_17_16_2 17.26829380019233
R15260 n_17_16_2 n_18_16_2 234.99999686312995
R15261 n_17_16_2 n_17_17_2 542.7703068543119
R15262 n_17_16_2 n_17_16_3 16.163122996980018
R15263 n_17_16_3 n_18_16_3 3289.999956083816
R15264 n_17_16_3 n_17_17_3 7598.7842959603595
R15265 n_17_16_3 n_17_16_4 0.21489432284683804
R15266 n_17_16_4 n_18_16_4 99.69696836617624
R15267 n_17_16_4 n_17_17_4 230.26619078667756
R15268 n_17_16_4 n_17_16_5 0.21489432284683804
R15269 n_17_16_5 n_18_16_5 3289.999956083816
R15270 n_17_16_5 n_17_17_5 7598.7842959603595
R15271 n_17_16_5 n_17_16_6 0.4144390512046162
R15272 n_17_16_6 n_18_16_6 731.1111013519592
R15273 n_17_16_6 n_17_17_6 1688.6187324356356
R15274 n_17_16_6 n_17_16_7 0.5832845905842741
R15275 n_17_16_7 n_18_16_7 1253.3333166033626
R15276 n_17_16_7 n_17_17_7 2894.77496988967
R15277 n_17_16_7 n_17_16_8 0.42978864569367475
R15278 n_17_16_8 n_18_16_8 1253.3333166033626
R15279 n_17_16_8 n_17_17_8 2894.77496988967
R15280 n_17_16_8 n_17_16_9 0.42978864569367475
R15281 n_17_16_9 n_18_16_9 1253.3333166033626
R15282 n_17_16_9 n_17_17_9 2894.77496988967
R15283 n_17_16_9 n_17_16_10 0.42978864569367475
R15284 n_17_16_10 n_18_16_10 1253.3333166033626
R15285 n_17_16_10 n_17_17_10 2894.77496988967
R15286 n_17_16_10 n_17_16_11 0.42978864569367203
R15287 n_17_16_11 n_18_16_11 1253.3333166033783
R15288 n_17_16_11 n_17_17_11 2894.7749698897064
R15289 n_17_16_11 n_17_16_12 0.4297886456936706
R15290 n_17_16_12 n_18_16_12 1253.3333166033706
R15291 n_17_16_12 n_17_17_12 2894.7749698896887
R15292 n_17_16_12 n_17_16_13 0.4297886456936747
R15293 n_17_16_13 n_18_16_13 1253.3333166033547
R15294 n_17_16_13 n_17_17_13 2894.7749698896514
R15295 n_17_16_13 n_17_16_14 2.148943228468379
R15296 n_17_16_14 n_18_16_14 139.25925740037331
R15297 n_17_16_14 n_17_17_14 321.6416633210738
R15298 n_17_16_14 n_17_16_15 11.14380559905754
R15299 n_17_16_15 n_18_16_15 6579.999912167574
R15300 n_17_16_15 n_17_17_15 15197.568591920583
R15301 n_17_17_0 n_18_17_0 93.99999874525186
R15302 n_17_17_0 n_17_18_0 217.1081227417249
R15303 n_17_17_0 n_17_17_1 7.598049272084614
R15304 n_17_17_1 n_18_17_1 131.59999824335262
R15305 n_17_17_1 n_17_18_1 303.95137183841484
R15306 n_17_17_1 n_17_17_2 17.268293800192303
R15307 n_17_17_2 n_18_17_2 234.99999686312967
R15308 n_17_17_2 n_17_18_2 542.7703068543123
R15309 n_17_17_2 n_17_17_3 16.163122996979993
R15310 n_17_17_3 n_18_17_3 3289.9999560838123
R15311 n_17_17_3 n_17_18_3 7598.784295960364
R15312 n_17_17_3 n_17_17_4 0.21489432284683777
R15313 n_17_17_4 n_18_17_4 99.69696836617614
R15314 n_17_17_4 n_17_18_4 230.26619078667767
R15315 n_17_17_4 n_17_17_5 0.21489432284683777
R15316 n_17_17_5 n_18_17_5 3289.9999560838123
R15317 n_17_17_5 n_17_18_5 7598.784295960364
R15318 n_17_17_5 n_17_17_6 0.41443905120461566
R15319 n_17_17_6 n_18_17_6 731.1111013519583
R15320 n_17_17_6 n_17_18_6 1688.6187324356365
R15321 n_17_17_6 n_17_17_7 0.5832845905842732
R15322 n_17_17_7 n_18_17_7 1253.3333166033608
R15323 n_17_17_7 n_17_18_7 2894.774969889672
R15324 n_17_17_7 n_17_17_8 0.42978864569367414
R15325 n_17_17_8 n_18_17_8 1253.3333166033608
R15326 n_17_17_8 n_17_18_8 2894.774969889672
R15327 n_17_17_8 n_17_17_9 0.42978864569367414
R15328 n_17_17_9 n_18_17_9 1253.3333166033608
R15329 n_17_17_9 n_17_18_9 2894.774969889672
R15330 n_17_17_9 n_17_17_10 0.42978864569367414
R15331 n_17_17_10 n_18_17_10 1253.3333166033608
R15332 n_17_17_10 n_17_18_10 2894.774969889672
R15333 n_17_17_10 n_17_17_11 0.42978864569367137
R15334 n_17_17_11 n_18_17_11 1253.333316603377
R15335 n_17_17_11 n_17_18_11 2894.7749698897082
R15336 n_17_17_11 n_17_17_12 0.42978864569367004
R15337 n_17_17_12 n_18_17_12 1253.333316603369
R15338 n_17_17_12 n_17_18_12 2894.7749698896905
R15339 n_17_17_12 n_17_17_13 0.42978864569367414
R15340 n_17_17_13 n_18_17_13 1253.3333166033528
R15341 n_17_17_13 n_17_18_13 2894.774969889653
R15342 n_17_17_13 n_17_17_14 2.1489432284683763
R15343 n_17_17_14 n_18_17_14 139.25925740037314
R15344 n_17_17_14 n_17_18_14 321.64166332107396
R15345 n_17_17_14 n_17_17_15 11.143805599057522
R15346 n_17_17_15 n_18_17_15 6579.999912167566
R15347 n_17_17_15 n_17_18_15 15197.568591920592
R15348 n_17_18_0 n_18_18_0 93.99999874525186
R15349 n_17_18_0 n_17_19_0 217.10812274172477
R15350 n_17_18_0 n_17_18_1 7.598049272084614
R15351 n_17_18_1 n_18_18_1 131.59999824335262
R15352 n_17_18_1 n_17_19_1 303.9513718384146
R15353 n_17_18_1 n_17_18_2 17.268293800192303
R15354 n_17_18_2 n_18_18_2 234.99999686312967
R15355 n_17_18_2 n_17_19_2 542.7703068543119
R15356 n_17_18_2 n_17_18_3 16.163122996979993
R15357 n_17_18_3 n_18_18_3 3289.9999560838123
R15358 n_17_18_3 n_17_19_3 7598.7842959603595
R15359 n_17_18_3 n_17_18_4 0.21489432284683777
R15360 n_17_18_4 n_18_18_4 99.69696836617614
R15361 n_17_18_4 n_17_19_4 230.26619078667756
R15362 n_17_18_4 n_17_18_5 0.21489432284683777
R15363 n_17_18_5 n_18_18_5 3289.9999560838123
R15364 n_17_18_5 n_17_19_5 7598.7842959603595
R15365 n_17_18_5 n_17_18_6 0.41443905120461566
R15366 n_17_18_6 n_18_18_6 731.1111013519583
R15367 n_17_18_6 n_17_19_6 1688.6187324356356
R15368 n_17_18_6 n_17_18_7 0.5832845905842732
R15369 n_17_18_7 n_18_18_7 1253.3333166033608
R15370 n_17_18_7 n_17_19_7 2894.77496988967
R15371 n_17_18_7 n_17_18_8 0.42978864569367414
R15372 n_17_18_8 n_18_18_8 1253.3333166033608
R15373 n_17_18_8 n_17_19_8 2894.77496988967
R15374 n_17_18_8 n_17_18_9 0.42978864569367414
R15375 n_17_18_9 n_18_18_9 1253.3333166033608
R15376 n_17_18_9 n_17_19_9 2894.77496988967
R15377 n_17_18_9 n_17_18_10 0.42978864569367414
R15378 n_17_18_10 n_18_18_10 1253.3333166033608
R15379 n_17_18_10 n_17_19_10 2894.77496988967
R15380 n_17_18_10 n_17_18_11 0.42978864569367137
R15381 n_17_18_11 n_18_18_11 1253.333316603377
R15382 n_17_18_11 n_17_19_11 2894.7749698897064
R15383 n_17_18_11 n_17_18_12 0.42978864569367004
R15384 n_17_18_12 n_18_18_12 1253.333316603369
R15385 n_17_18_12 n_17_19_12 2894.7749698896887
R15386 n_17_18_12 n_17_18_13 0.42978864569367414
R15387 n_17_18_13 n_18_18_13 1253.3333166033528
R15388 n_17_18_13 n_17_19_13 2894.7749698896514
R15389 n_17_18_13 n_17_18_14 2.1489432284683763
R15390 n_17_18_14 n_18_18_14 139.25925740037314
R15391 n_17_18_14 n_17_19_14 321.6416633210738
R15392 n_17_18_14 n_17_18_15 11.143805599057522
R15393 n_17_18_15 n_18_18_15 6579.999912167566
R15394 n_17_18_15 n_17_19_15 15197.568591920583
R15395 n_17_19_0 n_18_19_0 93.999998745252
R15396 n_17_19_0 n_17_20_0 110.44365397508223
R15397 n_17_19_0 n_17_19_1 7.598049272084623
R15398 n_17_19_1 n_18_19_1 131.59999824335276
R15399 n_17_19_1 n_17_20_1 154.6211155651151
R15400 n_17_19_1 n_17_19_2 17.26829380019233
R15401 n_17_19_2 n_18_19_2 234.99999686312995
R15402 n_17_19_2 n_17_20_2 276.10913493770556
R15403 n_17_19_2 n_17_19_3 16.163122996980018
R15404 n_17_19_3 n_18_19_3 3289.999956083816
R15405 n_17_19_3 n_17_20_3 3865.5278891278745
R15406 n_17_19_3 n_17_19_4 0.21489432284683804
R15407 n_17_19_4 n_18_19_4 99.69696836617624
R15408 n_17_19_4 n_17_20_4 117.13720876145074
R15409 n_17_19_4 n_17_19_5 0.21489432284683804
R15410 n_17_19_5 n_18_19_5 3289.999956083816
R15411 n_17_19_5 n_17_19_6 0.4144390512046162
R15412 n_17_19_6 n_18_19_6 731.1111013519592
R15413 n_17_19_6 n_17_19_7 0.5832845905842741
R15414 n_17_19_7 n_18_19_7 1253.3333166033626
R15415 n_17_19_7 n_17_19_8 0.42978864569367475
R15416 n_17_19_8 n_18_19_8 1253.3333166033626
R15417 n_17_19_8 n_17_19_9 0.42978864569367475
R15418 n_17_19_9 n_18_19_9 1253.3333166033626
R15419 n_17_19_9 n_17_19_10 0.42978864569367475
R15420 n_17_19_10 n_18_19_10 1253.3333166033626
R15421 n_17_19_10 n_17_19_11 0.42978864569367203
R15422 n_17_19_11 n_18_19_11 1253.3333166033783
R15423 n_17_19_11 n_17_19_12 0.4297886456936706
R15424 n_17_19_12 n_18_19_12 1253.3333166033706
R15425 n_17_19_12 n_17_19_13 0.4297886456936747
R15426 n_17_19_13 n_18_19_13 1253.3333166033547
R15427 n_17_19_13 n_17_19_14 2.148943228468379
R15428 n_17_19_14 n_18_19_14 139.25925740037331
R15429 n_17_19_14 n_17_19_15 11.14380559905754
R15430 n_17_19_15 n_18_19_15 6579.999912167574
R15431 n_17_19_15 n_17_20_15 7731.055778255679
R15432 n_17_20_0 n_18_20_0 5400.149010884628
R15433 n_17_20_0 n_17_21_0 3.7791852084398228
R15434 n_17_20_0 n_17_20_1 436.49573201055955
R15435 n_17_20_1 n_18_20_1 7560.208615238478
R15436 n_17_20_1 n_17_21_1 5.290859291815751
R15437 n_17_20_1 n_17_20_2 992.0357545694536
R15438 n_17_20_2 n_18_20_2 13500.372527211573
R15439 n_17_20_2 n_17_21_2 9.447963021099557
R15440 n_17_20_2 n_17_20_3 928.5454662770086
R15441 n_17_20_3 n_18_20_3 189005.2153809618
R15442 n_17_20_3 n_17_21_3 132.27148229539367
R15443 n_17_20_3 n_17_20_4 12.345333834642101
R15444 n_17_20_4 n_18_20_4 5727.430769120056
R15445 n_17_20_4 n_17_21_4 4.00822673622405
R15446 n_17_20_15 n_18_20_15 378010.43076192023
R15447 n_17_20_15 n_17_21_15 264.54296459078495
R15448 n_17_21_0 n_18_21_0 5400.149010884628
R15449 n_17_21_0 n_17_22_0 3.7791852084396886
R15450 n_17_21_0 n_17_21_1 436.49573201055955
R15451 n_17_21_1 n_18_21_1 7560.208615238478
R15452 n_17_21_1 n_17_22_1 5.290859291815563
R15453 n_17_21_1 n_17_21_2 992.0357545694536
R15454 n_17_21_2 n_18_21_2 13500.372527211573
R15455 n_17_21_2 n_17_22_2 9.447963021099222
R15456 n_17_21_2 n_17_21_3 928.5454662770086
R15457 n_17_21_3 n_18_21_3 189005.2153809618
R15458 n_17_21_3 n_17_22_3 132.27148229538898
R15459 n_17_21_3 n_17_21_4 12.345333834642101
R15460 n_17_21_4 n_18_21_4 5727.430769120056
R15461 n_17_21_4 n_17_22_4 4.008226736223907
R15462 n_17_21_15 n_18_21_15 378010.43076192023
R15463 n_17_21_15 n_17_22_15 264.54296459077557
R15464 n_17_22_0 n_18_22_0 5400.149010885012
R15465 n_17_22_0 n_17_23_0 3.7791852084396886
R15466 n_17_22_0 n_17_22_1 436.4957320105906
R15467 n_17_22_1 n_18_22_1 7560.208615239017
R15468 n_17_22_1 n_17_23_1 5.290859291815563
R15469 n_17_22_1 n_17_22_2 992.0357545695241
R15470 n_17_22_2 n_18_22_2 13500.37252721253
R15471 n_17_22_2 n_17_23_2 9.447963021099222
R15472 n_17_22_2 n_17_22_3 928.5454662770746
R15473 n_17_22_3 n_18_22_3 189005.21538097525
R15474 n_17_22_3 n_17_23_3 132.27148229538898
R15475 n_17_22_3 n_17_22_4 12.345333834642977
R15476 n_17_22_4 n_18_22_4 5727.430769120462
R15477 n_17_22_4 n_17_23_4 4.008226736223907
R15478 n_17_22_15 n_18_22_15 378010.4307619471
R15479 n_17_22_15 n_17_23_15 264.54296459077557
R15480 n_17_23_0 n_18_23_0 5400.149010884628
R15481 n_17_23_0 n_17_24_0 43.561715139231126
R15482 n_17_23_0 n_17_23_1 436.49573201055955
R15483 n_17_23_1 n_18_23_1 7560.208615238478
R15484 n_17_23_1 n_17_24_1 60.986401194923566
R15485 n_17_23_1 n_17_23_2 992.0357545694536
R15486 n_17_23_2 n_18_23_2 13500.372527211573
R15487 n_17_23_2 n_17_24_2 108.90428784807781
R15488 n_17_23_2 n_17_23_3 928.5454662770086
R15489 n_17_23_3 n_18_23_3 189005.2153809618
R15490 n_17_23_3 n_17_24_3 1524.6600298730878
R15491 n_17_23_3 n_17_23_4 12.345333834642101
R15492 n_17_23_4 n_18_23_4 5727.430769120056
R15493 n_17_23_4 n_17_24_4 46.20181908706326
R15494 n_17_23_15 n_18_23_15 378010.43076192023
R15495 n_17_23_15 n_17_24_15 3049.3200597461487
R15496 n_17_24_0 n_18_24_0 244.86589623746696
R15497 n_17_24_0 n_17_25_0 83.34424507002228
R15498 n_17_24_0 n_17_24_1 19.792586909576
R15499 n_17_24_1 n_18_24_1 342.8122547324537
R15500 n_17_24_1 n_17_25_1 116.6819430980312
R15501 n_17_24_1 n_17_24_2 44.98315206721817
R15502 n_17_24_2 n_18_24_2 612.1647405936674
R15503 n_17_24_2 n_17_25_2 208.36061267505573
R15504 n_17_24_2 n_17_24_3 42.10423033491621
R15505 n_17_24_3 n_18_24_3 8570.306368311336
R15506 n_17_24_3 n_17_25_3 2917.0485774507774
R15507 n_17_24_3 n_17_24_4 0.5597903368364934
R15508 n_17_24_4 n_18_24_4 259.706253585192
R15509 n_17_24_4 n_17_25_4 88.39541143790234
R15510 n_17_24_4 n_17_24_5 0.46268384983424454
R15511 n_17_24_5 n_18_24_5 1632.4393082497784
R15512 n_17_24_5 n_17_25_5 555.6283004668147
R15513 n_17_24_5 n_17_24_6 0.1599400962389981
R15514 n_17_24_6 n_18_24_6 272.0732180416297
R15515 n_17_24_6 n_17_25_6 92.60471674446912
R15516 n_17_24_6 n_17_24_7 0.21706155918149717
R15517 n_17_24_7 n_18_24_7 466.4112309285095
R15518 n_17_24_7 n_17_25_7 158.75094299051898
R15519 n_17_24_7 n_17_24_8 0.1599400962389976
R15520 n_17_24_8 n_18_24_8 466.4112309285095
R15521 n_17_24_8 n_17_25_8 158.75094299051898
R15522 n_17_24_8 n_17_24_9 0.1599400962389976
R15523 n_17_24_9 n_18_24_9 466.4112309285095
R15524 n_17_24_9 n_17_25_9 158.75094299051898
R15525 n_17_24_9 n_17_24_10 0.1599400962389976
R15526 n_17_24_10 n_18_24_10 466.4112309285095
R15527 n_17_24_10 n_17_25_10 158.75094299051898
R15528 n_17_24_10 n_17_24_11 0.15994009623899658
R15529 n_17_24_11 n_18_24_11 466.4112309285154
R15530 n_17_24_11 n_17_25_11 158.75094299052103
R15531 n_17_24_11 n_17_24_12 0.15994009623899608
R15532 n_17_24_12 n_18_24_12 466.4112309285125
R15533 n_17_24_12 n_17_25_12 158.75094299052
R15534 n_17_24_12 n_17_24_13 0.1599400962389976
R15535 n_17_24_13 n_18_24_13 466.41123092850654
R15536 n_17_24_13 n_17_25_13 158.75094299051796
R15537 n_17_24_13 n_17_24_14 0.7997004811949899
R15538 n_17_24_14 n_18_24_14 51.82347010316761
R15539 n_17_24_14 n_17_25_14 17.638993665613185
R15540 n_17_24_14 n_17_24_15 24.710744868925417
R15541 n_17_24_15 n_18_24_15 17140.612736622516
R15542 n_17_24_15 n_17_25_15 5834.097154901503
R15543 n_17_25_0 n_18_25_0 244.86589623746775
R15544 n_17_25_0 n_17_26_0 83.34424507002228
R15545 n_17_25_0 n_17_25_1 19.792586909576062
R15546 n_17_25_1 n_18_25_1 342.8122547324548
R15547 n_17_25_1 n_17_26_1 116.6819430980312
R15548 n_17_25_1 n_17_25_2 44.98315206721832
R15549 n_17_25_2 n_18_25_2 612.1647405936693
R15550 n_17_25_2 n_17_26_2 208.36061267505573
R15551 n_17_25_2 n_17_25_3 42.10423033491635
R15552 n_17_25_3 n_18_25_3 8570.306368311363
R15553 n_17_25_3 n_17_26_3 2917.0485774507774
R15554 n_17_25_3 n_17_25_4 0.5597903368364952
R15555 n_17_25_4 n_18_25_4 259.7062535851928
R15556 n_17_25_4 n_17_26_4 88.39541143790234
R15557 n_17_25_4 n_17_25_5 0.46268384983424593
R15558 n_17_25_5 n_18_25_5 1632.4393082497834
R15559 n_17_25_5 n_17_26_5 555.6283004668147
R15560 n_17_25_5 n_17_25_6 0.1599400962389986
R15561 n_17_25_6 n_18_25_6 272.0732180416306
R15562 n_17_25_6 n_17_26_6 92.60471674446912
R15563 n_17_25_6 n_17_25_7 0.21706155918149783
R15564 n_17_25_7 n_18_25_7 466.41123092851103
R15565 n_17_25_7 n_17_26_7 158.75094299051898
R15566 n_17_25_7 n_17_25_8 0.1599400962389981
R15567 n_17_25_8 n_18_25_8 466.41123092851103
R15568 n_17_25_8 n_17_26_8 158.75094299051898
R15569 n_17_25_8 n_17_25_9 0.1599400962389981
R15570 n_17_25_9 n_18_25_9 466.41123092851103
R15571 n_17_25_9 n_17_26_9 158.75094299051898
R15572 n_17_25_9 n_17_25_10 0.1599400962389981
R15573 n_17_25_10 n_18_25_10 466.41123092851103
R15574 n_17_25_10 n_17_26_10 158.75094299051898
R15575 n_17_25_10 n_17_25_11 0.15994009623899708
R15576 n_17_25_11 n_18_25_11 466.411230928517
R15577 n_17_25_11 n_17_26_11 158.75094299052103
R15578 n_17_25_11 n_17_25_12 0.15994009623899658
R15579 n_17_25_12 n_18_25_12 466.4112309285139
R15580 n_17_25_12 n_17_26_12 158.75094299052
R15581 n_17_25_12 n_17_25_13 0.1599400962389981
R15582 n_17_25_13 n_18_25_13 466.41123092850813
R15583 n_17_25_13 n_17_26_13 158.75094299051796
R15584 n_17_25_13 n_17_25_14 0.7997004811949925
R15585 n_17_25_14 n_18_25_14 51.82347010316777
R15586 n_17_25_14 n_17_26_14 17.638993665613185
R15587 n_17_25_14 n_17_25_15 24.7107448689255
R15588 n_17_25_15 n_18_25_15 17140.612736622574
R15589 n_17_25_15 n_17_26_15 5834.097154901503
R15590 n_17_26_0 n_18_26_0 244.86589623746696
R15591 n_17_26_0 n_17_27_0 83.34424507002242
R15592 n_17_26_0 n_17_26_1 19.792586909576
R15593 n_17_26_1 n_18_26_1 342.8122547324537
R15594 n_17_26_1 n_17_27_1 116.68194309803138
R15595 n_17_26_1 n_17_26_2 44.98315206721817
R15596 n_17_26_2 n_18_26_2 612.1647405936674
R15597 n_17_26_2 n_17_27_2 208.36061267505607
R15598 n_17_26_2 n_17_26_3 42.10423033491621
R15599 n_17_26_3 n_18_26_3 8570.306368311336
R15600 n_17_26_3 n_17_27_3 2917.048577450782
R15601 n_17_26_3 n_17_26_4 0.5597903368364934
R15602 n_17_26_4 n_18_26_4 259.706253585192
R15603 n_17_26_4 n_17_27_4 88.39541143790247
R15604 n_17_26_4 n_17_26_5 0.46268384983424454
R15605 n_17_26_5 n_18_26_5 1632.4393082497784
R15606 n_17_26_5 n_17_27_5 555.6283004668156
R15607 n_17_26_5 n_17_26_6 0.1599400962389981
R15608 n_17_26_6 n_18_26_6 272.0732180416297
R15609 n_17_26_6 n_17_27_6 92.60471674446926
R15610 n_17_26_6 n_17_26_7 0.21706155918149717
R15611 n_17_26_7 n_18_26_7 466.4112309285095
R15612 n_17_26_7 n_17_27_7 158.75094299051923
R15613 n_17_26_7 n_17_26_8 0.1599400962389976
R15614 n_17_26_8 n_18_26_8 466.4112309285095
R15615 n_17_26_8 n_17_27_8 158.75094299051923
R15616 n_17_26_8 n_17_26_9 0.1599400962389976
R15617 n_17_26_9 n_18_26_9 466.4112309285095
R15618 n_17_26_9 n_17_27_9 158.75094299051923
R15619 n_17_26_9 n_17_26_10 0.1599400962389976
R15620 n_17_26_10 n_18_26_10 466.4112309285095
R15621 n_17_26_10 n_17_27_10 158.75094299051923
R15622 n_17_26_10 n_17_26_11 0.15994009623899658
R15623 n_17_26_11 n_18_26_11 466.4112309285154
R15624 n_17_26_11 n_17_27_11 158.75094299052125
R15625 n_17_26_11 n_17_26_12 0.15994009623899608
R15626 n_17_26_12 n_18_26_12 466.4112309285125
R15627 n_17_26_12 n_17_27_12 158.75094299052026
R15628 n_17_26_12 n_17_26_13 0.1599400962389976
R15629 n_17_26_13 n_18_26_13 466.41123092850654
R15630 n_17_26_13 n_17_27_13 158.7509429905182
R15631 n_17_26_13 n_17_26_14 0.7997004811949899
R15632 n_17_26_14 n_18_26_14 51.82347010316761
R15633 n_17_26_14 n_17_27_14 17.63899366561321
R15634 n_17_26_14 n_17_26_15 24.710744868925417
R15635 n_17_26_15 n_18_26_15 17140.612736622516
R15636 n_17_26_15 n_17_27_15 5834.097154901512
R15637 n_17_27_0 n_18_27_0 244.86589623746696
R15638 n_17_27_0 n_17_27_1 19.792586909576
R15639 n_17_27_1 n_18_27_1 342.8122547324537
R15640 n_17_27_1 n_17_27_2 44.98315206721817
R15641 n_17_27_2 n_18_27_2 612.1647405936674
R15642 n_17_27_2 n_17_27_3 42.10423033491621
R15643 n_17_27_3 n_18_27_3 8570.306368311336
R15644 n_17_27_3 n_17_27_4 0.5597903368364934
R15645 n_17_27_4 n_18_27_4 259.706253585192
R15646 n_17_27_4 n_17_27_5 0.46268384983424454
R15647 n_17_27_5 n_18_27_5 1632.4393082497784
R15648 n_17_27_5 n_17_27_6 0.1599400962389981
R15649 n_17_27_6 n_18_27_6 272.0732180416297
R15650 n_17_27_6 n_17_27_7 0.21706155918149717
R15651 n_17_27_7 n_18_27_7 466.4112309285095
R15652 n_17_27_7 n_17_27_8 0.1599400962389976
R15653 n_17_27_8 n_18_27_8 466.4112309285095
R15654 n_17_27_8 n_17_27_9 0.1599400962389976
R15655 n_17_27_9 n_18_27_9 466.4112309285095
R15656 n_17_27_9 n_17_27_10 0.1599400962389976
R15657 n_17_27_10 n_18_27_10 466.4112309285095
R15658 n_17_27_10 n_17_27_11 0.15994009623899658
R15659 n_17_27_11 n_18_27_11 466.4112309285154
R15660 n_17_27_11 n_17_27_12 0.15994009623899608
R15661 n_17_27_12 n_18_27_12 466.4112309285125
R15662 n_17_27_12 n_17_27_13 0.1599400962389976
R15663 n_17_27_13 n_18_27_13 466.41123092850654
R15664 n_17_27_13 n_17_27_14 0.7997004811949899
R15665 n_17_27_14 n_18_27_14 51.82347010316761
R15666 n_17_27_14 n_17_27_15 24.710744868925417
R15667 n_17_27_15 n_18_27_15 17140.612736622516
R15668 n_18_0_0 n_19_0_0 244.86587514965555
R15669 n_18_0_0 n_18_1_0 83.34425224761601
R15670 n_18_0_0 n_18_0_1 19.792585205041597
R15671 n_18_0_1 n_19_0_1 342.8122252095177
R15672 n_18_0_1 n_18_1_1 116.6819531466624
R15673 n_18_0_1 n_18_0_2 44.98314819327637
R15674 n_18_0_2 n_19_0_2 612.1646878741388
R15675 n_18_0_2 n_18_1_2 208.36063061904002
R15676 n_18_0_2 n_18_0_3 42.10422670890668
R15677 n_18_0_3 n_19_0_3 8570.305630237934
R15678 n_18_0_3 n_18_1_3 2917.0488286665573
R15679 n_18_0_3 n_18_0_4 0.5597902886274397
R15680 n_18_0_4 n_19_0_4 259.70623121933136
R15681 n_18_0_4 n_18_1_4 88.39541905050173
R15682 n_18_0_4 n_18_0_5 0.4626838099879859
R15683 n_18_0_5 n_19_0_5 1632.4391676643686
R15684 n_18_0_5 n_18_1_5 555.6283483174395
R15685 n_18_0_5 n_18_0_6 0.15994008246498279
R15686 n_18_0_6 n_19_0_6 272.07319461072814
R15687 n_18_0_6 n_18_1_6 92.60472471957324
R15688 n_18_0_6 n_18_0_7 0.21706154048819065
R15689 n_18_0_7 n_19_0_7 466.41119076124966
R15690 n_18_0_7 n_18_1_7 158.75095666212607
R15691 n_18_0_7 n_18_0_8 0.15994008246498229
R15692 n_18_0_8 n_19_0_8 466.41119076124966
R15693 n_18_0_8 n_18_1_8 158.75095666212607
R15694 n_18_0_8 n_18_0_9 0.15994008246498229
R15695 n_18_0_9 n_19_0_9 466.41119076124966
R15696 n_18_0_9 n_18_1_9 158.75095666212607
R15697 n_18_0_9 n_18_0_10 0.15994008246498229
R15698 n_18_0_10 n_19_0_10 466.41119076124966
R15699 n_18_0_10 n_18_1_10 158.75095666212607
R15700 n_18_0_10 n_18_0_11 0.15994008246498126
R15701 n_18_0_11 n_19_0_11 466.4111907612556
R15702 n_18_0_11 n_18_1_11 158.7509566621281
R15703 n_18_0_11 n_18_0_12 0.15994008246498076
R15704 n_18_0_12 n_19_0_12 466.4111907612528
R15705 n_18_0_12 n_18_1_12 158.75095666212707
R15706 n_18_0_12 n_18_0_13 0.15994008246498226
R15707 n_18_0_13 n_19_0_13 466.41119076124676
R15708 n_18_0_13 n_18_1_13 158.75095666212505
R15709 n_18_0_13 n_18_0_14 0.7997004123249134
R15710 n_18_0_14 n_19_0_14 51.82346564013874
R15711 n_18_0_14 n_18_1_14 17.638995184680635
R15712 n_18_0_14 n_18_0_15 24.71074274084005
R15713 n_18_0_15 n_19_0_15 17140.61126047572
R15714 n_18_0_15 n_18_1_15 5834.097657333063
R15715 n_18_1_0 n_19_1_0 244.86587514965555
R15716 n_18_1_0 n_18_2_0 83.34425224761601
R15717 n_18_1_0 n_18_1_1 19.792585205041597
R15718 n_18_1_1 n_19_1_1 342.8122252095177
R15719 n_18_1_1 n_18_2_1 116.6819531466624
R15720 n_18_1_1 n_18_1_2 44.98314819327637
R15721 n_18_1_2 n_19_1_2 612.1646878741388
R15722 n_18_1_2 n_18_2_2 208.36063061904002
R15723 n_18_1_2 n_18_1_3 42.10422670890668
R15724 n_18_1_3 n_19_1_3 8570.305630237934
R15725 n_18_1_3 n_18_2_3 2917.0488286665573
R15726 n_18_1_3 n_18_1_4 0.5597902886274397
R15727 n_18_1_4 n_19_1_4 259.70623121933136
R15728 n_18_1_4 n_18_2_4 88.39541905050173
R15729 n_18_1_4 n_18_1_5 0.4626838099879859
R15730 n_18_1_5 n_19_1_5 1632.4391676643686
R15731 n_18_1_5 n_18_2_5 555.6283483174395
R15732 n_18_1_5 n_18_1_6 0.15994008246498279
R15733 n_18_1_6 n_19_1_6 272.07319461072814
R15734 n_18_1_6 n_18_2_6 92.60472471957324
R15735 n_18_1_6 n_18_1_7 0.21706154048819065
R15736 n_18_1_7 n_19_1_7 466.41119076124966
R15737 n_18_1_7 n_18_2_7 158.75095666212607
R15738 n_18_1_7 n_18_1_8 0.15994008246498229
R15739 n_18_1_8 n_19_1_8 466.41119076124966
R15740 n_18_1_8 n_18_2_8 158.75095666212607
R15741 n_18_1_8 n_18_1_9 0.15994008246498229
R15742 n_18_1_9 n_19_1_9 466.41119076124966
R15743 n_18_1_9 n_18_2_9 158.75095666212607
R15744 n_18_1_9 n_18_1_10 0.15994008246498229
R15745 n_18_1_10 n_19_1_10 466.41119076124966
R15746 n_18_1_10 n_18_2_10 158.75095666212607
R15747 n_18_1_10 n_18_1_11 0.15994008246498126
R15748 n_18_1_11 n_19_1_11 466.4111907612556
R15749 n_18_1_11 n_18_2_11 158.7509566621281
R15750 n_18_1_11 n_18_1_12 0.15994008246498076
R15751 n_18_1_12 n_19_1_12 466.4111907612528
R15752 n_18_1_12 n_18_2_12 158.75095666212707
R15753 n_18_1_12 n_18_1_13 0.15994008246498226
R15754 n_18_1_13 n_19_1_13 466.41119076124676
R15755 n_18_1_13 n_18_2_13 158.75095666212505
R15756 n_18_1_13 n_18_1_14 0.7997004123249134
R15757 n_18_1_14 n_19_1_14 51.82346564013874
R15758 n_18_1_14 n_18_2_14 17.638995184680635
R15759 n_18_1_14 n_18_1_15 24.71074274084005
R15760 n_18_1_15 n_19_1_15 17140.61126047572
R15761 n_18_1_15 n_18_2_15 5834.097657333063
R15762 n_18_2_0 n_19_2_0 244.86587514965555
R15763 n_18_2_0 n_18_3_0 83.34425224761601
R15764 n_18_2_0 n_18_2_1 19.792585205041597
R15765 n_18_2_1 n_19_2_1 342.8122252095177
R15766 n_18_2_1 n_18_3_1 116.6819531466624
R15767 n_18_2_1 n_18_2_2 44.98314819327637
R15768 n_18_2_2 n_19_2_2 612.1646878741388
R15769 n_18_2_2 n_18_3_2 208.36063061904002
R15770 n_18_2_2 n_18_2_3 42.10422670890668
R15771 n_18_2_3 n_19_2_3 8570.305630237934
R15772 n_18_2_3 n_18_3_3 2917.0488286665573
R15773 n_18_2_3 n_18_2_4 0.5597902886274397
R15774 n_18_2_4 n_19_2_4 259.70623121933136
R15775 n_18_2_4 n_18_3_4 88.39541905050173
R15776 n_18_2_4 n_18_2_5 0.4626838099879859
R15777 n_18_2_5 n_19_2_5 1632.4391676643686
R15778 n_18_2_5 n_18_3_5 555.6283483174395
R15779 n_18_2_5 n_18_2_6 0.15994008246498279
R15780 n_18_2_6 n_19_2_6 272.07319461072814
R15781 n_18_2_6 n_18_3_6 92.60472471957324
R15782 n_18_2_6 n_18_2_7 0.21706154048819065
R15783 n_18_2_7 n_19_2_7 466.41119076124966
R15784 n_18_2_7 n_18_3_7 158.75095666212607
R15785 n_18_2_7 n_18_2_8 0.15994008246498229
R15786 n_18_2_8 n_19_2_8 466.41119076124966
R15787 n_18_2_8 n_18_3_8 158.75095666212607
R15788 n_18_2_8 n_18_2_9 0.15994008246498229
R15789 n_18_2_9 n_19_2_9 466.41119076124966
R15790 n_18_2_9 n_18_3_9 158.75095666212607
R15791 n_18_2_9 n_18_2_10 0.15994008246498229
R15792 n_18_2_10 n_19_2_10 466.41119076124966
R15793 n_18_2_10 n_18_3_10 158.75095666212607
R15794 n_18_2_10 n_18_2_11 0.15994008246498126
R15795 n_18_2_11 n_19_2_11 466.4111907612556
R15796 n_18_2_11 n_18_3_11 158.7509566621281
R15797 n_18_2_11 n_18_2_12 0.15994008246498076
R15798 n_18_2_12 n_19_2_12 466.4111907612528
R15799 n_18_2_12 n_18_3_12 158.75095666212707
R15800 n_18_2_12 n_18_2_13 0.15994008246498226
R15801 n_18_2_13 n_19_2_13 466.41119076124676
R15802 n_18_2_13 n_18_3_13 158.75095666212505
R15803 n_18_2_13 n_18_2_14 0.7997004123249134
R15804 n_18_2_14 n_19_2_14 51.82346564013874
R15805 n_18_2_14 n_18_3_14 17.638995184680635
R15806 n_18_2_14 n_18_2_15 24.71074274084005
R15807 n_18_2_15 n_19_2_15 17140.61126047572
R15808 n_18_2_15 n_18_3_15 5834.097657333063
R15809 n_18_3_0 n_19_3_0 244.86587514965555
R15810 n_18_3_0 n_18_4_0 43.561715139231026
R15811 n_18_3_0 n_18_3_1 19.792585205041597
R15812 n_18_3_1 n_19_3_1 342.8122252095177
R15813 n_18_3_1 n_18_4_1 60.986401194923424
R15814 n_18_3_1 n_18_3_2 44.98314819327637
R15815 n_18_3_2 n_19_3_2 612.1646878741388
R15816 n_18_3_2 n_18_4_2 108.90428784807756
R15817 n_18_3_2 n_18_3_3 42.10422670890668
R15818 n_18_3_3 n_19_3_3 8570.305630237934
R15819 n_18_3_3 n_18_4_3 1524.6600298730843
R15820 n_18_3_3 n_18_3_4 0.5597902886274397
R15821 n_18_3_4 n_19_3_4 259.70623121933136
R15822 n_18_3_4 n_18_4_4 46.20181908706316
R15823 n_18_3_4 n_18_3_5 0.4626838099879859
R15824 n_18_3_5 n_19_3_5 1632.4391676643686
R15825 n_18_3_5 n_18_3_6 0.15994008246498279
R15826 n_18_3_6 n_19_3_6 272.07319461072814
R15827 n_18_3_6 n_18_3_7 0.21706154048819065
R15828 n_18_3_7 n_19_3_7 466.41119076124966
R15829 n_18_3_7 n_18_3_8 0.15994008246498229
R15830 n_18_3_8 n_19_3_8 466.41119076124966
R15831 n_18_3_8 n_18_3_9 0.15994008246498229
R15832 n_18_3_9 n_19_3_9 466.41119076124966
R15833 n_18_3_9 n_18_3_10 0.15994008246498229
R15834 n_18_3_10 n_19_3_10 466.41119076124966
R15835 n_18_3_10 n_18_3_11 0.15994008246498126
R15836 n_18_3_11 n_19_3_11 466.4111907612556
R15837 n_18_3_11 n_18_3_12 0.15994008246498076
R15838 n_18_3_12 n_19_3_12 466.4111907612528
R15839 n_18_3_12 n_18_3_13 0.15994008246498226
R15840 n_18_3_13 n_19_3_13 466.41119076124676
R15841 n_18_3_13 n_18_3_14 0.7997004123249134
R15842 n_18_3_14 n_19_3_14 51.82346564013874
R15843 n_18_3_14 n_18_3_15 24.71074274084005
R15844 n_18_3_15 n_19_3_15 17140.61126047572
R15845 n_18_3_15 n_18_4_15 3049.3200597461414
R15846 n_18_4_0 n_19_4_0 5400.159267103214
R15847 n_18_4_0 n_18_5_0 3.7791780308460767
R15848 n_18_4_0 n_18_4_1 436.4965610239126
R15849 n_18_4_1 n_19_4_1 7560.222973944499
R15850 n_18_4_1 n_18_5_1 5.290849243184507
R15851 n_18_4_1 n_18_4_2 992.0376386907103
R15852 n_18_4_2 n_19_4_2 13500.398167758036
R15853 n_18_4_2 n_18_5_2 9.447945077115193
R15854 n_18_4_2 n_18_4_3 928.5472298145049
R15855 n_18_4_3 n_19_4_3 189005.57434861234
R15856 n_18_4_3 n_18_5_3 132.27123107961256
R15857 n_18_4_3 n_18_4_4 12.345357281484407
R15858 n_18_4_4 n_19_4_4 5727.441646927647
R15859 n_18_4_4 n_18_5_4 4.008219123624623
R15860 n_18_4_15 n_19_4_15 378011.1486972213
R15861 n_18_4_15 n_18_5_15 264.54246215922274
R15862 n_18_5_0 n_19_5_0 5400.159267103119
R15863 n_18_5_0 n_18_6_0 3.7791780308461105
R15864 n_18_5_0 n_18_5_1 436.49656102390486
R15865 n_18_5_1 n_19_5_1 7560.222973944365
R15866 n_18_5_1 n_18_6_1 5.290849243184554
R15867 n_18_5_1 n_18_5_2 992.0376386906928
R15868 n_18_5_2 n_19_5_2 13500.398167757798
R15869 n_18_5_2 n_18_6_2 9.447945077115277
R15870 n_18_5_2 n_18_5_3 928.5472298144884
R15871 n_18_5_3 n_19_5_3 189005.57434860896
R15872 n_18_5_3 n_18_6_3 132.27123107961373
R15873 n_18_5_3 n_18_5_4 12.34535728148419
R15874 n_18_5_4 n_19_5_4 5727.441646927545
R15875 n_18_5_4 n_18_6_4 4.0082191236246585
R15876 n_18_5_15 n_19_5_15 378011.14869721455
R15877 n_18_5_15 n_18_6_15 264.5424621592251
R15878 n_18_6_0 n_19_6_0 5400.159267103119
R15879 n_18_6_0 n_18_7_0 3.7791780308460767
R15880 n_18_6_0 n_18_6_1 436.49656102390486
R15881 n_18_6_1 n_19_6_1 7560.222973944365
R15882 n_18_6_1 n_18_7_1 5.290849243184507
R15883 n_18_6_1 n_18_6_2 992.0376386906928
R15884 n_18_6_2 n_19_6_2 13500.398167757798
R15885 n_18_6_2 n_18_7_2 9.447945077115193
R15886 n_18_6_2 n_18_6_3 928.5472298144884
R15887 n_18_6_3 n_19_6_3 189005.57434860896
R15888 n_18_6_3 n_18_7_3 132.27123107961256
R15889 n_18_6_3 n_18_6_4 12.34535728148419
R15890 n_18_6_4 n_19_6_4 5727.441646927545
R15891 n_18_6_4 n_18_7_4 4.008219123624623
R15892 n_18_6_15 n_19_6_15 378011.14869721455
R15893 n_18_6_15 n_18_7_15 264.54246215922274
R15894 n_18_7_0 n_19_7_0 5400.159267103214
R15895 n_18_7_0 n_18_8_0 110.44365038628541
R15896 n_18_7_0 n_18_7_1 436.4965610239126
R15897 n_18_7_1 n_19_7_1 7560.222973944499
R15898 n_18_7_1 n_18_8_1 154.62111054079955
R15899 n_18_7_1 n_18_7_2 992.0376386907103
R15900 n_18_7_2 n_19_7_2 13500.398167758036
R15901 n_18_7_2 n_18_8_2 276.10912596571353
R15902 n_18_7_2 n_18_7_3 928.5472298145049
R15903 n_18_7_3 n_19_7_3 189005.57434861234
R15904 n_18_7_3 n_18_8_3 3865.5277635199855
R15905 n_18_7_3 n_18_7_4 12.345357281484407
R15906 n_18_7_4 n_19_7_4 5727.441646927647
R15907 n_18_7_4 n_18_8_4 117.13720495515106
R15908 n_18_7_15 n_19_7_15 378011.1486972213
R15909 n_18_7_15 n_18_8_15 7731.055527039902
R15910 n_18_8_0 n_19_8_0 93.99999874525199
R15911 n_18_8_0 n_18_9_0 217.10812274172486
R15912 n_18_8_0 n_18_8_1 7.5980492720846176
R15913 n_18_8_1 n_19_8_1 131.59999824335273
R15914 n_18_8_1 n_18_9_1 303.95137183841473
R15915 n_18_8_1 n_18_8_2 17.268293800192314
R15916 n_18_8_2 n_19_8_2 234.99999686312992
R15917 n_18_8_2 n_18_9_2 542.7703068543121
R15918 n_18_8_2 n_18_8_3 16.163122996980004
R15919 n_18_8_3 n_19_8_3 3289.999956083816
R15920 n_18_8_3 n_18_9_3 7598.784295960362
R15921 n_18_8_3 n_18_8_4 0.2148943228468379
R15922 n_18_8_4 n_19_8_4 99.69696836617626
R15923 n_18_8_4 n_18_9_4 230.2661907866776
R15924 n_18_8_4 n_18_8_5 0.2148943228468379
R15925 n_18_8_5 n_19_8_5 3289.999956083816
R15926 n_18_8_5 n_18_9_5 7598.784295960362
R15927 n_18_8_5 n_18_8_6 0.41443905120461594
R15928 n_18_8_6 n_19_8_6 731.1111013519591
R15929 n_18_8_6 n_18_9_6 1688.618732435636
R15930 n_18_8_6 n_18_8_7 0.5832845905842736
R15931 n_18_8_7 n_19_8_7 1253.3333166033626
R15932 n_18_8_7 n_18_9_7 2894.774969889671
R15933 n_18_8_7 n_18_8_8 0.4297886456936744
R15934 n_18_8_8 n_19_8_8 1253.3333166033626
R15935 n_18_8_8 n_18_9_8 2894.774969889671
R15936 n_18_8_8 n_18_8_9 0.4297886456936744
R15937 n_18_8_9 n_19_8_9 1253.3333166033626
R15938 n_18_8_9 n_18_9_9 2894.774969889671
R15939 n_18_8_9 n_18_8_10 0.4297886456936744
R15940 n_18_8_10 n_19_8_10 1253.3333166033626
R15941 n_18_8_10 n_18_9_10 2894.774969889671
R15942 n_18_8_10 n_18_8_11 0.4297886456936717
R15943 n_18_8_11 n_19_8_11 1253.3333166033783
R15944 n_18_8_11 n_18_9_11 2894.7749698897073
R15945 n_18_8_11 n_18_8_12 0.4297886456936703
R15946 n_18_8_12 n_19_8_12 1253.3333166033703
R15947 n_18_8_12 n_18_9_12 2894.7749698896896
R15948 n_18_8_12 n_18_8_13 0.4297886456936745
R15949 n_18_8_13 n_19_8_13 1253.3333166033544
R15950 n_18_8_13 n_18_9_13 2894.7749698896523
R15951 n_18_8_13 n_18_8_14 2.1489432284683776
R15952 n_18_8_14 n_19_8_14 139.25925740037331
R15953 n_18_8_14 n_18_9_14 321.64166332107385
R15954 n_18_8_14 n_18_8_15 11.143805599057531
R15955 n_18_8_15 n_19_8_15 6579.999912167574
R15956 n_18_8_15 n_18_9_15 15197.568591920586
R15957 n_18_9_0 n_19_9_0 93.9999987452519
R15958 n_18_9_0 n_18_10_0 217.10812274172486
R15959 n_18_9_0 n_18_9_1 7.598049272084614
R15960 n_18_9_1 n_19_9_1 131.59999824335267
R15961 n_18_9_1 n_18_10_1 303.95137183841473
R15962 n_18_9_1 n_18_9_2 17.268293800192303
R15963 n_18_9_2 n_19_9_2 234.99999686312978
R15964 n_18_9_2 n_18_10_2 542.7703068543121
R15965 n_18_9_2 n_18_9_3 16.163122996979993
R15966 n_18_9_3 n_19_9_3 3289.999956083814
R15967 n_18_9_3 n_18_10_3 7598.784295960362
R15968 n_18_9_3 n_18_9_4 0.21489432284683777
R15969 n_18_9_4 n_19_9_4 99.69696836617618
R15970 n_18_9_4 n_18_10_4 230.2661907866776
R15971 n_18_9_4 n_18_9_5 0.21489432284683777
R15972 n_18_9_5 n_19_9_5 3289.999956083814
R15973 n_18_9_5 n_18_10_5 7598.784295960362
R15974 n_18_9_5 n_18_9_6 0.41443905120461566
R15975 n_18_9_6 n_19_9_6 731.1111013519586
R15976 n_18_9_6 n_18_10_6 1688.618732435636
R15977 n_18_9_6 n_18_9_7 0.5832845905842732
R15978 n_18_9_7 n_19_9_7 1253.3333166033615
R15979 n_18_9_7 n_18_10_7 2894.774969889671
R15980 n_18_9_7 n_18_9_8 0.42978864569367414
R15981 n_18_9_8 n_19_9_8 1253.3333166033615
R15982 n_18_9_8 n_18_10_8 2894.774969889671
R15983 n_18_9_8 n_18_9_9 0.42978864569367414
R15984 n_18_9_9 n_19_9_9 1253.3333166033615
R15985 n_18_9_9 n_18_10_9 2894.774969889671
R15986 n_18_9_9 n_18_9_10 0.42978864569367414
R15987 n_18_9_10 n_19_9_10 1253.3333166033615
R15988 n_18_9_10 n_18_10_10 2894.774969889671
R15989 n_18_9_10 n_18_9_11 0.42978864569367137
R15990 n_18_9_11 n_19_9_11 1253.3333166033776
R15991 n_18_9_11 n_18_10_11 2894.7749698897073
R15992 n_18_9_11 n_18_9_12 0.42978864569367004
R15993 n_18_9_12 n_19_9_12 1253.3333166033697
R15994 n_18_9_12 n_18_10_12 2894.7749698896896
R15995 n_18_9_12 n_18_9_13 0.42978864569367414
R15996 n_18_9_13 n_19_9_13 1253.3333166033535
R15997 n_18_9_13 n_18_10_13 2894.7749698896523
R15998 n_18_9_13 n_18_9_14 2.1489432284683763
R15999 n_18_9_14 n_19_9_14 139.2592574003732
R16000 n_18_9_14 n_18_10_14 321.64166332107385
R16001 n_18_9_14 n_18_9_15 11.143805599057522
R16002 n_18_9_15 n_19_9_15 6579.99991216757
R16003 n_18_9_15 n_18_10_15 15197.568591920586
R16004 n_18_10_0 n_19_10_0 93.99999874525199
R16005 n_18_10_0 n_18_11_0 217.10812274172477
R16006 n_18_10_0 n_18_10_1 7.5980492720846176
R16007 n_18_10_1 n_19_10_1 131.59999824335273
R16008 n_18_10_1 n_18_11_1 303.9513718384146
R16009 n_18_10_1 n_18_10_2 17.268293800192314
R16010 n_18_10_2 n_19_10_2 234.99999686312992
R16011 n_18_10_2 n_18_11_2 542.7703068543119
R16012 n_18_10_2 n_18_10_3 16.163122996980004
R16013 n_18_10_3 n_19_10_3 3289.999956083816
R16014 n_18_10_3 n_18_11_3 7598.7842959603595
R16015 n_18_10_3 n_18_10_4 0.2148943228468379
R16016 n_18_10_4 n_19_10_4 99.69696836617626
R16017 n_18_10_4 n_18_11_4 230.26619078667753
R16018 n_18_10_4 n_18_10_5 0.2148943228468379
R16019 n_18_10_5 n_19_10_5 3289.999956083816
R16020 n_18_10_5 n_18_11_5 7598.7842959603595
R16021 n_18_10_5 n_18_10_6 0.41443905120461594
R16022 n_18_10_6 n_19_10_6 731.1111013519591
R16023 n_18_10_6 n_18_11_6 1688.6187324356354
R16024 n_18_10_6 n_18_10_7 0.5832845905842736
R16025 n_18_10_7 n_19_10_7 1253.3333166033626
R16026 n_18_10_7 n_18_11_7 2894.77496988967
R16027 n_18_10_7 n_18_10_8 0.4297886456936744
R16028 n_18_10_8 n_19_10_8 1253.3333166033626
R16029 n_18_10_8 n_18_11_8 2894.77496988967
R16030 n_18_10_8 n_18_10_9 0.4297886456936744
R16031 n_18_10_9 n_19_10_9 1253.3333166033626
R16032 n_18_10_9 n_18_11_9 2894.77496988967
R16033 n_18_10_9 n_18_10_10 0.4297886456936744
R16034 n_18_10_10 n_19_10_10 1253.3333166033626
R16035 n_18_10_10 n_18_11_10 2894.77496988967
R16036 n_18_10_10 n_18_10_11 0.4297886456936717
R16037 n_18_10_11 n_19_10_11 1253.3333166033783
R16038 n_18_10_11 n_18_11_11 2894.7749698897064
R16039 n_18_10_11 n_18_10_12 0.4297886456936703
R16040 n_18_10_12 n_19_10_12 1253.3333166033703
R16041 n_18_10_12 n_18_11_12 2894.7749698896887
R16042 n_18_10_12 n_18_10_13 0.4297886456936745
R16043 n_18_10_13 n_19_10_13 1253.3333166033544
R16044 n_18_10_13 n_18_11_13 2894.7749698896514
R16045 n_18_10_13 n_18_10_14 2.1489432284683776
R16046 n_18_10_14 n_19_10_14 139.25925740037331
R16047 n_18_10_14 n_18_11_14 321.64166332107374
R16048 n_18_10_14 n_18_10_15 11.143805599057531
R16049 n_18_10_15 n_19_10_15 6579.999912167574
R16050 n_18_10_15 n_18_11_15 15197.568591920583
R16051 n_18_11_0 n_19_11_0 93.99999874525199
R16052 n_18_11_0 n_18_12_0 110.44365362970515
R16053 n_18_11_0 n_18_11_1 7.5980492720846176
R16054 n_18_11_1 n_19_11_1 131.59999824335273
R16055 n_18_11_1 n_18_12_1 154.62111508158716
R16056 n_18_11_1 n_18_11_2 17.268293800192314
R16057 n_18_11_2 n_19_11_2 234.99999686312992
R16058 n_18_11_2 n_18_12_2 276.10913407426284
R16059 n_18_11_2 n_18_11_3 16.163122996980004
R16060 n_18_11_3 n_19_11_3 3289.999956083816
R16061 n_18_11_3 n_18_12_3 3865.5278770396762
R16062 n_18_11_3 n_18_11_4 0.2148943228468379
R16063 n_18_11_4 n_19_11_4 99.69696836617626
R16064 n_18_11_4 n_18_12_4 117.1372083951417
R16065 n_18_11_4 n_18_11_5 0.2148943228468379
R16066 n_18_11_5 n_19_11_5 3289.999956083816
R16067 n_18_11_5 n_18_11_6 0.41443905120461594
R16068 n_18_11_6 n_19_11_6 731.1111013519591
R16069 n_18_11_6 n_18_11_7 0.5832845905842736
R16070 n_18_11_7 n_19_11_7 1253.3333166033626
R16071 n_18_11_7 n_18_11_8 0.4297886456936744
R16072 n_18_11_8 n_19_11_8 1253.3333166033626
R16073 n_18_11_8 n_18_11_9 0.4297886456936744
R16074 n_18_11_9 n_19_11_9 1253.3333166033626
R16075 n_18_11_9 n_18_11_10 0.4297886456936744
R16076 n_18_11_10 n_19_11_10 1253.3333166033626
R16077 n_18_11_10 n_18_11_11 0.4297886456936717
R16078 n_18_11_11 n_19_11_11 1253.3333166033783
R16079 n_18_11_11 n_18_11_12 0.4297886456936703
R16080 n_18_11_12 n_19_11_12 1253.3333166033703
R16081 n_18_11_12 n_18_11_13 0.4297886456936745
R16082 n_18_11_13 n_19_11_13 1253.3333166033544
R16083 n_18_11_13 n_18_11_14 2.1489432284683776
R16084 n_18_11_14 n_19_11_14 139.25925740037331
R16085 n_18_11_14 n_18_11_15 11.143805599057531
R16086 n_18_11_15 n_19_11_15 6579.999912167574
R16087 n_18_11_15 n_18_12_15 7731.055754079283
R16088 n_18_12_0 n_19_12_0 5400.149997916649
R16089 n_18_12_0 n_18_13_0 3.7791845176855285
R16090 n_18_12_0 n_18_12_1 436.495811792666
R16091 n_18_12_1 n_19_12_1 7560.209997083308
R16092 n_18_12_1 n_18_13_1 5.290858324759739
R16093 n_18_12_1 n_18_12_2 992.0359358924229
R16094 n_18_12_2 n_19_12_2 13500.374994791624
R16095 n_18_12_2 n_18_13_2 9.447961294213822
R16096 n_18_12_2 n_18_12_3 928.5456359953077
R16097 n_18_12_3 n_19_12_3 189005.24992708254
R16098 n_18_12_3 n_18_13_3 132.27145811899337
R16099 n_18_12_3 n_18_12_4 12.345336091105716
R16100 n_18_12_4 n_19_12_4 5727.431815972199
R16101 n_18_12_4 n_18_13_4 4.008226003605859
R16102 n_18_12_15 n_19_12_15 378010.49985416175
R16103 n_18_12_15 n_18_13_15 264.54291623798434
R16104 n_18_13_0 n_19_13_0 5400.149997916649
R16105 n_18_13_0 n_18_14_0 3.7791845176855285
R16106 n_18_13_0 n_18_13_1 436.495811792666
R16107 n_18_13_1 n_19_13_1 7560.209997083308
R16108 n_18_13_1 n_18_14_1 5.290858324759739
R16109 n_18_13_1 n_18_13_2 992.0359358924229
R16110 n_18_13_2 n_19_13_2 13500.374994791624
R16111 n_18_13_2 n_18_14_2 9.447961294213822
R16112 n_18_13_2 n_18_13_3 928.5456359953077
R16113 n_18_13_3 n_19_13_3 189005.24992708254
R16114 n_18_13_3 n_18_14_3 132.27145811899337
R16115 n_18_13_3 n_18_13_4 12.345336091105716
R16116 n_18_13_4 n_19_13_4 5727.431815972199
R16117 n_18_13_4 n_18_14_4 4.008226003605859
R16118 n_18_13_15 n_19_13_15 378010.49985416175
R16119 n_18_13_15 n_18_14_15 264.54291623798434
R16120 n_18_14_0 n_19_14_0 5400.149997916649
R16121 n_18_14_0 n_18_15_0 3.7791845176855285
R16122 n_18_14_0 n_18_14_1 436.495811792666
R16123 n_18_14_1 n_19_14_1 7560.209997083308
R16124 n_18_14_1 n_18_15_1 5.290858324759739
R16125 n_18_14_1 n_18_14_2 992.0359358924229
R16126 n_18_14_2 n_19_14_2 13500.374994791624
R16127 n_18_14_2 n_18_15_2 9.447961294213822
R16128 n_18_14_2 n_18_14_3 928.5456359953077
R16129 n_18_14_3 n_19_14_3 189005.24992708254
R16130 n_18_14_3 n_18_15_3 132.27145811899337
R16131 n_18_14_3 n_18_14_4 12.345336091105716
R16132 n_18_14_4 n_19_14_4 5727.431815972199
R16133 n_18_14_4 n_18_15_4 4.008226003605859
R16134 n_18_14_15 n_19_14_15 378010.49985416175
R16135 n_18_14_15 n_18_15_15 264.54291623798434
R16136 n_18_15_0 n_19_15_0 5400.149997916649
R16137 n_18_15_0 n_18_16_0 110.44365362970508
R16138 n_18_15_0 n_18_15_1 436.495811792666
R16139 n_18_15_1 n_19_15_1 7560.209997083308
R16140 n_18_15_1 n_18_16_1 154.6211150815871
R16141 n_18_15_1 n_18_15_2 992.0359358924229
R16142 n_18_15_2 n_19_15_2 13500.374994791624
R16143 n_18_15_2 n_18_16_2 276.10913407426267
R16144 n_18_15_2 n_18_15_3 928.5456359953077
R16145 n_18_15_3 n_19_15_3 189005.24992708254
R16146 n_18_15_3 n_18_16_3 3865.527877039674
R16147 n_18_15_3 n_18_15_4 12.345336091105716
R16148 n_18_15_4 n_19_15_4 5727.431815972199
R16149 n_18_15_4 n_18_16_4 117.13720839514164
R16150 n_18_15_15 n_19_15_15 378010.49985416175
R16151 n_18_15_15 n_18_16_15 7731.055754079279
R16152 n_18_16_0 n_19_16_0 93.99999874525204
R16153 n_18_16_0 n_18_17_0 217.10812274172477
R16154 n_18_16_0 n_18_16_1 7.598049272084623
R16155 n_18_16_1 n_19_16_1 131.59999824335284
R16156 n_18_16_1 n_18_17_1 303.9513718384146
R16157 n_18_16_1 n_18_16_2 17.26829380019233
R16158 n_18_16_2 n_19_16_2 234.9999968631301
R16159 n_18_16_2 n_18_17_2 542.7703068543119
R16160 n_18_16_2 n_18_16_3 16.163122996980018
R16161 n_18_16_3 n_19_16_3 3289.999956083818
R16162 n_18_16_3 n_18_17_3 7598.7842959603595
R16163 n_18_16_3 n_18_16_4 0.21489432284683804
R16164 n_18_16_4 n_19_16_4 99.69696836617629
R16165 n_18_16_4 n_18_17_4 230.26619078667756
R16166 n_18_16_4 n_18_16_5 0.21489432284683804
R16167 n_18_16_5 n_19_16_5 3289.999956083818
R16168 n_18_16_5 n_18_17_5 7598.7842959603595
R16169 n_18_16_5 n_18_16_6 0.4144390512046162
R16170 n_18_16_6 n_19_16_6 731.1111013519596
R16171 n_18_16_6 n_18_17_6 1688.6187324356356
R16172 n_18_16_6 n_18_16_7 0.5832845905842741
R16173 n_18_16_7 n_19_16_7 1253.333316603363
R16174 n_18_16_7 n_18_17_7 2894.77496988967
R16175 n_18_16_7 n_18_16_8 0.42978864569367475
R16176 n_18_16_8 n_19_16_8 1253.333316603363
R16177 n_18_16_8 n_18_17_8 2894.77496988967
R16178 n_18_16_8 n_18_16_9 0.42978864569367475
R16179 n_18_16_9 n_19_16_9 1253.333316603363
R16180 n_18_16_9 n_18_17_9 2894.77496988967
R16181 n_18_16_9 n_18_16_10 0.42978864569367475
R16182 n_18_16_10 n_19_16_10 1253.333316603363
R16183 n_18_16_10 n_18_17_10 2894.77496988967
R16184 n_18_16_10 n_18_16_11 0.42978864569367203
R16185 n_18_16_11 n_19_16_11 1253.333316603379
R16186 n_18_16_11 n_18_17_11 2894.7749698897064
R16187 n_18_16_11 n_18_16_12 0.4297886456936706
R16188 n_18_16_12 n_19_16_12 1253.3333166033713
R16189 n_18_16_12 n_18_17_12 2894.7749698896887
R16190 n_18_16_12 n_18_16_13 0.4297886456936747
R16191 n_18_16_13 n_19_16_13 1253.3333166033553
R16192 n_18_16_13 n_18_17_13 2894.7749698896514
R16193 n_18_16_13 n_18_16_14 2.148943228468379
R16194 n_18_16_14 n_19_16_14 139.25925740037337
R16195 n_18_16_14 n_18_17_14 321.6416633210738
R16196 n_18_16_14 n_18_16_15 11.14380559905754
R16197 n_18_16_15 n_19_16_15 6579.999912167577
R16198 n_18_16_15 n_18_17_15 15197.568591920583
R16199 n_18_17_0 n_19_17_0 93.9999987452519
R16200 n_18_17_0 n_18_18_0 217.1081227417249
R16201 n_18_17_0 n_18_17_1 7.598049272084614
R16202 n_18_17_1 n_19_17_1 131.59999824335267
R16203 n_18_17_1 n_18_18_1 303.95137183841484
R16204 n_18_17_1 n_18_17_2 17.268293800192303
R16205 n_18_17_2 n_19_17_2 234.99999686312978
R16206 n_18_17_2 n_18_18_2 542.7703068543123
R16207 n_18_17_2 n_18_17_3 16.163122996979993
R16208 n_18_17_3 n_19_17_3 3289.999956083814
R16209 n_18_17_3 n_18_18_3 7598.784295960364
R16210 n_18_17_3 n_18_17_4 0.21489432284683777
R16211 n_18_17_4 n_19_17_4 99.69696836617618
R16212 n_18_17_4 n_18_18_4 230.26619078667767
R16213 n_18_17_4 n_18_17_5 0.21489432284683777
R16214 n_18_17_5 n_19_17_5 3289.999956083814
R16215 n_18_17_5 n_18_18_5 7598.784295960364
R16216 n_18_17_5 n_18_17_6 0.41443905120461566
R16217 n_18_17_6 n_19_17_6 731.1111013519586
R16218 n_18_17_6 n_18_18_6 1688.6187324356365
R16219 n_18_17_6 n_18_17_7 0.5832845905842732
R16220 n_18_17_7 n_19_17_7 1253.3333166033615
R16221 n_18_17_7 n_18_18_7 2894.774969889672
R16222 n_18_17_7 n_18_17_8 0.42978864569367414
R16223 n_18_17_8 n_19_17_8 1253.3333166033615
R16224 n_18_17_8 n_18_18_8 2894.774969889672
R16225 n_18_17_8 n_18_17_9 0.42978864569367414
R16226 n_18_17_9 n_19_17_9 1253.3333166033615
R16227 n_18_17_9 n_18_18_9 2894.774969889672
R16228 n_18_17_9 n_18_17_10 0.42978864569367414
R16229 n_18_17_10 n_19_17_10 1253.3333166033615
R16230 n_18_17_10 n_18_18_10 2894.774969889672
R16231 n_18_17_10 n_18_17_11 0.42978864569367137
R16232 n_18_17_11 n_19_17_11 1253.3333166033776
R16233 n_18_17_11 n_18_18_11 2894.7749698897082
R16234 n_18_17_11 n_18_17_12 0.42978864569367004
R16235 n_18_17_12 n_19_17_12 1253.3333166033697
R16236 n_18_17_12 n_18_18_12 2894.7749698896905
R16237 n_18_17_12 n_18_17_13 0.42978864569367414
R16238 n_18_17_13 n_19_17_13 1253.3333166033535
R16239 n_18_17_13 n_18_18_13 2894.774969889653
R16240 n_18_17_13 n_18_17_14 2.1489432284683763
R16241 n_18_17_14 n_19_17_14 139.2592574003732
R16242 n_18_17_14 n_18_18_14 321.64166332107396
R16243 n_18_17_14 n_18_17_15 11.143805599057522
R16244 n_18_17_15 n_19_17_15 6579.99991216757
R16245 n_18_17_15 n_18_18_15 15197.568591920592
R16246 n_18_18_0 n_19_18_0 93.9999987452519
R16247 n_18_18_0 n_18_19_0 217.10812274172477
R16248 n_18_18_0 n_18_18_1 7.598049272084614
R16249 n_18_18_1 n_19_18_1 131.59999824335267
R16250 n_18_18_1 n_18_19_1 303.9513718384146
R16251 n_18_18_1 n_18_18_2 17.268293800192303
R16252 n_18_18_2 n_19_18_2 234.99999686312978
R16253 n_18_18_2 n_18_19_2 542.7703068543119
R16254 n_18_18_2 n_18_18_3 16.163122996979993
R16255 n_18_18_3 n_19_18_3 3289.999956083814
R16256 n_18_18_3 n_18_19_3 7598.7842959603595
R16257 n_18_18_3 n_18_18_4 0.21489432284683777
R16258 n_18_18_4 n_19_18_4 99.69696836617618
R16259 n_18_18_4 n_18_19_4 230.26619078667756
R16260 n_18_18_4 n_18_18_5 0.21489432284683777
R16261 n_18_18_5 n_19_18_5 3289.999956083814
R16262 n_18_18_5 n_18_19_5 7598.7842959603595
R16263 n_18_18_5 n_18_18_6 0.41443905120461566
R16264 n_18_18_6 n_19_18_6 731.1111013519586
R16265 n_18_18_6 n_18_19_6 1688.6187324356356
R16266 n_18_18_6 n_18_18_7 0.5832845905842732
R16267 n_18_18_7 n_19_18_7 1253.3333166033615
R16268 n_18_18_7 n_18_19_7 2894.77496988967
R16269 n_18_18_7 n_18_18_8 0.42978864569367414
R16270 n_18_18_8 n_19_18_8 1253.3333166033615
R16271 n_18_18_8 n_18_19_8 2894.77496988967
R16272 n_18_18_8 n_18_18_9 0.42978864569367414
R16273 n_18_18_9 n_19_18_9 1253.3333166033615
R16274 n_18_18_9 n_18_19_9 2894.77496988967
R16275 n_18_18_9 n_18_18_10 0.42978864569367414
R16276 n_18_18_10 n_19_18_10 1253.3333166033615
R16277 n_18_18_10 n_18_19_10 2894.77496988967
R16278 n_18_18_10 n_18_18_11 0.42978864569367137
R16279 n_18_18_11 n_19_18_11 1253.3333166033776
R16280 n_18_18_11 n_18_19_11 2894.7749698897064
R16281 n_18_18_11 n_18_18_12 0.42978864569367004
R16282 n_18_18_12 n_19_18_12 1253.3333166033697
R16283 n_18_18_12 n_18_19_12 2894.7749698896887
R16284 n_18_18_12 n_18_18_13 0.42978864569367414
R16285 n_18_18_13 n_19_18_13 1253.3333166033535
R16286 n_18_18_13 n_18_19_13 2894.7749698896514
R16287 n_18_18_13 n_18_18_14 2.1489432284683763
R16288 n_18_18_14 n_19_18_14 139.2592574003732
R16289 n_18_18_14 n_18_19_14 321.6416633210738
R16290 n_18_18_14 n_18_18_15 11.143805599057522
R16291 n_18_18_15 n_19_18_15 6579.99991216757
R16292 n_18_18_15 n_18_19_15 15197.568591920583
R16293 n_18_19_0 n_19_19_0 93.99999874525204
R16294 n_18_19_0 n_18_20_0 110.44365397508223
R16295 n_18_19_0 n_18_19_1 7.598049272084623
R16296 n_18_19_1 n_19_19_1 131.59999824335284
R16297 n_18_19_1 n_18_20_1 154.6211155651151
R16298 n_18_19_1 n_18_19_2 17.26829380019233
R16299 n_18_19_2 n_19_19_2 234.9999968631301
R16300 n_18_19_2 n_18_20_2 276.10913493770556
R16301 n_18_19_2 n_18_19_3 16.163122996980018
R16302 n_18_19_3 n_19_19_3 3289.999956083818
R16303 n_18_19_3 n_18_20_3 3865.5278891278745
R16304 n_18_19_3 n_18_19_4 0.21489432284683804
R16305 n_18_19_4 n_19_19_4 99.69696836617629
R16306 n_18_19_4 n_18_20_4 117.13720876145074
R16307 n_18_19_4 n_18_19_5 0.21489432284683804
R16308 n_18_19_5 n_19_19_5 3289.999956083818
R16309 n_18_19_5 n_18_19_6 0.4144390512046162
R16310 n_18_19_6 n_19_19_6 731.1111013519596
R16311 n_18_19_6 n_18_19_7 0.5832845905842741
R16312 n_18_19_7 n_19_19_7 1253.333316603363
R16313 n_18_19_7 n_18_19_8 0.42978864569367475
R16314 n_18_19_8 n_19_19_8 1253.333316603363
R16315 n_18_19_8 n_18_19_9 0.42978864569367475
R16316 n_18_19_9 n_19_19_9 1253.333316603363
R16317 n_18_19_9 n_18_19_10 0.42978864569367475
R16318 n_18_19_10 n_19_19_10 1253.333316603363
R16319 n_18_19_10 n_18_19_11 0.42978864569367203
R16320 n_18_19_11 n_19_19_11 1253.333316603379
R16321 n_18_19_11 n_18_19_12 0.4297886456936706
R16322 n_18_19_12 n_19_19_12 1253.3333166033713
R16323 n_18_19_12 n_18_19_13 0.4297886456936747
R16324 n_18_19_13 n_19_19_13 1253.3333166033553
R16325 n_18_19_13 n_18_19_14 2.148943228468379
R16326 n_18_19_14 n_19_19_14 139.25925740037337
R16327 n_18_19_14 n_18_19_15 11.14380559905754
R16328 n_18_19_15 n_19_19_15 6579.999912167577
R16329 n_18_19_15 n_18_20_15 7731.055778255679
R16330 n_18_20_0 n_19_20_0 5400.149010884632
R16331 n_18_20_0 n_18_21_0 3.7791852084398228
R16332 n_18_20_0 n_18_20_1 436.49573201055955
R16333 n_18_20_1 n_19_20_1 7560.208615238482
R16334 n_18_20_1 n_18_21_1 5.290859291815751
R16335 n_18_20_1 n_18_20_2 992.0357545694536
R16336 n_18_20_2 n_19_20_2 13500.37252721158
R16337 n_18_20_2 n_18_21_2 9.447963021099557
R16338 n_18_20_2 n_18_20_3 928.5454662770086
R16339 n_18_20_3 n_19_20_3 189005.2153809619
R16340 n_18_20_3 n_18_21_3 132.27148229539367
R16341 n_18_20_3 n_18_20_4 12.345333834642101
R16342 n_18_20_4 n_19_20_4 5727.430769120058
R16343 n_18_20_4 n_18_21_4 4.00822673622405
R16344 n_18_20_15 n_19_20_15 378010.4307619204
R16345 n_18_20_15 n_18_21_15 264.54296459078495
R16346 n_18_21_0 n_19_21_0 5400.149010884632
R16347 n_18_21_0 n_18_22_0 3.7791852084396886
R16348 n_18_21_0 n_18_21_1 436.49573201055955
R16349 n_18_21_1 n_19_21_1 7560.208615238482
R16350 n_18_21_1 n_18_22_1 5.290859291815563
R16351 n_18_21_1 n_18_21_2 992.0357545694536
R16352 n_18_21_2 n_19_21_2 13500.37252721158
R16353 n_18_21_2 n_18_22_2 9.447963021099222
R16354 n_18_21_2 n_18_21_3 928.5454662770086
R16355 n_18_21_3 n_19_21_3 189005.2153809619
R16356 n_18_21_3 n_18_22_3 132.27148229538898
R16357 n_18_21_3 n_18_21_4 12.345333834642101
R16358 n_18_21_4 n_19_21_4 5727.430769120058
R16359 n_18_21_4 n_18_22_4 4.008226736223907
R16360 n_18_21_15 n_19_21_15 378010.4307619204
R16361 n_18_21_15 n_18_22_15 264.54296459077557
R16362 n_18_22_0 n_19_22_0 5400.149010885015
R16363 n_18_22_0 n_18_23_0 3.7791852084396886
R16364 n_18_22_0 n_18_22_1 436.4957320105906
R16365 n_18_22_1 n_19_22_1 7560.20861523902
R16366 n_18_22_1 n_18_23_1 5.290859291815563
R16367 n_18_22_1 n_18_22_2 992.0357545695241
R16368 n_18_22_2 n_19_22_2 13500.372527212538
R16369 n_18_22_2 n_18_23_2 9.447963021099222
R16370 n_18_22_2 n_18_22_3 928.5454662770746
R16371 n_18_22_3 n_19_22_3 189005.21538097534
R16372 n_18_22_3 n_18_23_3 132.27148229538898
R16373 n_18_22_3 n_18_22_4 12.345333834642977
R16374 n_18_22_4 n_19_22_4 5727.430769120465
R16375 n_18_22_4 n_18_23_4 4.008226736223907
R16376 n_18_22_15 n_19_22_15 378010.4307619473
R16377 n_18_22_15 n_18_23_15 264.54296459077557
R16378 n_18_23_0 n_19_23_0 5400.149010884632
R16379 n_18_23_0 n_18_24_0 43.561715139231126
R16380 n_18_23_0 n_18_23_1 436.49573201055955
R16381 n_18_23_1 n_19_23_1 7560.208615238482
R16382 n_18_23_1 n_18_24_1 60.986401194923566
R16383 n_18_23_1 n_18_23_2 992.0357545694536
R16384 n_18_23_2 n_19_23_2 13500.37252721158
R16385 n_18_23_2 n_18_24_2 108.90428784807781
R16386 n_18_23_2 n_18_23_3 928.5454662770086
R16387 n_18_23_3 n_19_23_3 189005.2153809619
R16388 n_18_23_3 n_18_24_3 1524.6600298730878
R16389 n_18_23_3 n_18_23_4 12.345333834642101
R16390 n_18_23_4 n_19_23_4 5727.430769120058
R16391 n_18_23_4 n_18_24_4 46.20181908706326
R16392 n_18_23_15 n_19_23_15 378010.4307619204
R16393 n_18_23_15 n_18_24_15 3049.3200597461487
R16394 n_18_24_0 n_19_24_0 244.8658962374671
R16395 n_18_24_0 n_18_25_0 83.34424507002228
R16396 n_18_24_0 n_18_24_1 19.792586909576
R16397 n_18_24_1 n_19_24_1 342.8122547324539
R16398 n_18_24_1 n_18_25_1 116.6819430980312
R16399 n_18_24_1 n_18_24_2 44.98315206721817
R16400 n_18_24_2 n_19_24_2 612.1647405936677
R16401 n_18_24_2 n_18_25_2 208.36061267505573
R16402 n_18_24_2 n_18_24_3 42.10423033491621
R16403 n_18_24_3 n_19_24_3 8570.30636831134
R16404 n_18_24_3 n_18_25_3 2917.0485774507774
R16405 n_18_24_3 n_18_24_4 0.5597903368364934
R16406 n_18_24_4 n_19_24_4 259.70625358519214
R16407 n_18_24_4 n_18_25_4 88.39541143790234
R16408 n_18_24_4 n_18_24_5 0.46268384983424454
R16409 n_18_24_5 n_19_24_5 1632.439308249779
R16410 n_18_24_5 n_18_25_5 555.6283004668147
R16411 n_18_24_5 n_18_24_6 0.1599400962389981
R16412 n_18_24_6 n_19_24_6 272.07321804162984
R16413 n_18_24_6 n_18_25_6 92.60471674446912
R16414 n_18_24_6 n_18_24_7 0.21706155918149717
R16415 n_18_24_7 n_19_24_7 466.4112309285097
R16416 n_18_24_7 n_18_25_7 158.75094299051898
R16417 n_18_24_7 n_18_24_8 0.1599400962389976
R16418 n_18_24_8 n_19_24_8 466.4112309285097
R16419 n_18_24_8 n_18_25_8 158.75094299051898
R16420 n_18_24_8 n_18_24_9 0.1599400962389976
R16421 n_18_24_9 n_19_24_9 466.4112309285097
R16422 n_18_24_9 n_18_25_9 158.75094299051898
R16423 n_18_24_9 n_18_24_10 0.1599400962389976
R16424 n_18_24_10 n_19_24_10 466.4112309285097
R16425 n_18_24_10 n_18_25_10 158.75094299051898
R16426 n_18_24_10 n_18_24_11 0.15994009623899658
R16427 n_18_24_11 n_19_24_11 466.4112309285157
R16428 n_18_24_11 n_18_25_11 158.75094299052103
R16429 n_18_24_11 n_18_24_12 0.15994009623899608
R16430 n_18_24_12 n_19_24_12 466.41123092851274
R16431 n_18_24_12 n_18_25_12 158.75094299052
R16432 n_18_24_12 n_18_24_13 0.1599400962389976
R16433 n_18_24_13 n_19_24_13 466.4112309285068
R16434 n_18_24_13 n_18_25_13 158.75094299051796
R16435 n_18_24_13 n_18_24_14 0.7997004811949899
R16436 n_18_24_14 n_19_24_14 51.82347010316764
R16437 n_18_24_14 n_18_25_14 17.638993665613185
R16438 n_18_24_14 n_18_24_15 24.710744868925417
R16439 n_18_24_15 n_19_24_15 17140.612736622526
R16440 n_18_24_15 n_18_25_15 5834.097154901503
R16441 n_18_25_0 n_19_25_0 244.8658962374679
R16442 n_18_25_0 n_18_26_0 83.34424507002228
R16443 n_18_25_0 n_18_25_1 19.792586909576062
R16444 n_18_25_1 n_19_25_1 342.812254732455
R16445 n_18_25_1 n_18_26_1 116.6819430980312
R16446 n_18_25_1 n_18_25_2 44.98315206721832
R16447 n_18_25_2 n_19_25_2 612.1647405936696
R16448 n_18_25_2 n_18_26_2 208.36061267505573
R16449 n_18_25_2 n_18_25_3 42.10423033491635
R16450 n_18_25_3 n_19_25_3 8570.306368311369
R16451 n_18_25_3 n_18_26_3 2917.0485774507774
R16452 n_18_25_3 n_18_25_4 0.5597903368364952
R16453 n_18_25_4 n_19_25_4 259.70625358519294
R16454 n_18_25_4 n_18_26_4 88.39541143790234
R16455 n_18_25_4 n_18_25_5 0.46268384983424593
R16456 n_18_25_5 n_19_25_5 1632.439308249784
R16457 n_18_25_5 n_18_26_5 555.6283004668147
R16458 n_18_25_5 n_18_25_6 0.1599400962389986
R16459 n_18_25_6 n_19_25_6 272.07321804163075
R16460 n_18_25_6 n_18_26_6 92.60471674446912
R16461 n_18_25_6 n_18_25_7 0.21706155918149783
R16462 n_18_25_7 n_19_25_7 466.41123092851126
R16463 n_18_25_7 n_18_26_7 158.75094299051898
R16464 n_18_25_7 n_18_25_8 0.1599400962389981
R16465 n_18_25_8 n_19_25_8 466.41123092851126
R16466 n_18_25_8 n_18_26_8 158.75094299051898
R16467 n_18_25_8 n_18_25_9 0.1599400962389981
R16468 n_18_25_9 n_19_25_9 466.41123092851126
R16469 n_18_25_9 n_18_26_9 158.75094299051898
R16470 n_18_25_9 n_18_25_10 0.1599400962389981
R16471 n_18_25_10 n_19_25_10 466.41123092851126
R16472 n_18_25_10 n_18_26_10 158.75094299051898
R16473 n_18_25_10 n_18_25_11 0.15994009623899708
R16474 n_18_25_11 n_19_25_11 466.4112309285172
R16475 n_18_25_11 n_18_26_11 158.75094299052103
R16476 n_18_25_11 n_18_25_12 0.15994009623899658
R16477 n_18_25_12 n_19_25_12 466.4112309285141
R16478 n_18_25_12 n_18_26_12 158.75094299052
R16479 n_18_25_12 n_18_25_13 0.1599400962389981
R16480 n_18_25_13 n_19_25_13 466.41123092850836
R16481 n_18_25_13 n_18_26_13 158.75094299051796
R16482 n_18_25_13 n_18_25_14 0.7997004811949925
R16483 n_18_25_14 n_19_25_14 51.8234701031678
R16484 n_18_25_14 n_18_26_14 17.638993665613185
R16485 n_18_25_14 n_18_25_15 24.7107448689255
R16486 n_18_25_15 n_19_25_15 17140.612736622585
R16487 n_18_25_15 n_18_26_15 5834.097154901503
R16488 n_18_26_0 n_19_26_0 244.8658962374671
R16489 n_18_26_0 n_18_27_0 83.34424507002242
R16490 n_18_26_0 n_18_26_1 19.792586909576
R16491 n_18_26_1 n_19_26_1 342.8122547324539
R16492 n_18_26_1 n_18_27_1 116.68194309803138
R16493 n_18_26_1 n_18_26_2 44.98315206721817
R16494 n_18_26_2 n_19_26_2 612.1647405936677
R16495 n_18_26_2 n_18_27_2 208.36061267505607
R16496 n_18_26_2 n_18_26_3 42.10423033491621
R16497 n_18_26_3 n_19_26_3 8570.30636831134
R16498 n_18_26_3 n_18_27_3 2917.048577450782
R16499 n_18_26_3 n_18_26_4 0.5597903368364934
R16500 n_18_26_4 n_19_26_4 259.70625358519214
R16501 n_18_26_4 n_18_27_4 88.39541143790247
R16502 n_18_26_4 n_18_26_5 0.46268384983424454
R16503 n_18_26_5 n_19_26_5 1632.439308249779
R16504 n_18_26_5 n_18_27_5 555.6283004668156
R16505 n_18_26_5 n_18_26_6 0.1599400962389981
R16506 n_18_26_6 n_19_26_6 272.07321804162984
R16507 n_18_26_6 n_18_27_6 92.60471674446926
R16508 n_18_26_6 n_18_26_7 0.21706155918149717
R16509 n_18_26_7 n_19_26_7 466.4112309285097
R16510 n_18_26_7 n_18_27_7 158.75094299051923
R16511 n_18_26_7 n_18_26_8 0.1599400962389976
R16512 n_18_26_8 n_19_26_8 466.4112309285097
R16513 n_18_26_8 n_18_27_8 158.75094299051923
R16514 n_18_26_8 n_18_26_9 0.1599400962389976
R16515 n_18_26_9 n_19_26_9 466.4112309285097
R16516 n_18_26_9 n_18_27_9 158.75094299051923
R16517 n_18_26_9 n_18_26_10 0.1599400962389976
R16518 n_18_26_10 n_19_26_10 466.4112309285097
R16519 n_18_26_10 n_18_27_10 158.75094299051923
R16520 n_18_26_10 n_18_26_11 0.15994009623899658
R16521 n_18_26_11 n_19_26_11 466.4112309285157
R16522 n_18_26_11 n_18_27_11 158.75094299052125
R16523 n_18_26_11 n_18_26_12 0.15994009623899608
R16524 n_18_26_12 n_19_26_12 466.41123092851274
R16525 n_18_26_12 n_18_27_12 158.75094299052026
R16526 n_18_26_12 n_18_26_13 0.1599400962389976
R16527 n_18_26_13 n_19_26_13 466.4112309285068
R16528 n_18_26_13 n_18_27_13 158.7509429905182
R16529 n_18_26_13 n_18_26_14 0.7997004811949899
R16530 n_18_26_14 n_19_26_14 51.82347010316764
R16531 n_18_26_14 n_18_27_14 17.63899366561321
R16532 n_18_26_14 n_18_26_15 24.710744868925417
R16533 n_18_26_15 n_19_26_15 17140.612736622526
R16534 n_18_26_15 n_18_27_15 5834.097154901512
R16535 n_18_27_0 n_19_27_0 244.8658962374671
R16536 n_18_27_0 n_18_27_1 19.792586909576
R16537 n_18_27_1 n_19_27_1 342.8122547324539
R16538 n_18_27_1 n_18_27_2 44.98315206721817
R16539 n_18_27_2 n_19_27_2 612.1647405936677
R16540 n_18_27_2 n_18_27_3 42.10423033491621
R16541 n_18_27_3 n_19_27_3 8570.30636831134
R16542 n_18_27_3 n_18_27_4 0.5597903368364934
R16543 n_18_27_4 n_19_27_4 259.70625358519214
R16544 n_18_27_4 n_18_27_5 0.46268384983424454
R16545 n_18_27_5 n_19_27_5 1632.439308249779
R16546 n_18_27_5 n_18_27_6 0.1599400962389981
R16547 n_18_27_6 n_19_27_6 272.07321804162984
R16548 n_18_27_6 n_18_27_7 0.21706155918149717
R16549 n_18_27_7 n_19_27_7 466.4112309285097
R16550 n_18_27_7 n_18_27_8 0.1599400962389976
R16551 n_18_27_8 n_19_27_8 466.4112309285097
R16552 n_18_27_8 n_18_27_9 0.1599400962389976
R16553 n_18_27_9 n_19_27_9 466.4112309285097
R16554 n_18_27_9 n_18_27_10 0.1599400962389976
R16555 n_18_27_10 n_19_27_10 466.4112309285097
R16556 n_18_27_10 n_18_27_11 0.15994009623899658
R16557 n_18_27_11 n_19_27_11 466.4112309285157
R16558 n_18_27_11 n_18_27_12 0.15994009623899608
R16559 n_18_27_12 n_19_27_12 466.41123092851274
R16560 n_18_27_12 n_18_27_13 0.1599400962389976
R16561 n_18_27_13 n_19_27_13 466.4112309285068
R16562 n_18_27_13 n_18_27_14 0.7997004811949899
R16563 n_18_27_14 n_19_27_14 51.82347010316764
R16564 n_18_27_14 n_18_27_15 24.710744868925417
R16565 n_18_27_15 n_19_27_15 17140.612736622526
R16566 n_19_0_0 n_20_0_0 125.67181420979068
R16567 n_19_0_0 n_19_1_0 83.34425224761593
R16568 n_19_0_0 n_19_0_1 19.792585205041586
R16569 n_19_0_1 n_20_0_1 175.9405398937069
R16570 n_19_0_1 n_19_1_1 116.6819531466623
R16571 n_19_0_1 n_19_0_2 44.98314819327633
R16572 n_19_0_2 n_20_0_2 314.1795355244767
R16573 n_19_0_2 n_19_1_2 208.3606306190398
R16574 n_19_0_2 n_19_0_3 42.104226708906644
R16575 n_19_0_3 n_20_0_3 4398.513497342668
R16576 n_19_0_3 n_19_1_3 2917.048828666555
R16577 n_19_0_3 n_19_0_4 0.5597902886274392
R16578 n_19_0_4 n_20_0_4 133.2882877982627
R16579 n_19_0_4 n_19_1_4 88.39541905050166
R16580 n_19_0_4 n_19_0_5 0.4626838099879854
R16581 n_19_0_5 n_20_0_5 837.8120947319369
R16582 n_19_0_5 n_19_1_5 555.6283483174391
R16583 n_19_0_5 n_19_0_6 0.15994008246498265
R16584 n_19_0_6 n_20_0_6 139.6353491219895
R16585 n_19_0_6 n_19_1_6 92.60472471957317
R16586 n_19_0_6 n_19_0_7 0.21706154048819049
R16587 n_19_0_7 n_20_0_7 239.37488420912558
R16588 n_19_0_7 n_19_1_7 158.75095666212593
R16589 n_19_0_7 n_19_0_8 0.15994008246498215
R16590 n_19_0_8 n_20_0_8 239.37488420912558
R16591 n_19_0_8 n_19_1_8 158.75095666212593
R16592 n_19_0_8 n_19_0_9 0.15994008246498215
R16593 n_19_0_9 n_20_0_9 239.37488420912558
R16594 n_19_0_9 n_19_1_9 158.75095666212593
R16595 n_19_0_9 n_19_0_10 0.15994008246498215
R16596 n_19_0_10 n_20_0_10 239.37488420912558
R16597 n_19_0_10 n_19_1_10 158.75095666212593
R16598 n_19_0_10 n_19_0_11 0.15994008246498112
R16599 n_19_0_11 n_20_0_11 239.37488420912865
R16600 n_19_0_11 n_19_1_11 158.75095666212795
R16601 n_19_0_11 n_19_0_12 0.1599400824649806
R16602 n_19_0_12 n_20_0_12 239.3748842091272
R16603 n_19_0_12 n_19_1_12 158.7509566621269
R16604 n_19_0_12 n_19_0_13 0.15994008246498215
R16605 n_19_0_13 n_20_0_13 239.3748842091241
R16606 n_19_0_13 n_19_1_13 158.75095666212493
R16607 n_19_0_13 n_19_0_14 0.7997004123249127
R16608 n_19_0_14 n_20_0_14 26.597209356569458
R16609 n_19_0_14 n_19_1_14 17.638995184680617
R16610 n_19_0_14 n_19_0_15 24.710742740840033
R16611 n_19_0_15 n_20_0_15 8797.02699468526
R16612 n_19_0_15 n_19_1_15 5834.097657333058
R16613 n_19_1_0 n_20_1_0 125.67181420979068
R16614 n_19_1_0 n_19_2_0 83.34425224761593
R16615 n_19_1_0 n_19_1_1 19.792585205041586
R16616 n_19_1_1 n_20_1_1 175.9405398937069
R16617 n_19_1_1 n_19_2_1 116.6819531466623
R16618 n_19_1_1 n_19_1_2 44.98314819327633
R16619 n_19_1_2 n_20_1_2 314.1795355244767
R16620 n_19_1_2 n_19_2_2 208.3606306190398
R16621 n_19_1_2 n_19_1_3 42.104226708906644
R16622 n_19_1_3 n_20_1_3 4398.513497342668
R16623 n_19_1_3 n_19_2_3 2917.048828666555
R16624 n_19_1_3 n_19_1_4 0.5597902886274392
R16625 n_19_1_4 n_20_1_4 133.2882877982627
R16626 n_19_1_4 n_19_2_4 88.39541905050166
R16627 n_19_1_4 n_19_1_5 0.4626838099879854
R16628 n_19_1_5 n_20_1_5 837.8120947319369
R16629 n_19_1_5 n_19_2_5 555.6283483174391
R16630 n_19_1_5 n_19_1_6 0.15994008246498265
R16631 n_19_1_6 n_20_1_6 139.6353491219895
R16632 n_19_1_6 n_19_2_6 92.60472471957317
R16633 n_19_1_6 n_19_1_7 0.21706154048819049
R16634 n_19_1_7 n_20_1_7 239.37488420912558
R16635 n_19_1_7 n_19_2_7 158.75095666212593
R16636 n_19_1_7 n_19_1_8 0.15994008246498215
R16637 n_19_1_8 n_20_1_8 239.37488420912558
R16638 n_19_1_8 n_19_2_8 158.75095666212593
R16639 n_19_1_8 n_19_1_9 0.15994008246498215
R16640 n_19_1_9 n_20_1_9 239.37488420912558
R16641 n_19_1_9 n_19_2_9 158.75095666212593
R16642 n_19_1_9 n_19_1_10 0.15994008246498215
R16643 n_19_1_10 n_20_1_10 239.37488420912558
R16644 n_19_1_10 n_19_2_10 158.75095666212593
R16645 n_19_1_10 n_19_1_11 0.15994008246498112
R16646 n_19_1_11 n_20_1_11 239.37488420912865
R16647 n_19_1_11 n_19_2_11 158.75095666212795
R16648 n_19_1_11 n_19_1_12 0.1599400824649806
R16649 n_19_1_12 n_20_1_12 239.3748842091272
R16650 n_19_1_12 n_19_2_12 158.7509566621269
R16651 n_19_1_12 n_19_1_13 0.15994008246498215
R16652 n_19_1_13 n_20_1_13 239.3748842091241
R16653 n_19_1_13 n_19_2_13 158.75095666212493
R16654 n_19_1_13 n_19_1_14 0.7997004123249127
R16655 n_19_1_14 n_20_1_14 26.597209356569458
R16656 n_19_1_14 n_19_2_14 17.638995184680617
R16657 n_19_1_14 n_19_1_15 24.710742740840033
R16658 n_19_1_15 n_20_1_15 8797.02699468526
R16659 n_19_1_15 n_19_2_15 5834.097657333058
R16660 n_19_2_0 n_20_2_0 125.67181420979068
R16661 n_19_2_0 n_19_3_0 83.34425224761593
R16662 n_19_2_0 n_19_2_1 19.792585205041586
R16663 n_19_2_1 n_20_2_1 175.9405398937069
R16664 n_19_2_1 n_19_3_1 116.6819531466623
R16665 n_19_2_1 n_19_2_2 44.98314819327633
R16666 n_19_2_2 n_20_2_2 314.1795355244767
R16667 n_19_2_2 n_19_3_2 208.3606306190398
R16668 n_19_2_2 n_19_2_3 42.104226708906644
R16669 n_19_2_3 n_20_2_3 4398.513497342668
R16670 n_19_2_3 n_19_3_3 2917.048828666555
R16671 n_19_2_3 n_19_2_4 0.5597902886274392
R16672 n_19_2_4 n_20_2_4 133.2882877982627
R16673 n_19_2_4 n_19_3_4 88.39541905050166
R16674 n_19_2_4 n_19_2_5 0.4626838099879854
R16675 n_19_2_5 n_20_2_5 837.8120947319369
R16676 n_19_2_5 n_19_3_5 555.6283483174391
R16677 n_19_2_5 n_19_2_6 0.15994008246498265
R16678 n_19_2_6 n_20_2_6 139.6353491219895
R16679 n_19_2_6 n_19_3_6 92.60472471957317
R16680 n_19_2_6 n_19_2_7 0.21706154048819049
R16681 n_19_2_7 n_20_2_7 239.37488420912558
R16682 n_19_2_7 n_19_3_7 158.75095666212593
R16683 n_19_2_7 n_19_2_8 0.15994008246498215
R16684 n_19_2_8 n_20_2_8 239.37488420912558
R16685 n_19_2_8 n_19_3_8 158.75095666212593
R16686 n_19_2_8 n_19_2_9 0.15994008246498215
R16687 n_19_2_9 n_20_2_9 239.37488420912558
R16688 n_19_2_9 n_19_3_9 158.75095666212593
R16689 n_19_2_9 n_19_2_10 0.15994008246498215
R16690 n_19_2_10 n_20_2_10 239.37488420912558
R16691 n_19_2_10 n_19_3_10 158.75095666212593
R16692 n_19_2_10 n_19_2_11 0.15994008246498112
R16693 n_19_2_11 n_20_2_11 239.37488420912865
R16694 n_19_2_11 n_19_3_11 158.75095666212795
R16695 n_19_2_11 n_19_2_12 0.1599400824649806
R16696 n_19_2_12 n_20_2_12 239.3748842091272
R16697 n_19_2_12 n_19_3_12 158.7509566621269
R16698 n_19_2_12 n_19_2_13 0.15994008246498215
R16699 n_19_2_13 n_20_2_13 239.3748842091241
R16700 n_19_2_13 n_19_3_13 158.75095666212493
R16701 n_19_2_13 n_19_2_14 0.7997004123249127
R16702 n_19_2_14 n_20_2_14 26.597209356569458
R16703 n_19_2_14 n_19_3_14 17.638995184680617
R16704 n_19_2_14 n_19_2_15 24.710742740840033
R16705 n_19_2_15 n_20_2_15 8797.02699468526
R16706 n_19_2_15 n_19_3_15 5834.097657333058
R16707 n_19_3_0 n_20_3_0 125.67181420979068
R16708 n_19_3_0 n_19_4_0 43.561715139230984
R16709 n_19_3_0 n_19_3_1 19.792585205041586
R16710 n_19_3_1 n_20_3_1 175.9405398937069
R16711 n_19_3_1 n_19_4_1 60.986401194923374
R16712 n_19_3_1 n_19_3_2 44.98314819327633
R16713 n_19_3_2 n_20_3_2 314.1795355244767
R16714 n_19_3_2 n_19_4_2 108.90428784807744
R16715 n_19_3_2 n_19_3_3 42.104226708906644
R16716 n_19_3_3 n_20_3_3 4398.513497342668
R16717 n_19_3_3 n_19_4_3 1524.6600298730832
R16718 n_19_3_3 n_19_3_4 0.5597902886274392
R16719 n_19_3_4 n_20_3_4 133.2882877982627
R16720 n_19_3_4 n_19_4_4 46.20181908706312
R16721 n_19_3_4 n_19_3_5 0.4626838099879854
R16722 n_19_3_5 n_20_3_5 837.8120947319369
R16723 n_19_3_5 n_19_3_6 0.15994008246498265
R16724 n_19_3_6 n_20_3_6 139.6353491219895
R16725 n_19_3_6 n_19_3_7 0.21706154048819049
R16726 n_19_3_7 n_20_3_7 239.37488420912558
R16727 n_19_3_7 n_19_3_8 0.15994008246498215
R16728 n_19_3_8 n_20_3_8 239.37488420912558
R16729 n_19_3_8 n_19_3_9 0.15994008246498215
R16730 n_19_3_9 n_20_3_9 239.37488420912558
R16731 n_19_3_9 n_19_3_10 0.15994008246498215
R16732 n_19_3_10 n_20_3_10 239.37488420912558
R16733 n_19_3_10 n_19_3_11 0.15994008246498112
R16734 n_19_3_11 n_20_3_11 239.37488420912865
R16735 n_19_3_11 n_19_3_12 0.1599400824649806
R16736 n_19_3_12 n_20_3_12 239.3748842091272
R16737 n_19_3_12 n_19_3_13 0.15994008246498215
R16738 n_19_3_13 n_20_3_13 239.3748842091241
R16739 n_19_3_13 n_19_3_14 0.7997004123249127
R16740 n_19_3_14 n_20_3_14 26.597209356569458
R16741 n_19_3_14 n_19_3_15 24.710742740840033
R16742 n_19_3_15 n_20_3_15 8797.02699468526
R16743 n_19_3_15 n_19_4_15 3049.320059746139
R16744 n_19_4_0 n_20_4_0 2771.508327585062
R16745 n_19_4_0 n_19_5_0 3.779178030846073
R16746 n_19_4_0 n_19_4_1 436.49656102391225
R16747 n_19_4_1 n_20_4_1 3880.111658619087
R16748 n_19_4_1 n_19_5_1 5.290849243184502
R16749 n_19_4_1 n_19_4_2 992.0376386907095
R16750 n_19_4_2 n_20_4_2 6928.7708189626555
R16751 n_19_4_2 n_19_5_2 9.447945077115182
R16752 n_19_4_2 n_19_4_3 928.547229814504
R16753 n_19_4_3 n_20_4_3 97002.7914654771
R16754 n_19_4_3 n_19_5_3 132.27123107961245
R16755 n_19_4_3 n_19_4_4 12.345357281484397
R16756 n_19_4_4 n_20_4_4 2939.4785292568818
R16757 n_19_4_4 n_19_5_4 4.008219123624619
R16758 n_19_4_15 n_20_4_15 194005.58293095249
R16759 n_19_4_15 n_19_5_15 264.5424621592225
R16760 n_19_5_0 n_20_5_0 2771.5083275850134
R16761 n_19_5_0 n_19_6_0 3.7791780308461065
R16762 n_19_5_0 n_19_5_1 436.49656102390446
R16763 n_19_5_1 n_20_5_1 3880.111658619018
R16764 n_19_5_1 n_19_6_1 5.290849243184549
R16765 n_19_5_1 n_19_5_2 992.0376386906918
R16766 n_19_5_2 n_20_5_2 6928.770818962533
R16767 n_19_5_2 n_19_6_2 9.447945077115266
R16768 n_19_5_2 n_19_5_3 928.5472298144875
R16769 n_19_5_3 n_20_5_3 97002.79146547537
R16770 n_19_5_3 n_19_6_3 132.2712310796136
R16771 n_19_5_3 n_19_5_4 12.345357281484178
R16772 n_19_5_4 n_20_5_4 2939.4785292568295
R16773 n_19_5_4 n_19_6_4 4.008219123624655
R16774 n_19_5_15 n_20_5_15 194005.58293094902
R16775 n_19_5_15 n_19_6_15 264.5424621592249
R16776 n_19_6_0 n_20_6_0 2771.5083275850134
R16777 n_19_6_0 n_19_7_0 3.779178030846073
R16778 n_19_6_0 n_19_6_1 436.49656102390446
R16779 n_19_6_1 n_20_6_1 3880.111658619018
R16780 n_19_6_1 n_19_7_1 5.290849243184502
R16781 n_19_6_1 n_19_6_2 992.0376386906918
R16782 n_19_6_2 n_20_6_2 6928.770818962533
R16783 n_19_6_2 n_19_7_2 9.447945077115182
R16784 n_19_6_2 n_19_6_3 928.5472298144875
R16785 n_19_6_3 n_20_6_3 97002.79146547537
R16786 n_19_6_3 n_19_7_3 132.27123107961245
R16787 n_19_6_3 n_19_6_4 12.345357281484178
R16788 n_19_6_4 n_20_6_4 2939.4785292568295
R16789 n_19_6_4 n_19_7_4 4.008219123624619
R16790 n_19_6_15 n_20_6_15 194005.58293094902
R16791 n_19_6_15 n_19_7_15 264.5424621592225
R16792 n_19_7_0 n_20_7_0 2771.508327585062
R16793 n_19_7_0 n_19_8_0 110.44365038628528
R16794 n_19_7_0 n_19_7_1 436.49656102391225
R16795 n_19_7_1 n_20_7_1 3880.111658619087
R16796 n_19_7_1 n_19_8_1 154.62111054079944
R16797 n_19_7_1 n_19_7_2 992.0376386907095
R16798 n_19_7_2 n_20_7_2 6928.7708189626555
R16799 n_19_7_2 n_19_8_2 276.10912596571325
R16800 n_19_7_2 n_19_7_3 928.547229814504
R16801 n_19_7_3 n_20_7_3 97002.7914654771
R16802 n_19_7_3 n_19_8_3 3865.5277635199823
R16803 n_19_7_3 n_19_7_4 12.345357281484397
R16804 n_19_7_4 n_20_7_4 2939.4785292568818
R16805 n_19_7_4 n_19_8_4 117.13720495515096
R16806 n_19_7_15 n_20_7_15 194005.58293095249
R16807 n_19_7_15 n_19_8_15 7731.055527039895
R16808 n_19_8_0 n_20_8_0 48.24335106234782
R16809 n_19_8_0 n_19_9_0 217.10812274172463
R16810 n_19_8_0 n_19_8_1 7.598049272084611
R16811 n_19_8_1 n_20_8_1 67.54069148728694
R16812 n_19_8_1 n_19_9_1 303.9513718384145
R16813 n_19_8_1 n_19_8_2 17.268293800192296
R16814 n_19_8_2 n_20_8_2 120.60837765586953
R16815 n_19_8_2 n_19_9_2 542.7703068543115
R16816 n_19_8_2 n_19_8_3 16.16312299697999
R16817 n_19_8_3 n_20_8_3 1688.517287182172
R16818 n_19_8_3 n_19_9_3 7598.784295960355
R16819 n_19_8_3 n_19_8_4 0.2148943228468377
R16820 n_19_8_4 n_20_8_4 51.16719052067188
R16821 n_19_8_4 n_19_9_4 230.26619078667744
R16822 n_19_8_4 n_19_8_5 0.2148943228468377
R16823 n_19_8_5 n_19_9_5 7598.784295960355
R16824 n_19_8_5 n_19_8_6 0.4144390512046156
R16825 n_19_8_6 n_19_9_6 1688.6187324356342
R16826 n_19_8_6 n_19_8_7 0.5832845905842732
R16827 n_19_8_7 n_19_9_7 2894.774969889668
R16828 n_19_8_7 n_19_8_8 0.4297886456936741
R16829 n_19_8_8 n_19_9_8 2894.774969889668
R16830 n_19_8_8 n_19_8_9 0.4297886456936741
R16831 n_19_8_9 n_19_9_9 2894.774969889668
R16832 n_19_8_9 n_19_8_10 0.4297886456936741
R16833 n_19_8_10 n_19_9_10 2894.774969889668
R16834 n_19_8_10 n_19_8_11 0.42978864569367137
R16835 n_19_8_11 n_19_9_11 2894.774969889705
R16836 n_19_8_11 n_19_8_12 0.4297886456936699
R16837 n_19_8_12 n_19_9_12 2894.7749698896864
R16838 n_19_8_12 n_19_8_13 0.42978864569367403
R16839 n_19_8_13 n_19_9_13 2894.77496988965
R16840 n_19_8_13 n_19_8_14 2.148943228468376
R16841 n_19_8_14 n_19_9_14 321.64166332107345
R16842 n_19_8_14 n_19_8_15 11.14380559905752
R16843 n_19_8_15 n_20_8_15 3377.034574364314
R16844 n_19_8_15 n_19_9_15 15197.568591920575
R16845 n_19_9_0 n_20_9_0 48.243351062347784
R16846 n_19_9_0 n_19_10_0 217.10812274172463
R16847 n_19_9_0 n_19_9_1 7.598049272084607
R16848 n_19_9_1 n_20_9_1 67.5406914872869
R16849 n_19_9_1 n_19_10_1 303.9513718384145
R16850 n_19_9_1 n_19_9_2 17.268293800192286
R16851 n_19_9_2 n_20_9_2 120.60837765586945
R16852 n_19_9_2 n_19_10_2 542.7703068543115
R16853 n_19_9_2 n_19_9_3 16.16312299697998
R16854 n_19_9_3 n_20_9_3 1688.517287182171
R16855 n_19_9_3 n_19_10_3 7598.784295960355
R16856 n_19_9_3 n_19_9_4 0.21489432284683754
R16857 n_19_9_4 n_20_9_4 51.167190520671845
R16858 n_19_9_4 n_19_10_4 230.26619078667744
R16859 n_19_9_4 n_19_9_5 0.21489432284683754
R16860 n_19_9_5 n_19_10_5 7598.784295960355
R16861 n_19_9_5 n_19_9_6 0.41443905120461527
R16862 n_19_9_6 n_19_10_6 1688.6187324356342
R16863 n_19_9_6 n_19_9_7 0.5832845905842726
R16864 n_19_9_7 n_19_10_7 2894.774969889668
R16865 n_19_9_7 n_19_9_8 0.4297886456936737
R16866 n_19_9_8 n_19_10_8 2894.774969889668
R16867 n_19_9_8 n_19_9_9 0.4297886456936737
R16868 n_19_9_9 n_19_10_9 2894.774969889668
R16869 n_19_9_9 n_19_9_10 0.4297886456936737
R16870 n_19_9_10 n_19_10_10 2894.774969889668
R16871 n_19_9_10 n_19_9_11 0.429788645693671
R16872 n_19_9_11 n_19_10_11 2894.774969889705
R16873 n_19_9_11 n_19_9_12 0.4297886456936696
R16874 n_19_9_12 n_19_10_12 2894.7749698896864
R16875 n_19_9_12 n_19_9_13 0.4297886456936737
R16876 n_19_9_13 n_19_10_13 2894.77496988965
R16877 n_19_9_13 n_19_9_14 2.148943228468374
R16878 n_19_9_14 n_19_10_14 321.64166332107345
R16879 n_19_9_14 n_19_9_15 11.143805599057513
R16880 n_19_9_15 n_20_9_15 3377.034574364312
R16881 n_19_9_15 n_19_10_15 15197.568591920575
R16882 n_19_10_0 n_20_10_0 48.24335106234782
R16883 n_19_10_0 n_19_11_0 217.10812274172454
R16884 n_19_10_0 n_19_10_1 7.598049272084611
R16885 n_19_10_1 n_20_10_1 67.54069148728694
R16886 n_19_10_1 n_19_11_1 303.9513718384144
R16887 n_19_10_1 n_19_10_2 17.268293800192296
R16888 n_19_10_2 n_20_10_2 120.60837765586953
R16889 n_19_10_2 n_19_11_2 542.7703068543113
R16890 n_19_10_2 n_19_10_3 16.16312299697999
R16891 n_19_10_3 n_20_10_3 1688.517287182172
R16892 n_19_10_3 n_19_11_3 7598.784295960353
R16893 n_19_10_3 n_19_10_4 0.2148943228468377
R16894 n_19_10_4 n_20_10_4 51.16719052067188
R16895 n_19_10_4 n_19_11_4 230.26619078667736
R16896 n_19_10_4 n_19_10_5 0.2148943228468377
R16897 n_19_10_5 n_19_11_5 7598.784295960353
R16898 n_19_10_5 n_19_10_6 0.4144390512046156
R16899 n_19_10_6 n_19_11_6 1688.6187324356338
R16900 n_19_10_6 n_19_10_7 0.5832845905842732
R16901 n_19_10_7 n_19_11_7 2894.774969889667
R16902 n_19_10_7 n_19_10_8 0.4297886456936741
R16903 n_19_10_8 n_19_11_8 2894.774969889667
R16904 n_19_10_8 n_19_10_9 0.4297886456936741
R16905 n_19_10_9 n_19_11_9 2894.774969889667
R16906 n_19_10_9 n_19_10_10 0.4297886456936741
R16907 n_19_10_10 n_19_11_10 2894.774969889667
R16908 n_19_10_10 n_19_10_11 0.42978864569367137
R16909 n_19_10_11 n_19_11_11 2894.774969889704
R16910 n_19_10_11 n_19_10_12 0.4297886456936699
R16911 n_19_10_12 n_19_11_12 2894.7749698896855
R16912 n_19_10_12 n_19_10_13 0.42978864569367403
R16913 n_19_10_13 n_19_11_13 2894.774969889649
R16914 n_19_10_13 n_19_10_14 2.148943228468376
R16915 n_19_10_14 n_19_11_14 321.6416633210734
R16916 n_19_10_14 n_19_10_15 11.14380559905752
R16917 n_19_10_15 n_20_10_15 3377.034574364314
R16918 n_19_10_15 n_19_11_15 15197.56859192057
R16919 n_19_11_0 n_20_11_0 48.24335106234782
R16920 n_19_11_0 n_19_12_0 110.44365362970504
R16921 n_19_11_0 n_19_11_1 7.598049272084611
R16922 n_19_11_1 n_20_11_1 67.54069148728694
R16923 n_19_11_1 n_19_12_1 154.62111508158705
R16924 n_19_11_1 n_19_11_2 17.268293800192296
R16925 n_19_11_2 n_20_11_2 120.60837765586953
R16926 n_19_11_2 n_19_12_2 276.10913407426256
R16927 n_19_11_2 n_19_11_3 16.16312299697999
R16928 n_19_11_3 n_20_11_3 1688.517287182172
R16929 n_19_11_3 n_19_12_3 3865.527877039673
R16930 n_19_11_3 n_19_11_4 0.2148943228468377
R16931 n_19_11_4 n_20_11_4 51.16719052067188
R16932 n_19_11_4 n_19_12_4 117.13720839514161
R16933 n_19_11_4 n_19_11_5 0.2148943228468377
R16934 n_19_11_5 n_19_11_6 0.4144390512046156
R16935 n_19_11_6 n_19_11_7 0.5832845905842732
R16936 n_19_11_7 n_19_11_8 0.4297886456936741
R16937 n_19_11_8 n_19_11_9 0.4297886456936741
R16938 n_19_11_9 n_19_11_10 0.4297886456936741
R16939 n_19_11_10 n_19_11_11 0.42978864569367137
R16940 n_19_11_11 n_19_11_12 0.4297886456936699
R16941 n_19_11_12 n_19_11_13 0.42978864569367403
R16942 n_19_11_13 n_19_11_14 2.148943228468376
R16943 n_19_11_14 n_19_11_15 11.14380559905752
R16944 n_19_11_15 n_20_11_15 3377.034574364314
R16945 n_19_11_15 n_19_12_15 7731.055754079277
R16946 n_19_12_0 n_20_12_0 2771.5035703868975
R16947 n_19_12_0 n_19_13_0 3.7791845176855245
R16948 n_19_12_0 n_19_12_1 436.4958117926656
R16949 n_19_12_1 n_20_12_1 3880.104998541656
R16950 n_19_12_1 n_19_13_1 5.290858324759735
R16951 n_19_12_1 n_19_12_2 992.0359358924218
R16952 n_19_12_2 n_20_12_2 6928.758925967244
R16953 n_19_12_2 n_19_13_2 9.447961294213812
R16954 n_19_12_2 n_19_12_3 928.5456359953067
R16955 n_19_12_3 n_20_12_3 97002.62496354131
R16956 n_19_12_3 n_19_13_3 132.27145811899325
R16957 n_19_12_3 n_19_12_4 12.345336091105704
R16958 n_19_12_4 n_20_12_4 2939.4734837436763
R16959 n_19_12_4 n_19_13_4 4.008226003605856
R16960 n_19_12_15 n_20_12_15 194005.2499270809
R16961 n_19_12_15 n_19_13_15 264.5429162379842
R16962 n_19_13_0 n_20_13_0 2771.5035703868975
R16963 n_19_13_0 n_19_14_0 3.7791845176855245
R16964 n_19_13_0 n_19_13_1 436.4958117926656
R16965 n_19_13_1 n_20_13_1 3880.104998541656
R16966 n_19_13_1 n_19_14_1 5.290858324759735
R16967 n_19_13_1 n_19_13_2 992.0359358924218
R16968 n_19_13_2 n_20_13_2 6928.758925967244
R16969 n_19_13_2 n_19_14_2 9.447961294213812
R16970 n_19_13_2 n_19_13_3 928.5456359953067
R16971 n_19_13_3 n_20_13_3 97002.62496354131
R16972 n_19_13_3 n_19_14_3 132.27145811899325
R16973 n_19_13_3 n_19_13_4 12.345336091105704
R16974 n_19_13_4 n_20_13_4 2939.4734837436763
R16975 n_19_13_4 n_19_14_4 4.008226003605856
R16976 n_19_13_15 n_20_13_15 194005.2499270809
R16977 n_19_13_15 n_19_14_15 264.5429162379842
R16978 n_19_14_0 n_20_14_0 2771.5035703868975
R16979 n_19_14_0 n_19_15_0 3.7791845176855245
R16980 n_19_14_0 n_19_14_1 436.4958117926656
R16981 n_19_14_1 n_20_14_1 3880.104998541656
R16982 n_19_14_1 n_19_15_1 5.290858324759735
R16983 n_19_14_1 n_19_14_2 992.0359358924218
R16984 n_19_14_2 n_20_14_2 6928.758925967244
R16985 n_19_14_2 n_19_15_2 9.447961294213812
R16986 n_19_14_2 n_19_14_3 928.5456359953067
R16987 n_19_14_3 n_20_14_3 97002.62496354131
R16988 n_19_14_3 n_19_15_3 132.27145811899325
R16989 n_19_14_3 n_19_14_4 12.345336091105704
R16990 n_19_14_4 n_20_14_4 2939.4734837436763
R16991 n_19_14_4 n_19_15_4 4.008226003605856
R16992 n_19_14_15 n_20_14_15 194005.2499270809
R16993 n_19_14_15 n_19_15_15 264.5429162379842
R16994 n_19_15_0 n_20_15_0 2771.5035703868975
R16995 n_19_15_0 n_19_16_0 110.44365362970498
R16996 n_19_15_0 n_19_15_1 436.4958117926656
R16997 n_19_15_1 n_20_15_1 3880.104998541656
R16998 n_19_15_1 n_19_16_1 154.62111508158694
R16999 n_19_15_1 n_19_15_2 992.0359358924218
R17000 n_19_15_2 n_20_15_2 6928.758925967244
R17001 n_19_15_2 n_19_16_2 276.1091340742624
R17002 n_19_15_2 n_19_15_3 928.5456359953067
R17003 n_19_15_3 n_20_15_3 97002.62496354131
R17004 n_19_15_3 n_19_16_3 3865.527877039671
R17005 n_19_15_3 n_19_15_4 12.345336091105704
R17006 n_19_15_4 n_20_15_4 2939.4734837436763
R17007 n_19_15_4 n_19_16_4 117.13720839514153
R17008 n_19_15_15 n_20_15_15 194005.2499270809
R17009 n_19_15_15 n_19_16_15 7731.055754079272
R17010 n_19_16_0 n_20_16_0 48.243351062347855
R17011 n_19_16_0 n_19_17_0 217.10812274172457
R17012 n_19_16_0 n_19_16_1 7.598049272084617
R17013 n_19_16_1 n_20_16_1 67.54069148728698
R17014 n_19_16_1 n_19_17_1 303.9513718384144
R17015 n_19_16_1 n_19_16_2 17.26829380019231
R17016 n_19_16_2 n_20_16_2 120.60837765586962
R17017 n_19_16_2 n_19_17_2 542.7703068543113
R17018 n_19_16_2 n_19_16_3 16.16312299698
R17019 n_19_16_3 n_20_16_3 1688.5172871821728
R17020 n_19_16_3 n_19_17_3 7598.784295960353
R17021 n_19_16_3 n_19_16_4 0.21489432284683782
R17022 n_19_16_4 n_20_16_4 51.167190520671895
R17023 n_19_16_4 n_19_17_4 230.26619078667736
R17024 n_19_16_4 n_19_16_5 0.21489432284683782
R17025 n_19_16_5 n_19_17_5 7598.784295960353
R17026 n_19_16_5 n_19_16_6 0.4144390512046158
R17027 n_19_16_6 n_19_17_6 1688.6187324356338
R17028 n_19_16_6 n_19_16_7 0.5832845905842734
R17029 n_19_16_7 n_19_17_7 2894.774969889667
R17030 n_19_16_7 n_19_16_8 0.4297886456936743
R17031 n_19_16_8 n_19_17_8 2894.774969889667
R17032 n_19_16_8 n_19_16_9 0.4297886456936743
R17033 n_19_16_9 n_19_17_9 2894.774969889667
R17034 n_19_16_9 n_19_16_10 0.4297886456936743
R17035 n_19_16_10 n_19_17_10 2894.774969889667
R17036 n_19_16_10 n_19_16_11 0.4297886456936716
R17037 n_19_16_11 n_19_17_11 2894.774969889704
R17038 n_19_16_11 n_19_16_12 0.42978864569367015
R17039 n_19_16_12 n_19_17_12 2894.7749698896855
R17040 n_19_16_12 n_19_16_13 0.42978864569367425
R17041 n_19_16_13 n_19_17_13 2894.774969889649
R17042 n_19_16_13 n_19_16_14 2.1489432284683767
R17043 n_19_16_14 n_19_17_14 321.6416633210734
R17044 n_19_16_14 n_19_16_15 11.143805599057526
R17045 n_19_16_15 n_20_16_15 3377.034574364316
R17046 n_19_16_15 n_19_17_15 15197.56859192057
R17047 n_19_17_0 n_20_17_0 48.243351062347784
R17048 n_19_17_0 n_19_18_0 217.10812274172469
R17049 n_19_17_0 n_19_17_1 7.598049272084607
R17050 n_19_17_1 n_20_17_1 67.5406914872869
R17051 n_19_17_1 n_19_18_1 303.95137183841456
R17052 n_19_17_1 n_19_17_2 17.268293800192286
R17053 n_19_17_2 n_20_17_2 120.60837765586945
R17054 n_19_17_2 n_19_18_2 542.7703068543117
R17055 n_19_17_2 n_19_17_3 16.16312299697998
R17056 n_19_17_3 n_20_17_3 1688.517287182171
R17057 n_19_17_3 n_19_18_3 7598.784295960358
R17058 n_19_17_3 n_19_17_4 0.21489432284683754
R17059 n_19_17_4 n_20_17_4 51.167190520671845
R17060 n_19_17_4 n_19_18_4 230.2661907866775
R17061 n_19_17_4 n_19_17_5 0.21489432284683754
R17062 n_19_17_5 n_19_18_5 7598.784295960358
R17063 n_19_17_5 n_19_17_6 0.41443905120461527
R17064 n_19_17_6 n_19_18_6 1688.6187324356347
R17065 n_19_17_6 n_19_17_7 0.5832845905842726
R17066 n_19_17_7 n_19_18_7 2894.7749698896687
R17067 n_19_17_7 n_19_17_8 0.4297886456936737
R17068 n_19_17_8 n_19_18_8 2894.7749698896687
R17069 n_19_17_8 n_19_17_9 0.4297886456936737
R17070 n_19_17_9 n_19_18_9 2894.7749698896687
R17071 n_19_17_9 n_19_17_10 0.4297886456936737
R17072 n_19_17_10 n_19_18_10 2894.7749698896687
R17073 n_19_17_10 n_19_17_11 0.429788645693671
R17074 n_19_17_11 n_19_18_11 2894.774969889706
R17075 n_19_17_11 n_19_17_12 0.4297886456936696
R17076 n_19_17_12 n_19_18_12 2894.7749698896873
R17077 n_19_17_12 n_19_17_13 0.4297886456936737
R17078 n_19_17_13 n_19_18_13 2894.774969889651
R17079 n_19_17_13 n_19_17_14 2.148943228468374
R17080 n_19_17_14 n_19_18_14 321.64166332107357
R17081 n_19_17_14 n_19_17_15 11.143805599057513
R17082 n_19_17_15 n_20_17_15 3377.034574364312
R17083 n_19_17_15 n_19_18_15 15197.568591920579
R17084 n_19_18_0 n_20_18_0 48.243351062347784
R17085 n_19_18_0 n_19_19_0 217.10812274172457
R17086 n_19_18_0 n_19_18_1 7.598049272084607
R17087 n_19_18_1 n_20_18_1 67.5406914872869
R17088 n_19_18_1 n_19_19_1 303.9513718384144
R17089 n_19_18_1 n_19_18_2 17.268293800192286
R17090 n_19_18_2 n_20_18_2 120.60837765586945
R17091 n_19_18_2 n_19_19_2 542.7703068543113
R17092 n_19_18_2 n_19_18_3 16.16312299697998
R17093 n_19_18_3 n_20_18_3 1688.517287182171
R17094 n_19_18_3 n_19_19_3 7598.784295960353
R17095 n_19_18_3 n_19_18_4 0.21489432284683754
R17096 n_19_18_4 n_20_18_4 51.167190520671845
R17097 n_19_18_4 n_19_19_4 230.26619078667736
R17098 n_19_18_4 n_19_18_5 0.21489432284683754
R17099 n_19_18_5 n_19_19_5 7598.784295960353
R17100 n_19_18_5 n_19_18_6 0.41443905120461527
R17101 n_19_18_6 n_19_19_6 1688.6187324356338
R17102 n_19_18_6 n_19_18_7 0.5832845905842726
R17103 n_19_18_7 n_19_19_7 2894.774969889667
R17104 n_19_18_7 n_19_18_8 0.4297886456936737
R17105 n_19_18_8 n_19_19_8 2894.774969889667
R17106 n_19_18_8 n_19_18_9 0.4297886456936737
R17107 n_19_18_9 n_19_19_9 2894.774969889667
R17108 n_19_18_9 n_19_18_10 0.4297886456936737
R17109 n_19_18_10 n_19_19_10 2894.774969889667
R17110 n_19_18_10 n_19_18_11 0.429788645693671
R17111 n_19_18_11 n_19_19_11 2894.774969889704
R17112 n_19_18_11 n_19_18_12 0.4297886456936696
R17113 n_19_18_12 n_19_19_12 2894.7749698896855
R17114 n_19_18_12 n_19_18_13 0.4297886456936737
R17115 n_19_18_13 n_19_19_13 2894.774969889649
R17116 n_19_18_13 n_19_18_14 2.148943228468374
R17117 n_19_18_14 n_19_19_14 321.6416633210734
R17118 n_19_18_14 n_19_18_15 11.143805599057513
R17119 n_19_18_15 n_20_18_15 3377.034574364312
R17120 n_19_18_15 n_19_19_15 15197.56859192057
R17121 n_19_19_0 n_20_19_0 48.243351062347855
R17122 n_19_19_0 n_19_20_0 110.44365397508213
R17123 n_19_19_0 n_19_19_1 7.598049272084617
R17124 n_19_19_1 n_20_19_1 67.54069148728698
R17125 n_19_19_1 n_19_20_1 154.62111556511496
R17126 n_19_19_1 n_19_19_2 17.26829380019231
R17127 n_19_19_2 n_20_19_2 120.60837765586962
R17128 n_19_19_2 n_19_20_2 276.1091349377053
R17129 n_19_19_2 n_19_19_3 16.16312299698
R17130 n_19_19_3 n_20_19_3 1688.5172871821728
R17131 n_19_19_3 n_19_20_3 3865.5278891278713
R17132 n_19_19_3 n_19_19_4 0.21489432284683782
R17133 n_19_19_4 n_20_19_4 51.167190520671895
R17134 n_19_19_4 n_19_20_4 117.13720876145064
R17135 n_19_19_4 n_19_19_5 0.21489432284683782
R17136 n_19_19_5 n_19_19_6 0.4144390512046158
R17137 n_19_19_6 n_19_19_7 0.5832845905842734
R17138 n_19_19_7 n_19_19_8 0.4297886456936743
R17139 n_19_19_8 n_19_19_9 0.4297886456936743
R17140 n_19_19_9 n_19_19_10 0.4297886456936743
R17141 n_19_19_10 n_19_19_11 0.4297886456936716
R17142 n_19_19_11 n_19_19_12 0.42978864569367015
R17143 n_19_19_12 n_19_19_13 0.42978864569367425
R17144 n_19_19_13 n_19_19_14 2.1489432284683767
R17145 n_19_19_14 n_19_19_15 11.143805599057526
R17146 n_19_19_15 n_20_19_15 3377.034574364316
R17147 n_19_19_15 n_19_20_15 7731.0557782556725
R17148 n_19_20_0 n_20_20_0 2771.5030638152725
R17149 n_19_20_0 n_19_21_0 3.7791852084398188
R17150 n_19_20_0 n_19_20_1 436.4957320105592
R17151 n_19_20_1 n_20_20_1 3880.10428934138
R17152 n_19_20_1 n_19_21_1 5.290859291815746
R17153 n_19_20_1 n_19_20_2 992.0357545694527
R17154 n_19_20_2 n_20_20_2 6928.757659538181
R17155 n_19_20_2 n_19_21_2 9.447963021099547
R17156 n_19_20_2 n_19_20_3 928.5454662770078
R17157 n_19_20_3 n_20_20_3 97002.60723353442
R17158 n_19_20_3 n_19_21_3 132.27148229539355
R17159 n_19_20_3 n_19_20_4 12.34533383464209
R17160 n_19_20_4 n_20_20_4 2939.47294647074
R17161 n_19_20_4 n_19_21_4 4.008226736224047
R17162 n_19_20_15 n_20_20_15 194005.21446706713
R17163 n_19_20_15 n_19_21_15 264.5429645907847
R17164 n_19_21_0 n_20_21_0 2771.5030638152725
R17165 n_19_21_0 n_19_22_0 3.7791852084396846
R17166 n_19_21_0 n_19_21_1 436.4957320105592
R17167 n_19_21_1 n_20_21_1 3880.10428934138
R17168 n_19_21_1 n_19_22_1 5.290859291815558
R17169 n_19_21_1 n_19_21_2 992.0357545694527
R17170 n_19_21_2 n_20_21_2 6928.757659538181
R17171 n_19_21_2 n_19_22_2 9.447963021099211
R17172 n_19_21_2 n_19_21_3 928.5454662770078
R17173 n_19_21_3 n_20_21_3 97002.60723353442
R17174 n_19_21_3 n_19_22_3 132.27148229538886
R17175 n_19_21_3 n_19_21_4 12.34533383464209
R17176 n_19_21_4 n_20_21_4 2939.47294647074
R17177 n_19_21_4 n_19_22_4 4.008226736223905
R17178 n_19_21_15 n_20_21_15 194005.21446706713
R17179 n_19_21_15 n_19_22_15 264.54296459077534
R17180 n_19_22_0 n_20_22_0 2771.503063815469
R17181 n_19_22_0 n_19_23_0 3.7791852084396846
R17182 n_19_22_0 n_19_22_1 436.49573201059025
R17183 n_19_22_1 n_20_22_1 3880.1042893416566
R17184 n_19_22_1 n_19_23_1 5.290859291815558
R17185 n_19_22_1 n_19_22_2 992.0357545695232
R17186 n_19_22_2 n_20_22_2 6928.757659538673
R17187 n_19_22_2 n_19_23_2 9.447963021099211
R17188 n_19_22_2 n_19_22_3 928.5454662770737
R17189 n_19_22_3 n_20_22_3 97002.60723354133
R17190 n_19_22_3 n_19_23_3 132.27148229538886
R17191 n_19_22_3 n_19_22_4 12.345333834642968
R17192 n_19_22_4 n_20_22_4 2939.472946470949
R17193 n_19_22_4 n_19_23_4 4.008226736223905
R17194 n_19_22_15 n_20_22_15 194005.21446708092
R17195 n_19_22_15 n_19_23_15 264.54296459077534
R17196 n_19_23_0 n_20_23_0 2771.5030638152725
R17197 n_19_23_0 n_19_24_0 43.561715139231076
R17198 n_19_23_0 n_19_23_1 436.4957320105592
R17199 n_19_23_1 n_20_23_1 3880.10428934138
R17200 n_19_23_1 n_19_24_1 60.98640119492351
R17201 n_19_23_1 n_19_23_2 992.0357545694527
R17202 n_19_23_2 n_20_23_2 6928.757659538181
R17203 n_19_23_2 n_19_24_2 108.90428784807769
R17204 n_19_23_2 n_19_23_3 928.5454662770078
R17205 n_19_23_3 n_20_23_3 97002.60723353442
R17206 n_19_23_3 n_19_24_3 1524.6600298730866
R17207 n_19_23_3 n_19_23_4 12.34533383464209
R17208 n_19_23_4 n_20_23_4 2939.47294647074
R17209 n_19_23_4 n_19_24_4 46.20181908706322
R17210 n_19_23_15 n_20_23_15 194005.21446706713
R17211 n_19_23_15 n_19_24_15 3049.3200597461455
R17212 n_19_24_0 n_20_24_0 125.67182503262799
R17213 n_19_24_0 n_19_25_0 83.3442450700222
R17214 n_19_24_0 n_19_24_1 19.79258690957598
R17215 n_19_24_1 n_20_24_1 175.94055504567916
R17216 n_19_24_1 n_19_25_1 116.68194309803108
R17217 n_19_24_1 n_19_24_2 44.983152067218136
R17218 n_19_24_2 n_20_24_2 314.17956258157
R17219 n_19_24_2 n_19_25_2 208.3606126750555
R17220 n_19_24_2 n_19_24_3 42.10423033491618
R17221 n_19_24_3 n_20_24_3 4398.513876141976
R17222 n_19_24_3 n_19_25_3 2917.048577450775
R17223 n_19_24_3 n_19_24_4 0.5597903368364929
R17224 n_19_24_4 n_20_24_4 133.28829927702958
R17225 n_19_24_4 n_19_25_4 88.39541143790225
R17226 n_19_24_4 n_19_24_5 0.46268384983424415
R17227 n_19_24_5 n_20_24_5 837.8121668841859
R17228 n_19_24_5 n_19_25_5 555.6283004668143
R17229 n_19_24_5 n_19_24_6 0.15994009623899796
R17230 n_19_24_6 n_20_24_6 139.6353611473643
R17231 n_19_24_6 n_19_25_6 92.60471674446904
R17232 n_19_24_6 n_19_24_7 0.217061559181497
R17233 n_19_24_7 n_20_24_7 239.37490482405383
R17234 n_19_24_7 n_19_25_7 158.75094299051884
R17235 n_19_24_7 n_19_24_8 0.15994009623899746
R17236 n_19_24_8 n_20_24_8 239.37490482405383
R17237 n_19_24_8 n_19_25_8 158.75094299051884
R17238 n_19_24_8 n_19_24_9 0.15994009623899746
R17239 n_19_24_9 n_20_24_9 239.37490482405383
R17240 n_19_24_9 n_19_25_9 158.75094299051884
R17241 n_19_24_9 n_19_24_10 0.15994009623899746
R17242 n_19_24_10 n_20_24_10 239.37490482405383
R17243 n_19_24_10 n_19_25_10 158.75094299051884
R17244 n_19_24_10 n_19_24_11 0.15994009623899644
R17245 n_19_24_11 n_20_24_11 239.3749048240569
R17246 n_19_24_11 n_19_25_11 158.75094299052085
R17247 n_19_24_11 n_19_24_12 0.1599400962389959
R17248 n_19_24_12 n_20_24_12 239.37490482405536
R17249 n_19_24_12 n_19_25_12 158.75094299051983
R17250 n_19_24_12 n_19_24_13 0.15994009623899746
R17251 n_19_24_13 n_20_24_13 239.37490482405235
R17252 n_19_24_13 n_19_25_13 158.75094299051784
R17253 n_19_24_13 n_19_24_14 0.7997004811949894
R17254 n_19_24_14 n_20_24_14 26.597211647117035
R17255 n_19_24_14 n_19_25_14 17.638993665613164
R17256 n_19_24_14 n_19_24_15 24.7107448689254
R17257 n_19_24_15 n_20_24_15 8797.027752283871
R17258 n_19_24_15 n_19_25_15 5834.097154901498
R17259 n_19_25_0 n_20_25_0 125.6718250326284
R17260 n_19_25_0 n_19_26_0 83.3442450700222
R17261 n_19_25_0 n_19_25_1 19.792586909576038
R17262 n_19_25_1 n_20_25_1 175.94055504567976
R17263 n_19_25_1 n_19_26_1 116.68194309803108
R17264 n_19_25_1 n_19_25_2 44.983152067218285
R17265 n_19_25_2 n_20_25_2 314.179562581571
R17266 n_19_25_2 n_19_26_2 208.3606126750555
R17267 n_19_25_2 n_19_25_3 42.104230334916316
R17268 n_19_25_3 n_20_25_3 4398.51387614199
R17269 n_19_25_3 n_19_26_3 2917.048577450775
R17270 n_19_25_3 n_19_25_4 0.5597903368364947
R17271 n_19_25_4 n_20_25_4 133.28829927703
R17272 n_19_25_4 n_19_26_4 88.39541143790225
R17273 n_19_25_4 n_19_25_5 0.46268384983424565
R17274 n_19_25_5 n_20_25_5 837.8121668841885
R17275 n_19_25_5 n_19_26_5 555.6283004668143
R17276 n_19_25_5 n_19_25_6 0.1599400962389985
R17277 n_19_25_6 n_20_25_6 139.63536114736476
R17278 n_19_25_6 n_19_26_6 92.60471674446904
R17279 n_19_25_6 n_19_25_7 0.21706155918149772
R17280 n_19_25_7 n_20_25_7 239.37490482405465
R17281 n_19_25_7 n_19_26_7 158.75094299051884
R17282 n_19_25_7 n_19_25_8 0.159940096238998
R17283 n_19_25_8 n_20_25_8 239.37490482405465
R17284 n_19_25_8 n_19_26_8 158.75094299051884
R17285 n_19_25_8 n_19_25_9 0.159940096238998
R17286 n_19_25_9 n_20_25_9 239.37490482405465
R17287 n_19_25_9 n_19_26_9 158.75094299051884
R17288 n_19_25_9 n_19_25_10 0.159940096238998
R17289 n_19_25_10 n_20_25_10 239.37490482405465
R17290 n_19_25_10 n_19_26_10 158.75094299051884
R17291 n_19_25_10 n_19_25_11 0.15994009623899696
R17292 n_19_25_11 n_20_25_11 239.3749048240577
R17293 n_19_25_11 n_19_26_11 158.75094299052085
R17294 n_19_25_11 n_19_25_12 0.15994009623899647
R17295 n_19_25_12 n_20_25_12 239.37490482405607
R17296 n_19_25_12 n_19_26_12 158.75094299051983
R17297 n_19_25_12 n_19_25_13 0.15994009623899796
R17298 n_19_25_13 n_20_25_13 239.37490482405312
R17299 n_19_25_13 n_19_26_13 158.75094299051784
R17300 n_19_25_13 n_19_25_14 0.7997004811949919
R17301 n_19_25_14 n_20_25_14 26.59721164711712
R17302 n_19_25_14 n_19_26_14 17.638993665613164
R17303 n_19_25_14 n_19_25_15 24.71074486892548
R17304 n_19_25_15 n_20_25_15 8797.027752283902
R17305 n_19_25_15 n_19_26_15 5834.097154901498
R17306 n_19_26_0 n_20_26_0 125.67182503262799
R17307 n_19_26_0 n_19_27_0 83.34424507002234
R17308 n_19_26_0 n_19_26_1 19.79258690957598
R17309 n_19_26_1 n_20_26_1 175.94055504567916
R17310 n_19_26_1 n_19_27_1 116.68194309803127
R17311 n_19_26_1 n_19_26_2 44.983152067218136
R17312 n_19_26_2 n_20_26_2 314.17956258157
R17313 n_19_26_2 n_19_27_2 208.36061267505582
R17314 n_19_26_2 n_19_26_3 42.10423033491618
R17315 n_19_26_3 n_20_26_3 4398.513876141976
R17316 n_19_26_3 n_19_27_3 2917.0485774507797
R17317 n_19_26_3 n_19_26_4 0.5597903368364929
R17318 n_19_26_4 n_20_26_4 133.28829927702958
R17319 n_19_26_4 n_19_27_4 88.3954114379024
R17320 n_19_26_4 n_19_26_5 0.46268384983424415
R17321 n_19_26_5 n_20_26_5 837.8121668841859
R17322 n_19_26_5 n_19_27_5 555.6283004668152
R17323 n_19_26_5 n_19_26_6 0.15994009623899796
R17324 n_19_26_6 n_20_26_6 139.6353611473643
R17325 n_19_26_6 n_19_27_6 92.60471674446919
R17326 n_19_26_6 n_19_26_7 0.217061559181497
R17327 n_19_26_7 n_20_26_7 239.37490482405383
R17328 n_19_26_7 n_19_27_7 158.7509429905191
R17329 n_19_26_7 n_19_26_8 0.15994009623899746
R17330 n_19_26_8 n_20_26_8 239.37490482405383
R17331 n_19_26_8 n_19_27_8 158.7509429905191
R17332 n_19_26_8 n_19_26_9 0.15994009623899746
R17333 n_19_26_9 n_20_26_9 239.37490482405383
R17334 n_19_26_9 n_19_27_9 158.7509429905191
R17335 n_19_26_9 n_19_26_10 0.15994009623899746
R17336 n_19_26_10 n_20_26_10 239.37490482405383
R17337 n_19_26_10 n_19_27_10 158.7509429905191
R17338 n_19_26_10 n_19_26_11 0.15994009623899644
R17339 n_19_26_11 n_20_26_11 239.3749048240569
R17340 n_19_26_11 n_19_27_11 158.7509429905211
R17341 n_19_26_11 n_19_26_12 0.1599400962389959
R17342 n_19_26_12 n_20_26_12 239.37490482405536
R17343 n_19_26_12 n_19_27_12 158.7509429905201
R17344 n_19_26_12 n_19_26_13 0.15994009623899746
R17345 n_19_26_13 n_20_26_13 239.37490482405235
R17346 n_19_26_13 n_19_27_13 158.7509429905181
R17347 n_19_26_13 n_19_26_14 0.7997004811949894
R17348 n_19_26_14 n_20_26_14 26.597211647117035
R17349 n_19_26_14 n_19_27_14 17.638993665613192
R17350 n_19_26_14 n_19_26_15 24.7107448689254
R17351 n_19_26_15 n_20_26_15 8797.027752283871
R17352 n_19_26_15 n_19_27_15 5834.097154901507
R17353 n_19_27_0 n_20_27_0 125.67182503262799
R17354 n_19_27_0 n_19_27_1 19.79258690957598
R17355 n_19_27_1 n_20_27_1 175.94055504567916
R17356 n_19_27_1 n_19_27_2 44.983152067218136
R17357 n_19_27_2 n_20_27_2 314.17956258157
R17358 n_19_27_2 n_19_27_3 42.10423033491618
R17359 n_19_27_3 n_20_27_3 4398.513876141976
R17360 n_19_27_3 n_19_27_4 0.5597903368364929
R17361 n_19_27_4 n_20_27_4 133.28829927702958
R17362 n_19_27_4 n_19_27_5 0.46268384983424415
R17363 n_19_27_5 n_20_27_5 837.8121668841859
R17364 n_19_27_5 n_19_27_6 0.15994009623899796
R17365 n_19_27_6 n_20_27_6 139.6353611473643
R17366 n_19_27_6 n_19_27_7 0.217061559181497
R17367 n_19_27_7 n_20_27_7 239.37490482405383
R17368 n_19_27_7 n_19_27_8 0.15994009623899746
R17369 n_19_27_8 n_20_27_8 239.37490482405383
R17370 n_19_27_8 n_19_27_9 0.15994009623899746
R17371 n_19_27_9 n_20_27_9 239.37490482405383
R17372 n_19_27_9 n_19_27_10 0.15994009623899746
R17373 n_19_27_10 n_20_27_10 239.37490482405383
R17374 n_19_27_10 n_19_27_11 0.15994009623899644
R17375 n_19_27_11 n_20_27_11 239.3749048240569
R17376 n_19_27_11 n_19_27_12 0.1599400962389959
R17377 n_19_27_12 n_20_27_12 239.37490482405536
R17378 n_19_27_12 n_19_27_13 0.15994009623899746
R17379 n_19_27_13 n_20_27_13 239.37490482405235
R17380 n_19_27_13 n_19_27_14 0.7997004811949894
R17381 n_19_27_14 n_20_27_14 26.597211647117035
R17382 n_19_27_14 n_19_27_15 24.7107448689254
R17383 n_19_27_15 n_20_27_15 8797.027752283871
R17384 n_20_0_0 n_21_0_0 6.4777532699256675
R17385 n_20_0_0 n_20_1_0 3150.5002452092954
R17386 n_20_0_0 n_20_0_1 748.1805026763932
R17387 n_20_0_1 n_21_0_1 9.068854577895932
R17388 n_20_0_1 n_20_1_1 4410.700343293014
R17389 n_20_0_1 n_20_0_2 1700.4102333554388
R17390 n_20_0_2 n_21_0_2 16.194383174814167
R17391 n_20_0_2 n_20_1_2 7876.25061302324
R17392 n_20_0_2 n_20_0_3 1591.5839784206908
R17393 n_20_0_3 n_21_0_3 226.7213644473981
R17394 n_20_0_3 n_20_1_3 110267.50858232524
R17395 n_20_0_3 n_20_0_4 21.160660681756593
R17396 n_20_0_4 n_21_0_4 6.870344377193882
R17397 n_20_0_4 n_20_1_4 3341.4396540098564
R17398 n_20_0_4 n_20_0_5 17.489933828798815
R17399 n_20_0_5 n_21_0_5 43.1850217995044
R17400 n_20_0_5 n_20_1_5 21003.33496806195
R17401 n_20_0_5 n_20_0_6 6.045903051930455
R17402 n_20_0_6 n_21_0_6 7.197503633250734
R17403 n_20_0_6 n_20_1_6 3500.5558280103255
R17404 n_20_0_6 n_20_0_7 8.205154141905608
R17405 n_20_0_7 n_21_0_7 12.338577657001295
R17406 n_20_0_7 n_20_1_7 6000.95284801772
R17407 n_20_0_7 n_20_0_8 6.045903051930436
R17408 n_20_0_8 n_21_0_8 12.338577657001295
R17409 n_20_0_8 n_20_1_8 6000.95284801772
R17410 n_20_0_8 n_20_0_9 6.045903051930436
R17411 n_20_0_9 n_21_0_9 12.338577657001295
R17412 n_20_0_9 n_20_1_9 6000.95284801772
R17413 n_20_0_9 n_20_0_10 6.045903051930436
R17414 n_20_0_10 n_21_0_10 12.338577657001295
R17415 n_20_0_10 n_20_1_10 6000.95284801772
R17416 n_20_0_10 n_20_0_11 6.045903051930397
R17417 n_20_0_11 n_21_0_11 12.338577657001453
R17418 n_20_0_11 n_20_1_11 6000.952848017796
R17419 n_20_0_11 n_20_0_12 6.045903051930377
R17420 n_20_0_12 n_21_0_12 12.338577657001379
R17421 n_20_0_12 n_20_1_12 6000.952848017758
R17422 n_20_0_12 n_20_0_13 6.045903051930436
R17423 n_20_0_13 n_21_0_13 12.338577657001219
R17424 n_20_0_13 n_20_1_13 6000.952848017681
R17425 n_20_0_13 n_20_0_14 30.229515259652253
R17426 n_20_0_14 n_21_0_14 1.3709530730001411
R17427 n_20_0_14 n_20_1_14 666.7725386686341
R17428 n_20_0_14 n_20_0_15 934.0920215232634
R17429 n_20_0_15 n_21_0_15 453.4427288947922
R17430 n_20_0_15 n_20_1_15 220535.01716464857
R17431 n_20_1_0 n_21_1_0 6.4777532699256675
R17432 n_20_1_0 n_20_2_0 3150.5002452092954
R17433 n_20_1_0 n_20_1_1 748.1805026763932
R17434 n_20_1_1 n_21_1_1 9.068854577895932
R17435 n_20_1_1 n_20_2_1 4410.700343293014
R17436 n_20_1_1 n_20_1_2 1700.4102333554388
R17437 n_20_1_2 n_21_1_2 16.194383174814167
R17438 n_20_1_2 n_20_2_2 7876.25061302324
R17439 n_20_1_2 n_20_1_3 1591.5839784206908
R17440 n_20_1_3 n_21_1_3 226.7213644473981
R17441 n_20_1_3 n_20_2_3 110267.50858232524
R17442 n_20_1_3 n_20_1_4 21.160660681756593
R17443 n_20_1_4 n_21_1_4 6.870344377193882
R17444 n_20_1_4 n_20_2_4 3341.4396540098564
R17445 n_20_1_4 n_20_1_5 17.489933828798815
R17446 n_20_1_5 n_21_1_5 43.1850217995044
R17447 n_20_1_5 n_20_2_5 21003.33496806195
R17448 n_20_1_5 n_20_1_6 6.045903051930455
R17449 n_20_1_6 n_21_1_6 7.197503633250734
R17450 n_20_1_6 n_20_2_6 3500.5558280103255
R17451 n_20_1_6 n_20_1_7 8.205154141905608
R17452 n_20_1_7 n_21_1_7 12.338577657001295
R17453 n_20_1_7 n_20_2_7 6000.95284801772
R17454 n_20_1_7 n_20_1_8 6.045903051930436
R17455 n_20_1_8 n_21_1_8 12.338577657001295
R17456 n_20_1_8 n_20_2_8 6000.95284801772
R17457 n_20_1_8 n_20_1_9 6.045903051930436
R17458 n_20_1_9 n_21_1_9 12.338577657001295
R17459 n_20_1_9 n_20_2_9 6000.95284801772
R17460 n_20_1_9 n_20_1_10 6.045903051930436
R17461 n_20_1_10 n_21_1_10 12.338577657001295
R17462 n_20_1_10 n_20_2_10 6000.95284801772
R17463 n_20_1_10 n_20_1_11 6.045903051930397
R17464 n_20_1_11 n_21_1_11 12.338577657001453
R17465 n_20_1_11 n_20_2_11 6000.952848017796
R17466 n_20_1_11 n_20_1_12 6.045903051930377
R17467 n_20_1_12 n_21_1_12 12.338577657001379
R17468 n_20_1_12 n_20_2_12 6000.952848017758
R17469 n_20_1_12 n_20_1_13 6.045903051930436
R17470 n_20_1_13 n_21_1_13 12.338577657001219
R17471 n_20_1_13 n_20_2_13 6000.952848017681
R17472 n_20_1_13 n_20_1_14 30.229515259652253
R17473 n_20_1_14 n_21_1_14 1.3709530730001411
R17474 n_20_1_14 n_20_2_14 666.7725386686341
R17475 n_20_1_14 n_20_1_15 934.0920215232634
R17476 n_20_1_15 n_21_1_15 453.4427288947922
R17477 n_20_1_15 n_20_2_15 220535.01716464857
R17478 n_20_2_0 n_21_2_0 6.4777532699256675
R17479 n_20_2_0 n_20_3_0 3150.5002452092954
R17480 n_20_2_0 n_20_2_1 748.1805026763932
R17481 n_20_2_1 n_21_2_1 9.068854577895932
R17482 n_20_2_1 n_20_3_1 4410.700343293014
R17483 n_20_2_1 n_20_2_2 1700.4102333554388
R17484 n_20_2_2 n_21_2_2 16.194383174814167
R17485 n_20_2_2 n_20_3_2 7876.25061302324
R17486 n_20_2_2 n_20_2_3 1591.5839784206908
R17487 n_20_2_3 n_21_2_3 226.7213644473981
R17488 n_20_2_3 n_20_3_3 110267.50858232524
R17489 n_20_2_3 n_20_2_4 21.160660681756593
R17490 n_20_2_4 n_21_2_4 6.870344377193882
R17491 n_20_2_4 n_20_3_4 3341.4396540098564
R17492 n_20_2_4 n_20_2_5 17.489933828798815
R17493 n_20_2_5 n_21_2_5 43.1850217995044
R17494 n_20_2_5 n_20_3_5 21003.33496806195
R17495 n_20_2_5 n_20_2_6 6.045903051930455
R17496 n_20_2_6 n_21_2_6 7.197503633250734
R17497 n_20_2_6 n_20_3_6 3500.5558280103255
R17498 n_20_2_6 n_20_2_7 8.205154141905608
R17499 n_20_2_7 n_21_2_7 12.338577657001295
R17500 n_20_2_7 n_20_3_7 6000.95284801772
R17501 n_20_2_7 n_20_2_8 6.045903051930436
R17502 n_20_2_8 n_21_2_8 12.338577657001295
R17503 n_20_2_8 n_20_3_8 6000.95284801772
R17504 n_20_2_8 n_20_2_9 6.045903051930436
R17505 n_20_2_9 n_21_2_9 12.338577657001295
R17506 n_20_2_9 n_20_3_9 6000.95284801772
R17507 n_20_2_9 n_20_2_10 6.045903051930436
R17508 n_20_2_10 n_21_2_10 12.338577657001295
R17509 n_20_2_10 n_20_3_10 6000.95284801772
R17510 n_20_2_10 n_20_2_11 6.045903051930397
R17511 n_20_2_11 n_21_2_11 12.338577657001453
R17512 n_20_2_11 n_20_3_11 6000.952848017796
R17513 n_20_2_11 n_20_2_12 6.045903051930377
R17514 n_20_2_12 n_21_2_12 12.338577657001379
R17515 n_20_2_12 n_20_3_12 6000.952848017758
R17516 n_20_2_12 n_20_2_13 6.045903051930436
R17517 n_20_2_13 n_21_2_13 12.338577657001219
R17518 n_20_2_13 n_20_3_13 6000.952848017681
R17519 n_20_2_13 n_20_2_14 30.229515259652253
R17520 n_20_2_14 n_21_2_14 1.3709530730001411
R17521 n_20_2_14 n_20_3_14 666.7725386686341
R17522 n_20_2_14 n_20_2_15 934.0920215232634
R17523 n_20_2_15 n_21_2_15 453.4427288947922
R17524 n_20_2_15 n_20_3_15 220535.01716464857
R17525 n_20_3_0 n_21_3_0 6.4777532699256675
R17526 n_20_3_0 n_20_4_0 1646.6785714285472
R17527 n_20_3_0 n_20_3_1 748.1805026763932
R17528 n_20_3_1 n_21_3_1 9.068854577895932
R17529 n_20_3_1 n_20_4_1 2305.3499999999667
R17530 n_20_3_1 n_20_3_2 1700.4102333554388
R17531 n_20_3_2 n_21_3_2 16.194383174814167
R17532 n_20_3_2 n_20_4_2 4116.696428571369
R17533 n_20_3_2 n_20_3_3 1591.5839784206908
R17534 n_20_3_3 n_21_3_3 226.7213644473981
R17535 n_20_3_3 n_20_4_3 57633.749999999105
R17536 n_20_3_3 n_20_3_4 21.160660681756593
R17537 n_20_3_4 n_21_3_4 6.870344377193882
R17538 n_20_3_4 n_20_4_4 1746.477272727246
R17539 n_20_3_4 n_20_3_5 17.489933828798815
R17540 n_20_3_5 n_21_3_5 43.1850217995044
R17541 n_20_3_5 n_20_3_6 6.045903051930455
R17542 n_20_3_6 n_21_3_6 7.197503633250734
R17543 n_20_3_6 n_20_3_7 8.205154141905608
R17544 n_20_3_7 n_21_3_7 12.338577657001295
R17545 n_20_3_7 n_20_3_8 6.045903051930436
R17546 n_20_3_8 n_21_3_8 12.338577657001295
R17547 n_20_3_8 n_20_3_9 6.045903051930436
R17548 n_20_3_9 n_21_3_9 12.338577657001295
R17549 n_20_3_9 n_20_3_10 6.045903051930436
R17550 n_20_3_10 n_21_3_10 12.338577657001295
R17551 n_20_3_10 n_20_3_11 6.045903051930397
R17552 n_20_3_11 n_21_3_11 12.338577657001453
R17553 n_20_3_11 n_20_3_12 6.045903051930377
R17554 n_20_3_12 n_21_3_12 12.338577657001379
R17555 n_20_3_12 n_20_3_13 6.045903051930436
R17556 n_20_3_13 n_21_3_13 12.338577657001219
R17557 n_20_3_13 n_20_3_14 30.229515259652253
R17558 n_20_3_14 n_21_3_14 1.3709530730001411
R17559 n_20_3_14 n_20_3_15 934.0920215232634
R17560 n_20_3_15 n_21_3_15 453.4427288947922
R17561 n_20_3_15 n_20_4_15 115267.4999999972
R17562 n_20_4_0 n_21_4_0 142.8573880669074
R17563 n_20_4_0 n_20_5_0 142.8568976478005
R17564 n_20_4_0 n_20_4_1 16500.028321727335
R17565 n_20_4_1 n_21_4_1 200.00034329367034
R17566 n_20_4_1 n_20_5_1 199.99965670692075
R17567 n_20_4_1 n_20_4_2 37500.064367562125
R17568 n_20_4_2 n_21_4_2 357.1434701672685
R17569 n_20_4_2 n_20_5_2 357.14224411950136
R17570 n_20_4_2 n_20_4_3 35100.06024803815
R17571 n_20_4_3 n_21_4_3 5000.008582341755
R17572 n_20_4_3 n_20_5_3 4999.9914176730135
R17573 n_20_4_3 n_20_4_4 466.66746768521796
R17574 n_20_4_4 n_21_4_4 151.51541158611377
R17575 n_20_4_4 n_20_5_4 151.5148914446368
R17576 n_20_4_15 n_21_4_15 10000.01716468342
R17577 n_20_4_15 n_20_5_15 9999.982835345938
R17578 n_20_5_0 n_21_5_0 142.8573880669049
R17579 n_20_5_0 n_20_6_0 142.8568976478018
R17580 n_20_5_0 n_20_5_1 16500.02832172704
R17581 n_20_5_1 n_21_5_1 200.0003432936668
R17582 n_20_5_1 n_20_6_1 199.9996567069225
R17583 n_20_5_1 n_20_5_2 37500.06436756146
R17584 n_20_5_2 n_21_5_2 357.14347016726214
R17585 n_20_5_2 n_20_6_2 357.1422441195045
R17586 n_20_5_2 n_20_5_3 35100.06024803753
R17587 n_20_5_3 n_21_5_3 5000.008582341666
R17588 n_20_5_3 n_20_6_3 4999.991417673058
R17589 n_20_5_3 n_20_5_4 466.66746768520966
R17590 n_20_5_4 n_21_5_4 151.51541158611107
R17591 n_20_5_4 n_20_6_4 151.51489144463812
R17592 n_20_5_15 n_21_5_15 10000.017164683242
R17593 n_20_5_15 n_20_6_15 9999.982835346027
R17594 n_20_6_0 n_21_6_0 142.8573880669049
R17595 n_20_6_0 n_20_7_0 142.8568976478005
R17596 n_20_6_0 n_20_6_1 16500.02832172704
R17597 n_20_6_1 n_21_6_1 200.0003432936668
R17598 n_20_6_1 n_20_7_1 199.99965670692075
R17599 n_20_6_1 n_20_6_2 37500.06436756146
R17600 n_20_6_2 n_21_6_2 357.14347016726214
R17601 n_20_6_2 n_20_7_2 357.14224411950136
R17602 n_20_6_2 n_20_6_3 35100.06024803753
R17603 n_20_6_3 n_21_6_3 5000.008582341666
R17604 n_20_6_3 n_20_7_3 4999.9914176730135
R17605 n_20_6_3 n_20_6_4 466.66746768520966
R17606 n_20_6_4 n_21_6_4 151.51541158611107
R17607 n_20_6_4 n_20_7_4 151.5148914446368
R17608 n_20_6_15 n_21_6_15 10000.017164683242
R17609 n_20_6_15 n_20_7_15 9999.982835345938
R17610 n_20_7_0 n_21_7_0 142.8573880669074
R17611 n_20_7_0 n_20_8_0 4174.885948823841
R17612 n_20_7_0 n_20_7_1 16500.028321727335
R17613 n_20_7_1 n_21_7_1 200.00034329367034
R17614 n_20_7_1 n_20_8_1 5844.840328353377
R17615 n_20_7_1 n_20_7_2 37500.064367562125
R17616 n_20_7_2 n_21_7_2 357.1434701672685
R17617 n_20_7_2 n_20_8_2 10437.214872059603
R17618 n_20_7_2 n_20_7_3 35100.06024803815
R17619 n_20_7_3 n_21_7_3 5000.008582341755
R17620 n_20_7_3 n_20_8_3 146121.00820883428
R17621 n_20_7_3 n_20_7_4 466.66746768521796
R17622 n_20_7_4 n_21_7_4 151.51541158611377
R17623 n_20_7_4 n_20_8_4 4427.909339661646
R17624 n_20_7_15 n_21_7_15 10000.01716468342
R17625 n_20_7_15 n_20_8_15 292242.01641766605
R17626 n_20_8_0 n_21_8_0 2.486703379443606
R17627 n_20_8_0 n_20_9_0 8206.914999999884
R17628 n_20_8_0 n_20_8_1 287.21424032572827
R17629 n_20_8_1 n_21_8_1 3.481384731221048
R17630 n_20_8_1 n_20_9_1 11489.680999999839
R17631 n_20_8_1 n_20_8_2 652.759637103928
R17632 n_20_8_2 n_21_8_2 6.216758448609014
R17633 n_20_8_2 n_20_9_2 20517.287499999715
R17634 n_20_8_2 n_20_8_3 610.9830203292765
R17635 n_20_8_3 n_21_8_3 87.03461828052613
R17636 n_20_8_3 n_20_9_3 287242.0249999957
R17637 n_20_8_3 n_20_8_4 8.123231039515554
R17638 n_20_8_4 n_21_8_4 2.6374126751674587
R17639 n_20_8_4 n_20_9_4 8704.30378787866
R17640 n_20_8_15 n_21_8_15 174.0692365610507
R17641 n_20_8_15 n_20_9_15 574484.0499999863
R17642 n_20_9_0 n_21_9_0 2.486703379443604
R17643 n_20_9_0 n_20_10_0 8206.914999999884
R17644 n_20_9_0 n_20_9_1 287.2142403257281
R17645 n_20_9_1 n_21_9_1 3.481384731221046
R17646 n_20_9_1 n_20_10_1 11489.680999999839
R17647 n_20_9_1 n_20_9_2 652.7596371039276
R17648 n_20_9_2 n_21_9_2 6.216758448609011
R17649 n_20_9_2 n_20_10_2 20517.287499999715
R17650 n_20_9_2 n_20_9_3 610.9830203292762
R17651 n_20_9_3 n_21_9_3 87.03461828052608
R17652 n_20_9_3 n_20_10_3 287242.0249999957
R17653 n_20_9_3 n_20_9_4 8.123231039515549
R17654 n_20_9_4 n_21_9_4 2.637412675167457
R17655 n_20_9_4 n_20_10_4 8704.30378787866
R17656 n_20_9_15 n_21_9_15 174.06923656105062
R17657 n_20_9_15 n_20_10_15 574484.0499999863
R17658 n_20_10_0 n_21_10_0 2.486703379443606
R17659 n_20_10_0 n_20_11_0 8206.914999999883
R17660 n_20_10_0 n_20_10_1 287.21424032572827
R17661 n_20_10_1 n_21_10_1 3.481384731221048
R17662 n_20_10_1 n_20_11_1 11489.680999999835
R17663 n_20_10_1 n_20_10_2 652.759637103928
R17664 n_20_10_2 n_21_10_2 6.216758448609014
R17665 n_20_10_2 n_20_11_2 20517.287499999708
R17666 n_20_10_2 n_20_10_3 610.9830203292765
R17667 n_20_10_3 n_21_10_3 87.03461828052613
R17668 n_20_10_3 n_20_11_3 287242.0249999956
R17669 n_20_10_3 n_20_10_4 8.123231039515554
R17670 n_20_10_4 n_21_10_4 2.6374126751674587
R17671 n_20_10_4 n_20_11_4 8704.303787878656
R17672 n_20_10_15 n_21_10_15 174.0692365610507
R17673 n_20_10_15 n_20_11_15 574484.0499999862
R17674 n_20_11_0 n_21_11_0 2.486703379443606
R17675 n_20_11_0 n_20_12_0 4174.886071428513
R17676 n_20_11_0 n_20_11_1 287.21424032572827
R17677 n_20_11_1 n_21_11_1 3.481384731221048
R17678 n_20_11_1 n_20_12_1 5844.8404999999175
R17679 n_20_11_1 n_20_11_2 652.759637103928
R17680 n_20_11_2 n_21_11_2 6.216758448609014
R17681 n_20_11_2 n_20_12_2 10437.215178571283
R17682 n_20_11_2 n_20_11_3 610.9830203292765
R17683 n_20_11_3 n_21_11_3 87.03461828052613
R17684 n_20_11_3 n_20_12_3 146121.0124999978
R17685 n_20_11_3 n_20_11_4 8.123231039515554
R17686 n_20_11_4 n_21_11_4 2.6374126751674587
R17687 n_20_11_4 n_20_12_4 4427.909469696904
R17688 n_20_11_15 n_21_11_15 174.0692365610507
R17689 n_20_11_15 n_20_12_15 292242.02499999304
R17690 n_20_12_0 n_21_12_0 142.85714285714286
R17691 n_20_12_0 n_20_13_0 142.85714285714286
R17692 n_20_12_0 n_20_12_1 16499.99999999953
R17693 n_20_12_1 n_21_12_1 200.00000000000003
R17694 n_20_12_1 n_20_13_1 200.00000000000003
R17695 n_20_12_1 n_20_12_2 37499.99999999893
R17696 n_20_12_2 n_21_12_2 357.1428571428572
R17697 n_20_12_2 n_20_13_2 357.1428571428572
R17698 n_20_12_2 n_20_12_3 35099.999999999
R17699 n_20_12_3 n_21_12_3 4999.999999999996
R17700 n_20_12_3 n_20_13_3 4999.999999999996
R17701 n_20_12_3 n_20_12_4 466.66666666665384
R17702 n_20_12_4 n_21_12_4 151.51515151515142
R17703 n_20_12_4 n_20_13_4 151.51515151515142
R17704 n_20_12_15 n_21_12_15 9999.999999999904
R17705 n_20_12_15 n_20_13_15 9999.999999999904
R17706 n_20_13_0 n_21_13_0 142.85714285714286
R17707 n_20_13_0 n_20_14_0 142.85714285714286
R17708 n_20_13_0 n_20_13_1 16499.99999999953
R17709 n_20_13_1 n_21_13_1 200.00000000000003
R17710 n_20_13_1 n_20_14_1 200.00000000000003
R17711 n_20_13_1 n_20_13_2 37499.99999999893
R17712 n_20_13_2 n_21_13_2 357.1428571428572
R17713 n_20_13_2 n_20_14_2 357.1428571428572
R17714 n_20_13_2 n_20_13_3 35099.999999999
R17715 n_20_13_3 n_21_13_3 4999.999999999996
R17716 n_20_13_3 n_20_14_3 4999.999999999996
R17717 n_20_13_3 n_20_13_4 466.66666666665384
R17718 n_20_13_4 n_21_13_4 151.51515151515142
R17719 n_20_13_4 n_20_14_4 151.51515151515142
R17720 n_20_13_15 n_21_13_15 9999.999999999904
R17721 n_20_13_15 n_20_14_15 9999.999999999904
R17722 n_20_14_0 n_21_14_0 142.85714285714286
R17723 n_20_14_0 n_20_15_0 142.85714285714286
R17724 n_20_14_0 n_20_14_1 16499.99999999953
R17725 n_20_14_1 n_21_14_1 200.00000000000003
R17726 n_20_14_1 n_20_15_1 200.00000000000003
R17727 n_20_14_1 n_20_14_2 37499.99999999893
R17728 n_20_14_2 n_21_14_2 357.1428571428572
R17729 n_20_14_2 n_20_15_2 357.1428571428572
R17730 n_20_14_2 n_20_14_3 35099.999999999
R17731 n_20_14_3 n_21_14_3 4999.999999999996
R17732 n_20_14_3 n_20_15_3 4999.999999999996
R17733 n_20_14_3 n_20_14_4 466.66666666665384
R17734 n_20_14_4 n_21_14_4 151.51515151515142
R17735 n_20_14_4 n_20_15_4 151.51515151515142
R17736 n_20_14_15 n_21_14_15 9999.999999999904
R17737 n_20_14_15 n_20_15_15 9999.999999999904
R17738 n_20_15_0 n_21_15_0 142.85714285714286
R17739 n_20_15_0 n_20_16_0 4174.88607142851
R17740 n_20_15_0 n_20_15_1 16499.99999999953
R17741 n_20_15_1 n_21_15_1 200.00000000000003
R17742 n_20_15_1 n_20_16_1 5844.840499999915
R17743 n_20_15_1 n_20_15_2 37499.99999999893
R17744 n_20_15_2 n_21_15_2 357.1428571428572
R17745 n_20_15_2 n_20_16_2 10437.215178571278
R17746 n_20_15_2 n_20_15_3 35099.999999999
R17747 n_20_15_3 n_21_15_3 4999.999999999996
R17748 n_20_15_3 n_20_16_3 146121.0124999977
R17749 n_20_15_3 n_20_15_4 466.66666666665384
R17750 n_20_15_4 n_21_15_4 151.51515151515142
R17751 n_20_15_4 n_20_16_4 4427.909469696901
R17752 n_20_15_15 n_21_15_15 9999.999999999904
R17753 n_20_15_15 n_20_16_15 292242.02499999286
R17754 n_20_16_0 n_21_16_0 2.486703379443608
R17755 n_20_16_0 n_20_17_0 8206.914999999883
R17756 n_20_16_0 n_20_16_1 287.21424032572844
R17757 n_20_16_1 n_21_16_1 3.48138473122105
R17758 n_20_16_1 n_20_17_1 11489.680999999837
R17759 n_20_16_1 n_20_16_2 652.7596371039283
R17760 n_20_16_2 n_21_16_2 6.216758448609019
R17761 n_20_16_2 n_20_17_2 20517.287499999708
R17762 n_20_16_2 n_20_16_3 610.9830203292769
R17763 n_20_16_3 n_21_16_3 87.03461828052617
R17764 n_20_16_3 n_20_17_3 287242.0249999956
R17765 n_20_16_3 n_20_16_4 8.12323103951556
R17766 n_20_16_4 n_21_16_4 2.6374126751674596
R17767 n_20_16_4 n_20_17_4 8704.303787878656
R17768 n_20_16_15 n_21_16_15 174.06923656105081
R17769 n_20_16_15 n_20_17_15 574484.0499999862
R17770 n_20_17_0 n_21_17_0 2.486703379443604
R17771 n_20_17_0 n_20_18_0 8206.914999999888
R17772 n_20_17_0 n_20_17_1 287.2142403257281
R17773 n_20_17_1 n_21_17_1 3.481384731221046
R17774 n_20_17_1 n_20_18_1 11489.680999999842
R17775 n_20_17_1 n_20_17_2 652.7596371039276
R17776 n_20_17_2 n_21_17_2 6.216758448609011
R17777 n_20_17_2 n_20_18_2 20517.287499999722
R17778 n_20_17_2 n_20_17_3 610.9830203292762
R17779 n_20_17_3 n_21_17_3 87.03461828052608
R17780 n_20_17_3 n_20_18_3 287242.0249999958
R17781 n_20_17_3 n_20_17_4 8.123231039515549
R17782 n_20_17_4 n_21_17_4 2.637412675167457
R17783 n_20_17_4 n_20_18_4 8704.303787878662
R17784 n_20_17_15 n_21_17_15 174.06923656105062
R17785 n_20_17_15 n_20_18_15 574484.0499999865
R17786 n_20_18_0 n_21_18_0 2.486703379443604
R17787 n_20_18_0 n_20_19_0 8206.914999999883
R17788 n_20_18_0 n_20_18_1 287.2142403257281
R17789 n_20_18_1 n_21_18_1 3.481384731221046
R17790 n_20_18_1 n_20_19_1 11489.680999999837
R17791 n_20_18_1 n_20_18_2 652.7596371039276
R17792 n_20_18_2 n_21_18_2 6.216758448609011
R17793 n_20_18_2 n_20_19_2 20517.287499999708
R17794 n_20_18_2 n_20_18_3 610.9830203292762
R17795 n_20_18_3 n_21_18_3 87.03461828052608
R17796 n_20_18_3 n_20_19_3 287242.0249999956
R17797 n_20_18_3 n_20_18_4 8.123231039515549
R17798 n_20_18_4 n_21_18_4 2.637412675167457
R17799 n_20_18_4 n_20_19_4 8704.303787878656
R17800 n_20_18_15 n_21_18_15 174.06923656105062
R17801 n_20_18_15 n_20_19_15 574484.0499999862
R17802 n_20_19_0 n_21_19_0 2.486703379443608
R17803 n_20_19_0 n_20_20_0 4174.886084484129
R17804 n_20_19_0 n_20_19_1 287.21424032572844
R17805 n_20_19_1 n_21_19_1 3.48138473122105
R17806 n_20_19_1 n_20_20_1 5844.8405182777815
R17807 n_20_19_1 n_20_19_2 652.7596371039283
R17808 n_20_19_2 n_21_19_2 6.216758448609019
R17809 n_20_19_2 n_20_20_2 10437.215211210323
R17810 n_20_19_2 n_20_19_3 610.9830203292769
R17811 n_20_19_3 n_21_19_3 87.03461828052617
R17812 n_20_19_3 n_20_20_3 146121.01295694438
R17813 n_20_19_3 n_20_19_4 8.12323103951556
R17814 n_20_19_4 n_21_19_4 2.6374126751674596
R17815 n_20_19_4 n_20_20_4 4427.90948354377
R17816 n_20_19_15 n_21_19_15 174.06923656105081
R17817 n_20_19_15 n_20_20_15 292242.0259138862
R17818 n_20_20_0 n_21_20_0 142.85711674591005
R17819 n_20_20_0 n_20_21_0 142.85716896838048
R17820 n_20_20_0 n_20_20_1 16499.996984152138
R17821 n_20_20_1 n_21_20_1 199.99996344427402
R17822 n_20_20_1 n_20_21_1 200.00003655573266
R17823 n_20_20_1 n_20_20_2 37499.99314580031
R17824 n_20_20_2 n_21_20_2 357.1427918647751
R17825 n_20_20_2 n_20_21_2 357.1429224209512
R17826 n_20_20_2 n_20_20_3 35099.99358446909
R17827 n_20_20_3 n_21_20_3 4999.999086106846
R17828 n_20_20_3 n_20_21_3 5000.000913893312
R17829 n_20_20_3 n_20_20_4 466.66658136996
R17830 n_20_20_4 n_21_20_4 151.51512382141962
R17831 n_20_20_4 n_20_21_4 151.51517920888827
R17832 n_20_20_15 n_21_20_15 9999.998172213604
R17833 n_20_20_15 n_20_21_15 10000.001827786537
R17834 n_20_21_0 n_21_21_0 142.85711674591005
R17835 n_20_21_0 n_20_22_0 142.8571689683754
R17836 n_20_21_0 n_20_21_1 16499.996984152138
R17837 n_20_21_1 n_21_21_1 199.99996344427402
R17838 n_20_21_1 n_20_22_1 200.00003655572556
R17839 n_20_21_1 n_20_21_2 37499.99314580031
R17840 n_20_21_2 n_21_21_2 357.1427918647751
R17841 n_20_21_2 n_20_22_2 357.14292242093853
R17842 n_20_21_2 n_20_21_3 35099.99358446909
R17843 n_20_21_3 n_21_21_3 4999.999086106846
R17844 n_20_21_3 n_20_22_3 5000.000913893135
R17845 n_20_21_3 n_20_21_4 466.66658136996
R17846 n_20_21_4 n_21_21_4 151.51512382141962
R17847 n_20_21_4 n_20_22_4 151.5151792088829
R17848 n_20_21_15 n_21_21_15 9999.998172213604
R17849 n_20_21_15 n_20_22_15 10000.001827786182
R17850 n_20_22_0 n_21_22_0 142.85711674592017
R17851 n_20_22_0 n_20_23_0 142.8571689683754
R17852 n_20_22_0 n_20_22_1 16499.99698415331
R17853 n_20_22_1 n_21_22_1 199.99996344428826
R17854 n_20_22_1 n_20_23_1 200.00003655572556
R17855 n_20_22_1 n_20_22_2 37499.99314580298
R17856 n_20_22_2 n_21_22_2 357.1427918648005
R17857 n_20_22_2 n_20_23_2 357.14292242093853
R17858 n_20_22_2 n_20_22_3 35099.99358447159
R17859 n_20_22_3 n_21_22_3 4999.999086107202
R17860 n_20_22_3 n_20_23_3 5000.000913893135
R17861 n_20_22_3 n_20_22_4 466.66658136999297
R17862 n_20_22_4 n_21_22_4 151.51512382143036
R17863 n_20_22_4 n_20_23_4 151.5151792088829
R17864 n_20_22_15 n_21_22_15 9999.998172214315
R17865 n_20_22_15 n_20_23_15 10000.001827786182
R17866 n_20_23_0 n_21_23_0 142.85711674591005
R17867 n_20_23_0 n_20_24_0 1646.678571428551
R17868 n_20_23_0 n_20_23_1 16499.996984152138
R17869 n_20_23_1 n_21_23_1 199.99996344427402
R17870 n_20_23_1 n_20_24_1 2305.3499999999717
R17871 n_20_23_1 n_20_23_2 37499.99314580031
R17872 n_20_23_2 n_21_23_2 357.1427918647751
R17873 n_20_23_2 n_20_24_2 4116.696428571378
R17874 n_20_23_2 n_20_23_3 35099.99358446909
R17875 n_20_23_3 n_21_23_3 4999.999086106846
R17876 n_20_23_3 n_20_24_3 57633.749999999236
R17877 n_20_23_3 n_20_23_4 466.66658136996
R17878 n_20_23_4 n_21_23_4 151.51512382141962
R17879 n_20_23_4 n_20_24_4 1746.4772727272498
R17880 n_20_23_15 n_21_23_15 9999.998172213604
R17881 n_20_23_15 n_20_24_15 115267.49999999745
R17882 n_20_24_0 n_21_24_0 6.477753827788782
R17883 n_20_24_0 n_20_25_0 3150.499973888717
R17884 n_20_24_0 n_20_24_1 748.1805671095831
R17885 n_20_24_1 n_21_24_1 9.068855358904296
R17886 n_20_24_1 n_20_25_1 4410.699963444204
R17887 n_20_24_1 n_20_24_2 1700.410379794507
R17888 n_20_24_2 n_21_24_2 16.194384569471957
R17889 n_20_24_2 n_20_25_2 7876.249934721793
R17890 n_20_24_2 n_20_24_3 1591.5841154876584
R17891 n_20_24_3 n_21_24_3 226.72138397260719
R17892 n_20_24_3 n_20_25_3 110267.49908610499
R17893 n_20_24_3 n_20_24_4 21.16066250410944
R17894 n_20_24_4 n_21_24_4 6.870344968866884
R17895 n_20_24_4 n_20_25_4 3341.439366245606
R17896 n_20_24_4 n_20_24_5 17.48993533502923
R17897 n_20_24_5 n_21_24_5 43.18502551859185
R17898 n_20_24_5 n_20_25_5 21003.33315925809
R17899 n_20_24_5 n_20_24_6 6.045903572602696
R17900 n_20_24_6 n_21_24_6 7.19750425309864
R17901 n_20_24_6 n_20_25_6 3500.5555265430157
R17902 n_20_24_6 n_20_24_7 8.20515484853222
R17903 n_20_24_7 n_21_24_7 12.338578719597708
R17904 n_20_24_7 n_20_25_7 6000.952331216617
R17905 n_20_24_7 n_20_24_8 6.045903572602677
R17906 n_20_24_8 n_21_24_8 12.338578719597708
R17907 n_20_24_8 n_20_25_8 6000.952331216617
R17908 n_20_24_8 n_20_24_9 6.045903572602677
R17909 n_20_24_9 n_21_24_9 12.338578719597708
R17910 n_20_24_9 n_20_25_9 6000.952331216617
R17911 n_20_24_9 n_20_24_10 6.045903572602677
R17912 n_20_24_10 n_21_24_10 12.338578719597708
R17913 n_20_24_10 n_20_25_10 6000.952331216617
R17914 n_20_24_10 n_20_24_11 6.045903572602638
R17915 n_20_24_11 n_21_24_11 12.338578719597864
R17916 n_20_24_11 n_20_25_11 6000.952331216693
R17917 n_20_24_11 n_20_24_12 6.045903572602619
R17918 n_20_24_12 n_21_24_12 12.338578719597788
R17919 n_20_24_12 n_20_25_12 6000.952331216655
R17920 n_20_24_12 n_20_24_13 6.045903572602677
R17921 n_20_24_13 n_21_24_13 12.33857871959763
R17922 n_20_24_13 n_20_25_13 6000.952331216578
R17923 n_20_24_13 n_20_24_14 30.229517863013463
R17924 n_20_24_14 n_21_24_14 1.370953191066409
R17925 n_20_24_14 n_20_25_14 666.7724812462893
R17926 n_20_24_14 n_20_24_15 934.0921019671247
R17927 n_20_24_15 n_21_24_15 453.4427679452103
R17928 n_20_24_15 n_20_25_15 220534.99817220803
R17929 n_20_25_0 n_21_25_0 6.477753827788804
R17930 n_20_25_0 n_20_26_0 3150.499973888717
R17931 n_20_25_0 n_20_25_1 748.1805671095855
R17932 n_20_25_1 n_21_25_1 9.068855358904324
R17933 n_20_25_1 n_20_26_1 4410.699963444204
R17934 n_20_25_1 n_20_25_2 1700.4103797945122
R17935 n_20_25_2 n_21_25_2 16.19438456947201
R17936 n_20_25_2 n_20_26_2 7876.249934721793
R17937 n_20_25_2 n_20_25_3 1591.5841154876634
R17938 n_20_25_3 n_21_25_3 226.72138397260792
R17939 n_20_25_3 n_20_26_3 110267.49908610499
R17940 n_20_25_3 n_20_25_4 21.160662504109506
R17941 n_20_25_4 n_21_25_4 6.870344968866907
R17942 n_20_25_4 n_20_26_4 3341.439366245606
R17943 n_20_25_4 n_20_25_5 17.489935335029287
R17944 n_20_25_5 n_21_25_5 43.185025518591985
R17945 n_20_25_5 n_20_26_5 21003.33315925809
R17946 n_20_25_5 n_20_25_6 6.0459035726027155
R17947 n_20_25_6 n_21_25_6 7.197504253098664
R17948 n_20_25_6 n_20_26_6 3500.5555265430157
R17949 n_20_25_6 n_20_25_7 8.205154848532247
R17950 n_20_25_7 n_21_25_7 12.338578719597749
R17951 n_20_25_7 n_20_26_7 6000.952331216617
R17952 n_20_25_7 n_20_25_8 6.045903572602697
R17953 n_20_25_8 n_21_25_8 12.338578719597749
R17954 n_20_25_8 n_20_26_8 6000.952331216617
R17955 n_20_25_8 n_20_25_9 6.045903572602697
R17956 n_20_25_9 n_21_25_9 12.338578719597749
R17957 n_20_25_9 n_20_26_9 6000.952331216617
R17958 n_20_25_9 n_20_25_10 6.045903572602697
R17959 n_20_25_10 n_21_25_10 12.338578719597749
R17960 n_20_25_10 n_20_26_10 6000.952331216617
R17961 n_20_25_10 n_20_25_11 6.045903572602658
R17962 n_20_25_11 n_21_25_11 12.338578719597907
R17963 n_20_25_11 n_20_26_11 6000.952331216693
R17964 n_20_25_11 n_20_25_12 6.045903572602638
R17965 n_20_25_12 n_21_25_12 12.338578719597823
R17966 n_20_25_12 n_20_26_12 6000.952331216655
R17967 n_20_25_12 n_20_25_13 6.045903572602697
R17968 n_20_25_13 n_21_25_13 12.338578719597672
R17969 n_20_25_13 n_20_26_13 6000.952331216578
R17970 n_20_25_13 n_20_25_14 30.22951786301356
R17971 n_20_25_14 n_21_25_14 1.3709531910664134
R17972 n_20_25_14 n_20_26_14 666.7724812462893
R17973 n_20_25_14 n_20_25_15 934.0921019671276
R17974 n_20_25_15 n_21_25_15 453.44276794521176
R17975 n_20_25_15 n_20_26_15 220534.99817220803
R17976 n_20_26_0 n_21_26_0 6.477753827788782
R17977 n_20_26_0 n_20_27_0 3150.499973888722
R17978 n_20_26_0 n_20_26_1 748.1805671095831
R17979 n_20_26_1 n_21_26_1 9.068855358904296
R17980 n_20_26_1 n_20_27_1 4410.699963444211
R17981 n_20_26_1 n_20_26_2 1700.410379794507
R17982 n_20_26_2 n_21_26_2 16.194384569471957
R17983 n_20_26_2 n_20_27_2 7876.249934721805
R17984 n_20_26_2 n_20_26_3 1591.5841154876584
R17985 n_20_26_3 n_21_26_3 226.72138397260719
R17986 n_20_26_3 n_20_27_3 110267.49908610516
R17987 n_20_26_3 n_20_26_4 21.16066250410944
R17988 n_20_26_4 n_21_26_4 6.870344968866884
R17989 n_20_26_4 n_20_27_4 3341.4393662456114
R17990 n_20_26_4 n_20_26_5 17.48993533502923
R17991 n_20_26_5 n_21_26_5 43.18502551859185
R17992 n_20_26_5 n_20_27_5 21003.333159258123
R17993 n_20_26_5 n_20_26_6 6.045903572602696
R17994 n_20_26_6 n_21_26_6 7.19750425309864
R17995 n_20_26_6 n_20_27_6 3500.555526543021
R17996 n_20_26_6 n_20_26_7 8.20515484853222
R17997 n_20_26_7 n_21_26_7 12.338578719597708
R17998 n_20_26_7 n_20_27_7 6000.952331216627
R17999 n_20_26_7 n_20_26_8 6.045903572602677
R18000 n_20_26_8 n_21_26_8 12.338578719597708
R18001 n_20_26_8 n_20_27_8 6000.952331216627
R18002 n_20_26_8 n_20_26_9 6.045903572602677
R18003 n_20_26_9 n_21_26_9 12.338578719597708
R18004 n_20_26_9 n_20_27_9 6000.952331216627
R18005 n_20_26_9 n_20_26_10 6.045903572602677
R18006 n_20_26_10 n_21_26_10 12.338578719597708
R18007 n_20_26_10 n_20_27_10 6000.952331216627
R18008 n_20_26_10 n_20_26_11 6.045903572602638
R18009 n_20_26_11 n_21_26_11 12.338578719597864
R18010 n_20_26_11 n_20_27_11 6000.952331216702
R18011 n_20_26_11 n_20_26_12 6.045903572602619
R18012 n_20_26_12 n_21_26_12 12.338578719597788
R18013 n_20_26_12 n_20_27_12 6000.952331216665
R18014 n_20_26_12 n_20_26_13 6.045903572602677
R18015 n_20_26_13 n_21_26_13 12.33857871959763
R18016 n_20_26_13 n_20_27_13 6000.952331216588
R18017 n_20_26_13 n_20_26_14 30.229517863013463
R18018 n_20_26_14 n_21_26_14 1.370953191066409
R18019 n_20_26_14 n_20_27_14 666.7724812462903
R18020 n_20_26_14 n_20_26_15 934.0921019671247
R18021 n_20_26_15 n_21_26_15 453.4427679452103
R18022 n_20_26_15 n_20_27_15 220534.99817220838
R18023 n_20_27_0 n_21_27_0 6.477753827788782
R18024 n_20_27_0 n_20_27_1 748.1805671095831
R18025 n_20_27_1 n_21_27_1 9.068855358904296
R18026 n_20_27_1 n_20_27_2 1700.410379794507
R18027 n_20_27_2 n_21_27_2 16.194384569471957
R18028 n_20_27_2 n_20_27_3 1591.5841154876584
R18029 n_20_27_3 n_21_27_3 226.72138397260719
R18030 n_20_27_3 n_20_27_4 21.16066250410944
R18031 n_20_27_4 n_21_27_4 6.870344968866884
R18032 n_20_27_4 n_20_27_5 17.48993533502923
R18033 n_20_27_5 n_21_27_5 43.18502551859185
R18034 n_20_27_5 n_20_27_6 6.045903572602696
R18035 n_20_27_6 n_21_27_6 7.19750425309864
R18036 n_20_27_6 n_20_27_7 8.20515484853222
R18037 n_20_27_7 n_21_27_7 12.338578719597708
R18038 n_20_27_7 n_20_27_8 6.045903572602677
R18039 n_20_27_8 n_21_27_8 12.338578719597708
R18040 n_20_27_8 n_20_27_9 6.045903572602677
R18041 n_20_27_9 n_21_27_9 12.338578719597708
R18042 n_20_27_9 n_20_27_10 6.045903572602677
R18043 n_20_27_10 n_21_27_10 12.338578719597708
R18044 n_20_27_10 n_20_27_11 6.045903572602638
R18045 n_20_27_11 n_21_27_11 12.338578719597864
R18046 n_20_27_11 n_20_27_12 6.045903572602619
R18047 n_20_27_12 n_21_27_12 12.338578719597788
R18048 n_20_27_12 n_20_27_13 6.045903572602677
R18049 n_20_27_13 n_21_27_13 12.33857871959763
R18050 n_20_27_13 n_20_27_14 30.229517863013463
R18051 n_20_27_14 n_21_27_14 1.370953191066409
R18052 n_20_27_14 n_20_27_15 934.0921019671247
R18053 n_20_27_15 n_21_27_15 453.4427679452103
R18054 n_21_0_0 n_22_0_0 6.4777532699256675
R18055 n_21_0_0 n_21_1_0 3150.5002452092954
R18056 n_21_0_0 n_21_0_1 748.1805026763932
R18057 n_21_0_1 n_22_0_1 9.068854577895932
R18058 n_21_0_1 n_21_1_1 4410.700343293014
R18059 n_21_0_1 n_21_0_2 1700.4102333554388
R18060 n_21_0_2 n_22_0_2 16.194383174814167
R18061 n_21_0_2 n_21_1_2 7876.25061302324
R18062 n_21_0_2 n_21_0_3 1591.5839784206908
R18063 n_21_0_3 n_22_0_3 226.7213644473981
R18064 n_21_0_3 n_21_1_3 110267.50858232524
R18065 n_21_0_3 n_21_0_4 21.160660681756593
R18066 n_21_0_4 n_22_0_4 6.870344377193882
R18067 n_21_0_4 n_21_1_4 3341.4396540098564
R18068 n_21_0_4 n_21_0_5 17.489933828798815
R18069 n_21_0_5 n_22_0_5 43.1850217995044
R18070 n_21_0_5 n_21_1_5 21003.33496806195
R18071 n_21_0_5 n_21_0_6 6.045903051930455
R18072 n_21_0_6 n_22_0_6 7.197503633250734
R18073 n_21_0_6 n_21_1_6 3500.5558280103255
R18074 n_21_0_6 n_21_0_7 8.205154141905608
R18075 n_21_0_7 n_22_0_7 12.338577657001295
R18076 n_21_0_7 n_21_1_7 6000.95284801772
R18077 n_21_0_7 n_21_0_8 6.045903051930436
R18078 n_21_0_8 n_22_0_8 12.338577657001295
R18079 n_21_0_8 n_21_1_8 6000.95284801772
R18080 n_21_0_8 n_21_0_9 6.045903051930436
R18081 n_21_0_9 n_22_0_9 12.338577657001295
R18082 n_21_0_9 n_21_1_9 6000.95284801772
R18083 n_21_0_9 n_21_0_10 6.045903051930436
R18084 n_21_0_10 n_22_0_10 12.338577657001295
R18085 n_21_0_10 n_21_1_10 6000.95284801772
R18086 n_21_0_10 n_21_0_11 6.045903051930397
R18087 n_21_0_11 n_22_0_11 12.338577657001453
R18088 n_21_0_11 n_21_1_11 6000.952848017796
R18089 n_21_0_11 n_21_0_12 6.045903051930377
R18090 n_21_0_12 n_22_0_12 12.338577657001379
R18091 n_21_0_12 n_21_1_12 6000.952848017758
R18092 n_21_0_12 n_21_0_13 6.045903051930436
R18093 n_21_0_13 n_22_0_13 12.338577657001219
R18094 n_21_0_13 n_21_1_13 6000.952848017681
R18095 n_21_0_13 n_21_0_14 30.229515259652253
R18096 n_21_0_14 n_22_0_14 1.3709530730001411
R18097 n_21_0_14 n_21_1_14 666.7725386686341
R18098 n_21_0_14 n_21_0_15 934.0920215232634
R18099 n_21_0_15 n_22_0_15 453.4427288947922
R18100 n_21_0_15 n_21_1_15 220535.01716464857
R18101 n_21_1_0 n_22_1_0 6.4777532699256675
R18102 n_21_1_0 n_21_2_0 3150.5002452092954
R18103 n_21_1_0 n_21_1_1 748.1805026763932
R18104 n_21_1_1 n_22_1_1 9.068854577895932
R18105 n_21_1_1 n_21_2_1 4410.700343293014
R18106 n_21_1_1 n_21_1_2 1700.4102333554388
R18107 n_21_1_2 n_22_1_2 16.194383174814167
R18108 n_21_1_2 n_21_2_2 7876.25061302324
R18109 n_21_1_2 n_21_1_3 1591.5839784206908
R18110 n_21_1_3 n_22_1_3 226.7213644473981
R18111 n_21_1_3 n_21_2_3 110267.50858232524
R18112 n_21_1_3 n_21_1_4 21.160660681756593
R18113 n_21_1_4 n_22_1_4 6.870344377193882
R18114 n_21_1_4 n_21_2_4 3341.4396540098564
R18115 n_21_1_4 n_21_1_5 17.489933828798815
R18116 n_21_1_5 n_22_1_5 43.1850217995044
R18117 n_21_1_5 n_21_2_5 21003.33496806195
R18118 n_21_1_5 n_21_1_6 6.045903051930455
R18119 n_21_1_6 n_22_1_6 7.197503633250734
R18120 n_21_1_6 n_21_2_6 3500.5558280103255
R18121 n_21_1_6 n_21_1_7 8.205154141905608
R18122 n_21_1_7 n_22_1_7 12.338577657001295
R18123 n_21_1_7 n_21_2_7 6000.95284801772
R18124 n_21_1_7 n_21_1_8 6.045903051930436
R18125 n_21_1_8 n_22_1_8 12.338577657001295
R18126 n_21_1_8 n_21_2_8 6000.95284801772
R18127 n_21_1_8 n_21_1_9 6.045903051930436
R18128 n_21_1_9 n_22_1_9 12.338577657001295
R18129 n_21_1_9 n_21_2_9 6000.95284801772
R18130 n_21_1_9 n_21_1_10 6.045903051930436
R18131 n_21_1_10 n_22_1_10 12.338577657001295
R18132 n_21_1_10 n_21_2_10 6000.95284801772
R18133 n_21_1_10 n_21_1_11 6.045903051930397
R18134 n_21_1_11 n_22_1_11 12.338577657001453
R18135 n_21_1_11 n_21_2_11 6000.952848017796
R18136 n_21_1_11 n_21_1_12 6.045903051930377
R18137 n_21_1_12 n_22_1_12 12.338577657001379
R18138 n_21_1_12 n_21_2_12 6000.952848017758
R18139 n_21_1_12 n_21_1_13 6.045903051930436
R18140 n_21_1_13 n_22_1_13 12.338577657001219
R18141 n_21_1_13 n_21_2_13 6000.952848017681
R18142 n_21_1_13 n_21_1_14 30.229515259652253
R18143 n_21_1_14 n_22_1_14 1.3709530730001411
R18144 n_21_1_14 n_21_2_14 666.7725386686341
R18145 n_21_1_14 n_21_1_15 934.0920215232634
R18146 n_21_1_15 n_22_1_15 453.4427288947922
R18147 n_21_1_15 n_21_2_15 220535.01716464857
R18148 n_21_2_0 n_22_2_0 6.4777532699256675
R18149 n_21_2_0 n_21_3_0 3150.5002452092954
R18150 n_21_2_0 n_21_2_1 748.1805026763932
R18151 n_21_2_1 n_22_2_1 9.068854577895932
R18152 n_21_2_1 n_21_3_1 4410.700343293014
R18153 n_21_2_1 n_21_2_2 1700.4102333554388
R18154 n_21_2_2 n_22_2_2 16.194383174814167
R18155 n_21_2_2 n_21_3_2 7876.25061302324
R18156 n_21_2_2 n_21_2_3 1591.5839784206908
R18157 n_21_2_3 n_22_2_3 226.7213644473981
R18158 n_21_2_3 n_21_3_3 110267.50858232524
R18159 n_21_2_3 n_21_2_4 21.160660681756593
R18160 n_21_2_4 n_22_2_4 6.870344377193882
R18161 n_21_2_4 n_21_3_4 3341.4396540098564
R18162 n_21_2_4 n_21_2_5 17.489933828798815
R18163 n_21_2_5 n_22_2_5 43.1850217995044
R18164 n_21_2_5 n_21_3_5 21003.33496806195
R18165 n_21_2_5 n_21_2_6 6.045903051930455
R18166 n_21_2_6 n_22_2_6 7.197503633250734
R18167 n_21_2_6 n_21_3_6 3500.5558280103255
R18168 n_21_2_6 n_21_2_7 8.205154141905608
R18169 n_21_2_7 n_22_2_7 12.338577657001295
R18170 n_21_2_7 n_21_3_7 6000.95284801772
R18171 n_21_2_7 n_21_2_8 6.045903051930436
R18172 n_21_2_8 n_22_2_8 12.338577657001295
R18173 n_21_2_8 n_21_3_8 6000.95284801772
R18174 n_21_2_8 n_21_2_9 6.045903051930436
R18175 n_21_2_9 n_22_2_9 12.338577657001295
R18176 n_21_2_9 n_21_3_9 6000.95284801772
R18177 n_21_2_9 n_21_2_10 6.045903051930436
R18178 n_21_2_10 n_22_2_10 12.338577657001295
R18179 n_21_2_10 n_21_3_10 6000.95284801772
R18180 n_21_2_10 n_21_2_11 6.045903051930397
R18181 n_21_2_11 n_22_2_11 12.338577657001453
R18182 n_21_2_11 n_21_3_11 6000.952848017796
R18183 n_21_2_11 n_21_2_12 6.045903051930377
R18184 n_21_2_12 n_22_2_12 12.338577657001379
R18185 n_21_2_12 n_21_3_12 6000.952848017758
R18186 n_21_2_12 n_21_2_13 6.045903051930436
R18187 n_21_2_13 n_22_2_13 12.338577657001219
R18188 n_21_2_13 n_21_3_13 6000.952848017681
R18189 n_21_2_13 n_21_2_14 30.229515259652253
R18190 n_21_2_14 n_22_2_14 1.3709530730001411
R18191 n_21_2_14 n_21_3_14 666.7725386686341
R18192 n_21_2_14 n_21_2_15 934.0920215232634
R18193 n_21_2_15 n_22_2_15 453.4427288947922
R18194 n_21_2_15 n_21_3_15 220535.01716464857
R18195 n_21_3_0 n_22_3_0 6.4777532699256675
R18196 n_21_3_0 n_21_4_0 1646.6785714285472
R18197 n_21_3_0 n_21_3_1 748.1805026763932
R18198 n_21_3_1 n_22_3_1 9.068854577895932
R18199 n_21_3_1 n_21_4_1 2305.3499999999667
R18200 n_21_3_1 n_21_3_2 1700.4102333554388
R18201 n_21_3_2 n_22_3_2 16.194383174814167
R18202 n_21_3_2 n_21_4_2 4116.696428571369
R18203 n_21_3_2 n_21_3_3 1591.5839784206908
R18204 n_21_3_3 n_22_3_3 226.7213644473981
R18205 n_21_3_3 n_21_4_3 57633.749999999105
R18206 n_21_3_3 n_21_3_4 21.160660681756593
R18207 n_21_3_4 n_22_3_4 6.870344377193882
R18208 n_21_3_4 n_21_4_4 1746.477272727246
R18209 n_21_3_4 n_21_3_5 17.489933828798815
R18210 n_21_3_5 n_22_3_5 43.1850217995044
R18211 n_21_3_5 n_21_3_6 6.045903051930455
R18212 n_21_3_6 n_22_3_6 7.197503633250734
R18213 n_21_3_6 n_21_3_7 8.205154141905608
R18214 n_21_3_7 n_22_3_7 12.338577657001295
R18215 n_21_3_7 n_21_3_8 6.045903051930436
R18216 n_21_3_8 n_22_3_8 12.338577657001295
R18217 n_21_3_8 n_21_3_9 6.045903051930436
R18218 n_21_3_9 n_22_3_9 12.338577657001295
R18219 n_21_3_9 n_21_3_10 6.045903051930436
R18220 n_21_3_10 n_22_3_10 12.338577657001295
R18221 n_21_3_10 n_21_3_11 6.045903051930397
R18222 n_21_3_11 n_22_3_11 12.338577657001453
R18223 n_21_3_11 n_21_3_12 6.045903051930377
R18224 n_21_3_12 n_22_3_12 12.338577657001379
R18225 n_21_3_12 n_21_3_13 6.045903051930436
R18226 n_21_3_13 n_22_3_13 12.338577657001219
R18227 n_21_3_13 n_21_3_14 30.229515259652253
R18228 n_21_3_14 n_22_3_14 1.3709530730001411
R18229 n_21_3_14 n_21_3_15 934.0920215232634
R18230 n_21_3_15 n_22_3_15 453.4427288947922
R18231 n_21_3_15 n_21_4_15 115267.4999999972
R18232 n_21_4_0 n_22_4_0 142.8573880669074
R18233 n_21_4_0 n_21_5_0 142.8568976478005
R18234 n_21_4_0 n_21_4_1 16500.028321727335
R18235 n_21_4_1 n_22_4_1 200.00034329367034
R18236 n_21_4_1 n_21_5_1 199.99965670692075
R18237 n_21_4_1 n_21_4_2 37500.064367562125
R18238 n_21_4_2 n_22_4_2 357.1434701672685
R18239 n_21_4_2 n_21_5_2 357.14224411950136
R18240 n_21_4_2 n_21_4_3 35100.06024803815
R18241 n_21_4_3 n_22_4_3 5000.008582341755
R18242 n_21_4_3 n_21_5_3 4999.9914176730135
R18243 n_21_4_3 n_21_4_4 466.66746768521796
R18244 n_21_4_4 n_22_4_4 151.51541158611377
R18245 n_21_4_4 n_21_5_4 151.5148914446368
R18246 n_21_4_15 n_22_4_15 10000.01716468342
R18247 n_21_4_15 n_21_5_15 9999.982835345938
R18248 n_21_5_0 n_22_5_0 142.8573880669049
R18249 n_21_5_0 n_21_6_0 142.8568976478018
R18250 n_21_5_0 n_21_5_1 16500.02832172704
R18251 n_21_5_1 n_22_5_1 200.0003432936668
R18252 n_21_5_1 n_21_6_1 199.9996567069225
R18253 n_21_5_1 n_21_5_2 37500.06436756146
R18254 n_21_5_2 n_22_5_2 357.14347016726214
R18255 n_21_5_2 n_21_6_2 357.1422441195045
R18256 n_21_5_2 n_21_5_3 35100.06024803753
R18257 n_21_5_3 n_22_5_3 5000.008582341666
R18258 n_21_5_3 n_21_6_3 4999.991417673058
R18259 n_21_5_3 n_21_5_4 466.66746768520966
R18260 n_21_5_4 n_22_5_4 151.51541158611107
R18261 n_21_5_4 n_21_6_4 151.51489144463812
R18262 n_21_5_15 n_22_5_15 10000.017164683242
R18263 n_21_5_15 n_21_6_15 9999.982835346027
R18264 n_21_6_0 n_22_6_0 142.8573880669049
R18265 n_21_6_0 n_21_7_0 142.8568976478005
R18266 n_21_6_0 n_21_6_1 16500.02832172704
R18267 n_21_6_1 n_22_6_1 200.0003432936668
R18268 n_21_6_1 n_21_7_1 199.99965670692075
R18269 n_21_6_1 n_21_6_2 37500.06436756146
R18270 n_21_6_2 n_22_6_2 357.14347016726214
R18271 n_21_6_2 n_21_7_2 357.14224411950136
R18272 n_21_6_2 n_21_6_3 35100.06024803753
R18273 n_21_6_3 n_22_6_3 5000.008582341666
R18274 n_21_6_3 n_21_7_3 4999.9914176730135
R18275 n_21_6_3 n_21_6_4 466.66746768520966
R18276 n_21_6_4 n_22_6_4 151.51541158611107
R18277 n_21_6_4 n_21_7_4 151.5148914446368
R18278 n_21_6_15 n_22_6_15 10000.017164683242
R18279 n_21_6_15 n_21_7_15 9999.982835345938
R18280 n_21_7_0 n_22_7_0 142.8573880669074
R18281 n_21_7_0 n_21_8_0 4174.885948823841
R18282 n_21_7_0 n_21_7_1 16500.028321727335
R18283 n_21_7_1 n_22_7_1 200.00034329367034
R18284 n_21_7_1 n_21_8_1 5844.840328353377
R18285 n_21_7_1 n_21_7_2 37500.064367562125
R18286 n_21_7_2 n_22_7_2 357.1434701672685
R18287 n_21_7_2 n_21_8_2 10437.214872059603
R18288 n_21_7_2 n_21_7_3 35100.06024803815
R18289 n_21_7_3 n_22_7_3 5000.008582341755
R18290 n_21_7_3 n_21_8_3 146121.00820883428
R18291 n_21_7_3 n_21_7_4 466.66746768521796
R18292 n_21_7_4 n_22_7_4 151.51541158611377
R18293 n_21_7_4 n_21_8_4 4427.909339661646
R18294 n_21_7_15 n_22_7_15 10000.01716468342
R18295 n_21_7_15 n_21_8_15 292242.01641766605
R18296 n_21_8_0 n_22_8_0 2.486703379443606
R18297 n_21_8_0 n_21_9_0 8206.914999999884
R18298 n_21_8_0 n_21_8_1 287.21424032572827
R18299 n_21_8_1 n_22_8_1 3.481384731221048
R18300 n_21_8_1 n_21_9_1 11489.680999999839
R18301 n_21_8_1 n_21_8_2 652.759637103928
R18302 n_21_8_2 n_22_8_2 6.216758448609014
R18303 n_21_8_2 n_21_9_2 20517.287499999715
R18304 n_21_8_2 n_21_8_3 610.9830203292765
R18305 n_21_8_3 n_22_8_3 87.03461828052613
R18306 n_21_8_3 n_21_9_3 287242.0249999957
R18307 n_21_8_3 n_21_8_4 8.123231039515554
R18308 n_21_8_4 n_22_8_4 2.6374126751674587
R18309 n_21_8_4 n_21_9_4 8704.30378787866
R18310 n_21_8_15 n_22_8_15 174.0692365610507
R18311 n_21_8_15 n_21_9_15 574484.0499999863
R18312 n_21_9_0 n_22_9_0 2.486703379443604
R18313 n_21_9_0 n_21_10_0 8206.914999999884
R18314 n_21_9_0 n_21_9_1 287.2142403257281
R18315 n_21_9_1 n_22_9_1 3.481384731221046
R18316 n_21_9_1 n_21_10_1 11489.680999999839
R18317 n_21_9_1 n_21_9_2 652.7596371039276
R18318 n_21_9_2 n_22_9_2 6.216758448609011
R18319 n_21_9_2 n_21_10_2 20517.287499999715
R18320 n_21_9_2 n_21_9_3 610.9830203292762
R18321 n_21_9_3 n_22_9_3 87.03461828052608
R18322 n_21_9_3 n_21_10_3 287242.0249999957
R18323 n_21_9_3 n_21_9_4 8.123231039515549
R18324 n_21_9_4 n_22_9_4 2.637412675167457
R18325 n_21_9_4 n_21_10_4 8704.30378787866
R18326 n_21_9_15 n_22_9_15 174.06923656105062
R18327 n_21_9_15 n_21_10_15 574484.0499999863
R18328 n_21_10_0 n_22_10_0 2.486703379443606
R18329 n_21_10_0 n_21_11_0 8206.914999999883
R18330 n_21_10_0 n_21_10_1 287.21424032572827
R18331 n_21_10_1 n_22_10_1 3.481384731221048
R18332 n_21_10_1 n_21_11_1 11489.680999999835
R18333 n_21_10_1 n_21_10_2 652.759637103928
R18334 n_21_10_2 n_22_10_2 6.216758448609014
R18335 n_21_10_2 n_21_11_2 20517.287499999708
R18336 n_21_10_2 n_21_10_3 610.9830203292765
R18337 n_21_10_3 n_22_10_3 87.03461828052613
R18338 n_21_10_3 n_21_11_3 287242.0249999956
R18339 n_21_10_3 n_21_10_4 8.123231039515554
R18340 n_21_10_4 n_22_10_4 2.6374126751674587
R18341 n_21_10_4 n_21_11_4 8704.303787878656
R18342 n_21_10_15 n_22_10_15 174.0692365610507
R18343 n_21_10_15 n_21_11_15 574484.0499999862
R18344 n_21_11_0 n_22_11_0 2.486703379443606
R18345 n_21_11_0 n_21_12_0 4174.886071428513
R18346 n_21_11_0 n_21_11_1 287.21424032572827
R18347 n_21_11_1 n_22_11_1 3.481384731221048
R18348 n_21_11_1 n_21_12_1 5844.8404999999175
R18349 n_21_11_1 n_21_11_2 652.759637103928
R18350 n_21_11_2 n_22_11_2 6.216758448609014
R18351 n_21_11_2 n_21_12_2 10437.215178571283
R18352 n_21_11_2 n_21_11_3 610.9830203292765
R18353 n_21_11_3 n_22_11_3 87.03461828052613
R18354 n_21_11_3 n_21_12_3 146121.0124999978
R18355 n_21_11_3 n_21_11_4 8.123231039515554
R18356 n_21_11_4 n_22_11_4 2.6374126751674587
R18357 n_21_11_4 n_21_12_4 4427.909469696904
R18358 n_21_11_15 n_22_11_15 174.0692365610507
R18359 n_21_11_15 n_21_12_15 292242.02499999304
R18360 n_21_12_0 n_22_12_0 142.85714285714286
R18361 n_21_12_0 n_21_13_0 142.85714285714286
R18362 n_21_12_0 n_21_12_1 16499.99999999953
R18363 n_21_12_1 n_22_12_1 200.00000000000003
R18364 n_21_12_1 n_21_13_1 200.00000000000003
R18365 n_21_12_1 n_21_12_2 37499.99999999893
R18366 n_21_12_2 n_22_12_2 357.1428571428572
R18367 n_21_12_2 n_21_13_2 357.1428571428572
R18368 n_21_12_2 n_21_12_3 35099.999999999
R18369 n_21_12_3 n_22_12_3 4999.999999999996
R18370 n_21_12_3 n_21_13_3 4999.999999999996
R18371 n_21_12_3 n_21_12_4 466.66666666665384
R18372 n_21_12_4 n_22_12_4 151.51515151515142
R18373 n_21_12_4 n_21_13_4 151.51515151515142
R18374 n_21_12_15 n_22_12_15 9999.999999999904
R18375 n_21_12_15 n_21_13_15 9999.999999999904
R18376 n_21_13_0 n_22_13_0 142.85714285714286
R18377 n_21_13_0 n_21_14_0 142.85714285714286
R18378 n_21_13_0 n_21_13_1 16499.99999999953
R18379 n_21_13_1 n_22_13_1 200.00000000000003
R18380 n_21_13_1 n_21_14_1 200.00000000000003
R18381 n_21_13_1 n_21_13_2 37499.99999999893
R18382 n_21_13_2 n_22_13_2 357.1428571428572
R18383 n_21_13_2 n_21_14_2 357.1428571428572
R18384 n_21_13_2 n_21_13_3 35099.999999999
R18385 n_21_13_3 n_22_13_3 4999.999999999996
R18386 n_21_13_3 n_21_14_3 4999.999999999996
R18387 n_21_13_3 n_21_13_4 466.66666666665384
R18388 n_21_13_4 n_22_13_4 151.51515151515142
R18389 n_21_13_4 n_21_14_4 151.51515151515142
R18390 n_21_13_15 n_22_13_15 9999.999999999904
R18391 n_21_13_15 n_21_14_15 9999.999999999904
R18392 n_21_14_0 n_22_14_0 142.85714285714286
R18393 n_21_14_0 n_21_15_0 142.85714285714286
R18394 n_21_14_0 n_21_14_1 16499.99999999953
R18395 n_21_14_1 n_22_14_1 200.00000000000003
R18396 n_21_14_1 n_21_15_1 200.00000000000003
R18397 n_21_14_1 n_21_14_2 37499.99999999893
R18398 n_21_14_2 n_22_14_2 357.1428571428572
R18399 n_21_14_2 n_21_15_2 357.1428571428572
R18400 n_21_14_2 n_21_14_3 35099.999999999
R18401 n_21_14_3 n_22_14_3 4999.999999999996
R18402 n_21_14_3 n_21_15_3 4999.999999999996
R18403 n_21_14_3 n_21_14_4 466.66666666665384
R18404 n_21_14_4 n_22_14_4 151.51515151515142
R18405 n_21_14_4 n_21_15_4 151.51515151515142
R18406 n_21_14_15 n_22_14_15 9999.999999999904
R18407 n_21_14_15 n_21_15_15 9999.999999999904
R18408 n_21_15_0 n_22_15_0 142.85714285714286
R18409 n_21_15_0 n_21_16_0 4174.88607142851
R18410 n_21_15_0 n_21_15_1 16499.99999999953
R18411 n_21_15_1 n_22_15_1 200.00000000000003
R18412 n_21_15_1 n_21_16_1 5844.840499999915
R18413 n_21_15_1 n_21_15_2 37499.99999999893
R18414 n_21_15_2 n_22_15_2 357.1428571428572
R18415 n_21_15_2 n_21_16_2 10437.215178571278
R18416 n_21_15_2 n_21_15_3 35099.999999999
R18417 n_21_15_3 n_22_15_3 4999.999999999996
R18418 n_21_15_3 n_21_16_3 146121.0124999977
R18419 n_21_15_3 n_21_15_4 466.66666666665384
R18420 n_21_15_4 n_22_15_4 151.51515151515142
R18421 n_21_15_4 n_21_16_4 4427.909469696901
R18422 n_21_15_15 n_22_15_15 9999.999999999904
R18423 n_21_15_15 n_21_16_15 292242.02499999286
R18424 n_21_16_0 n_22_16_0 2.486703379443608
R18425 n_21_16_0 n_21_17_0 8206.914999999883
R18426 n_21_16_0 n_21_16_1 287.21424032572844
R18427 n_21_16_1 n_22_16_1 3.48138473122105
R18428 n_21_16_1 n_21_17_1 11489.680999999837
R18429 n_21_16_1 n_21_16_2 652.7596371039283
R18430 n_21_16_2 n_22_16_2 6.216758448609019
R18431 n_21_16_2 n_21_17_2 20517.287499999708
R18432 n_21_16_2 n_21_16_3 610.9830203292769
R18433 n_21_16_3 n_22_16_3 87.03461828052617
R18434 n_21_16_3 n_21_17_3 287242.0249999956
R18435 n_21_16_3 n_21_16_4 8.12323103951556
R18436 n_21_16_4 n_22_16_4 2.6374126751674596
R18437 n_21_16_4 n_21_17_4 8704.303787878656
R18438 n_21_16_15 n_22_16_15 174.06923656105081
R18439 n_21_16_15 n_21_17_15 574484.0499999862
R18440 n_21_17_0 n_22_17_0 2.486703379443604
R18441 n_21_17_0 n_21_18_0 8206.914999999888
R18442 n_21_17_0 n_21_17_1 287.2142403257281
R18443 n_21_17_1 n_22_17_1 3.481384731221046
R18444 n_21_17_1 n_21_18_1 11489.680999999842
R18445 n_21_17_1 n_21_17_2 652.7596371039276
R18446 n_21_17_2 n_22_17_2 6.216758448609011
R18447 n_21_17_2 n_21_18_2 20517.287499999722
R18448 n_21_17_2 n_21_17_3 610.9830203292762
R18449 n_21_17_3 n_22_17_3 87.03461828052608
R18450 n_21_17_3 n_21_18_3 287242.0249999958
R18451 n_21_17_3 n_21_17_4 8.123231039515549
R18452 n_21_17_4 n_22_17_4 2.637412675167457
R18453 n_21_17_4 n_21_18_4 8704.303787878662
R18454 n_21_17_15 n_22_17_15 174.06923656105062
R18455 n_21_17_15 n_21_18_15 574484.0499999865
R18456 n_21_18_0 n_22_18_0 2.486703379443604
R18457 n_21_18_0 n_21_19_0 8206.914999999883
R18458 n_21_18_0 n_21_18_1 287.2142403257281
R18459 n_21_18_1 n_22_18_1 3.481384731221046
R18460 n_21_18_1 n_21_19_1 11489.680999999837
R18461 n_21_18_1 n_21_18_2 652.7596371039276
R18462 n_21_18_2 n_22_18_2 6.216758448609011
R18463 n_21_18_2 n_21_19_2 20517.287499999708
R18464 n_21_18_2 n_21_18_3 610.9830203292762
R18465 n_21_18_3 n_22_18_3 87.03461828052608
R18466 n_21_18_3 n_21_19_3 287242.0249999956
R18467 n_21_18_3 n_21_18_4 8.123231039515549
R18468 n_21_18_4 n_22_18_4 2.637412675167457
R18469 n_21_18_4 n_21_19_4 8704.303787878656
R18470 n_21_18_15 n_22_18_15 174.06923656105062
R18471 n_21_18_15 n_21_19_15 574484.0499999862
R18472 n_21_19_0 n_22_19_0 2.486703379443608
R18473 n_21_19_0 n_21_20_0 4174.886084484129
R18474 n_21_19_0 n_21_19_1 287.21424032572844
R18475 n_21_19_1 n_22_19_1 3.48138473122105
R18476 n_21_19_1 n_21_20_1 5844.8405182777815
R18477 n_21_19_1 n_21_19_2 652.7596371039283
R18478 n_21_19_2 n_22_19_2 6.216758448609019
R18479 n_21_19_2 n_21_20_2 10437.215211210323
R18480 n_21_19_2 n_21_19_3 610.9830203292769
R18481 n_21_19_3 n_22_19_3 87.03461828052617
R18482 n_21_19_3 n_21_20_3 146121.01295694438
R18483 n_21_19_3 n_21_19_4 8.12323103951556
R18484 n_21_19_4 n_22_19_4 2.6374126751674596
R18485 n_21_19_4 n_21_20_4 4427.90948354377
R18486 n_21_19_15 n_22_19_15 174.06923656105081
R18487 n_21_19_15 n_21_20_15 292242.0259138862
R18488 n_21_20_0 n_22_20_0 142.85711674591005
R18489 n_21_20_0 n_21_21_0 142.85716896838048
R18490 n_21_20_0 n_21_20_1 16499.996984152138
R18491 n_21_20_1 n_22_20_1 199.99996344427402
R18492 n_21_20_1 n_21_21_1 200.00003655573266
R18493 n_21_20_1 n_21_20_2 37499.99314580031
R18494 n_21_20_2 n_22_20_2 357.1427918647751
R18495 n_21_20_2 n_21_21_2 357.1429224209512
R18496 n_21_20_2 n_21_20_3 35099.99358446909
R18497 n_21_20_3 n_22_20_3 4999.999086106846
R18498 n_21_20_3 n_21_21_3 5000.000913893312
R18499 n_21_20_3 n_21_20_4 466.66658136996
R18500 n_21_20_4 n_22_20_4 151.51512382141962
R18501 n_21_20_4 n_21_21_4 151.51517920888827
R18502 n_21_20_15 n_22_20_15 9999.998172213604
R18503 n_21_20_15 n_21_21_15 10000.001827786537
R18504 n_21_21_0 n_22_21_0 142.85711674591005
R18505 n_21_21_0 n_21_22_0 142.8571689683754
R18506 n_21_21_0 n_21_21_1 16499.996984152138
R18507 n_21_21_1 n_22_21_1 199.99996344427402
R18508 n_21_21_1 n_21_22_1 200.00003655572556
R18509 n_21_21_1 n_21_21_2 37499.99314580031
R18510 n_21_21_2 n_22_21_2 357.1427918647751
R18511 n_21_21_2 n_21_22_2 357.14292242093853
R18512 n_21_21_2 n_21_21_3 35099.99358446909
R18513 n_21_21_3 n_22_21_3 4999.999086106846
R18514 n_21_21_3 n_21_22_3 5000.000913893135
R18515 n_21_21_3 n_21_21_4 466.66658136996
R18516 n_21_21_4 n_22_21_4 151.51512382141962
R18517 n_21_21_4 n_21_22_4 151.5151792088829
R18518 n_21_21_15 n_22_21_15 9999.998172213604
R18519 n_21_21_15 n_21_22_15 10000.001827786182
R18520 n_21_22_0 n_22_22_0 142.85711674592017
R18521 n_21_22_0 n_21_23_0 142.8571689683754
R18522 n_21_22_0 n_21_22_1 16499.99698415331
R18523 n_21_22_1 n_22_22_1 199.99996344428826
R18524 n_21_22_1 n_21_23_1 200.00003655572556
R18525 n_21_22_1 n_21_22_2 37499.99314580298
R18526 n_21_22_2 n_22_22_2 357.1427918648005
R18527 n_21_22_2 n_21_23_2 357.14292242093853
R18528 n_21_22_2 n_21_22_3 35099.99358447159
R18529 n_21_22_3 n_22_22_3 4999.999086107202
R18530 n_21_22_3 n_21_23_3 5000.000913893135
R18531 n_21_22_3 n_21_22_4 466.66658136999297
R18532 n_21_22_4 n_22_22_4 151.51512382143036
R18533 n_21_22_4 n_21_23_4 151.5151792088829
R18534 n_21_22_15 n_22_22_15 9999.998172214315
R18535 n_21_22_15 n_21_23_15 10000.001827786182
R18536 n_21_23_0 n_22_23_0 142.85711674591005
R18537 n_21_23_0 n_21_24_0 1646.678571428551
R18538 n_21_23_0 n_21_23_1 16499.996984152138
R18539 n_21_23_1 n_22_23_1 199.99996344427402
R18540 n_21_23_1 n_21_24_1 2305.3499999999717
R18541 n_21_23_1 n_21_23_2 37499.99314580031
R18542 n_21_23_2 n_22_23_2 357.1427918647751
R18543 n_21_23_2 n_21_24_2 4116.696428571378
R18544 n_21_23_2 n_21_23_3 35099.99358446909
R18545 n_21_23_3 n_22_23_3 4999.999086106846
R18546 n_21_23_3 n_21_24_3 57633.749999999236
R18547 n_21_23_3 n_21_23_4 466.66658136996
R18548 n_21_23_4 n_22_23_4 151.51512382141962
R18549 n_21_23_4 n_21_24_4 1746.4772727272498
R18550 n_21_23_15 n_22_23_15 9999.998172213604
R18551 n_21_23_15 n_21_24_15 115267.49999999745
R18552 n_21_24_0 n_22_24_0 6.477753827788782
R18553 n_21_24_0 n_21_25_0 3150.499973888717
R18554 n_21_24_0 n_21_24_1 748.1805671095831
R18555 n_21_24_1 n_22_24_1 9.068855358904296
R18556 n_21_24_1 n_21_25_1 4410.699963444204
R18557 n_21_24_1 n_21_24_2 1700.410379794507
R18558 n_21_24_2 n_22_24_2 16.194384569471957
R18559 n_21_24_2 n_21_25_2 7876.249934721793
R18560 n_21_24_2 n_21_24_3 1591.5841154876584
R18561 n_21_24_3 n_22_24_3 226.72138397260719
R18562 n_21_24_3 n_21_25_3 110267.49908610499
R18563 n_21_24_3 n_21_24_4 21.16066250410944
R18564 n_21_24_4 n_22_24_4 6.870344968866884
R18565 n_21_24_4 n_21_25_4 3341.439366245606
R18566 n_21_24_4 n_21_24_5 17.48993533502923
R18567 n_21_24_5 n_22_24_5 43.18502551859185
R18568 n_21_24_5 n_21_25_5 21003.33315925809
R18569 n_21_24_5 n_21_24_6 6.045903572602696
R18570 n_21_24_6 n_22_24_6 7.19750425309864
R18571 n_21_24_6 n_21_25_6 3500.5555265430157
R18572 n_21_24_6 n_21_24_7 8.20515484853222
R18573 n_21_24_7 n_22_24_7 12.338578719597708
R18574 n_21_24_7 n_21_25_7 6000.952331216617
R18575 n_21_24_7 n_21_24_8 6.045903572602677
R18576 n_21_24_8 n_22_24_8 12.338578719597708
R18577 n_21_24_8 n_21_25_8 6000.952331216617
R18578 n_21_24_8 n_21_24_9 6.045903572602677
R18579 n_21_24_9 n_22_24_9 12.338578719597708
R18580 n_21_24_9 n_21_25_9 6000.952331216617
R18581 n_21_24_9 n_21_24_10 6.045903572602677
R18582 n_21_24_10 n_22_24_10 12.338578719597708
R18583 n_21_24_10 n_21_25_10 6000.952331216617
R18584 n_21_24_10 n_21_24_11 6.045903572602638
R18585 n_21_24_11 n_22_24_11 12.338578719597864
R18586 n_21_24_11 n_21_25_11 6000.952331216693
R18587 n_21_24_11 n_21_24_12 6.045903572602619
R18588 n_21_24_12 n_22_24_12 12.338578719597788
R18589 n_21_24_12 n_21_25_12 6000.952331216655
R18590 n_21_24_12 n_21_24_13 6.045903572602677
R18591 n_21_24_13 n_22_24_13 12.33857871959763
R18592 n_21_24_13 n_21_25_13 6000.952331216578
R18593 n_21_24_13 n_21_24_14 30.229517863013463
R18594 n_21_24_14 n_22_24_14 1.370953191066409
R18595 n_21_24_14 n_21_25_14 666.7724812462893
R18596 n_21_24_14 n_21_24_15 934.0921019671247
R18597 n_21_24_15 n_22_24_15 453.4427679452103
R18598 n_21_24_15 n_21_25_15 220534.99817220803
R18599 n_21_25_0 n_22_25_0 6.477753827788804
R18600 n_21_25_0 n_21_26_0 3150.499973888717
R18601 n_21_25_0 n_21_25_1 748.1805671095855
R18602 n_21_25_1 n_22_25_1 9.068855358904324
R18603 n_21_25_1 n_21_26_1 4410.699963444204
R18604 n_21_25_1 n_21_25_2 1700.4103797945122
R18605 n_21_25_2 n_22_25_2 16.19438456947201
R18606 n_21_25_2 n_21_26_2 7876.249934721793
R18607 n_21_25_2 n_21_25_3 1591.5841154876634
R18608 n_21_25_3 n_22_25_3 226.72138397260792
R18609 n_21_25_3 n_21_26_3 110267.49908610499
R18610 n_21_25_3 n_21_25_4 21.160662504109506
R18611 n_21_25_4 n_22_25_4 6.870344968866907
R18612 n_21_25_4 n_21_26_4 3341.439366245606
R18613 n_21_25_4 n_21_25_5 17.489935335029287
R18614 n_21_25_5 n_22_25_5 43.185025518591985
R18615 n_21_25_5 n_21_26_5 21003.33315925809
R18616 n_21_25_5 n_21_25_6 6.0459035726027155
R18617 n_21_25_6 n_22_25_6 7.197504253098664
R18618 n_21_25_6 n_21_26_6 3500.5555265430157
R18619 n_21_25_6 n_21_25_7 8.205154848532247
R18620 n_21_25_7 n_22_25_7 12.338578719597749
R18621 n_21_25_7 n_21_26_7 6000.952331216617
R18622 n_21_25_7 n_21_25_8 6.045903572602697
R18623 n_21_25_8 n_22_25_8 12.338578719597749
R18624 n_21_25_8 n_21_26_8 6000.952331216617
R18625 n_21_25_8 n_21_25_9 6.045903572602697
R18626 n_21_25_9 n_22_25_9 12.338578719597749
R18627 n_21_25_9 n_21_26_9 6000.952331216617
R18628 n_21_25_9 n_21_25_10 6.045903572602697
R18629 n_21_25_10 n_22_25_10 12.338578719597749
R18630 n_21_25_10 n_21_26_10 6000.952331216617
R18631 n_21_25_10 n_21_25_11 6.045903572602658
R18632 n_21_25_11 n_22_25_11 12.338578719597907
R18633 n_21_25_11 n_21_26_11 6000.952331216693
R18634 n_21_25_11 n_21_25_12 6.045903572602638
R18635 n_21_25_12 n_22_25_12 12.338578719597823
R18636 n_21_25_12 n_21_26_12 6000.952331216655
R18637 n_21_25_12 n_21_25_13 6.045903572602697
R18638 n_21_25_13 n_22_25_13 12.338578719597672
R18639 n_21_25_13 n_21_26_13 6000.952331216578
R18640 n_21_25_13 n_21_25_14 30.22951786301356
R18641 n_21_25_14 n_22_25_14 1.3709531910664134
R18642 n_21_25_14 n_21_26_14 666.7724812462893
R18643 n_21_25_14 n_21_25_15 934.0921019671276
R18644 n_21_25_15 n_22_25_15 453.44276794521176
R18645 n_21_25_15 n_21_26_15 220534.99817220803
R18646 n_21_26_0 n_22_26_0 6.477753827788782
R18647 n_21_26_0 n_21_27_0 3150.499973888722
R18648 n_21_26_0 n_21_26_1 748.1805671095831
R18649 n_21_26_1 n_22_26_1 9.068855358904296
R18650 n_21_26_1 n_21_27_1 4410.699963444211
R18651 n_21_26_1 n_21_26_2 1700.410379794507
R18652 n_21_26_2 n_22_26_2 16.194384569471957
R18653 n_21_26_2 n_21_27_2 7876.249934721805
R18654 n_21_26_2 n_21_26_3 1591.5841154876584
R18655 n_21_26_3 n_22_26_3 226.72138397260719
R18656 n_21_26_3 n_21_27_3 110267.49908610516
R18657 n_21_26_3 n_21_26_4 21.16066250410944
R18658 n_21_26_4 n_22_26_4 6.870344968866884
R18659 n_21_26_4 n_21_27_4 3341.4393662456114
R18660 n_21_26_4 n_21_26_5 17.48993533502923
R18661 n_21_26_5 n_22_26_5 43.18502551859185
R18662 n_21_26_5 n_21_27_5 21003.333159258123
R18663 n_21_26_5 n_21_26_6 6.045903572602696
R18664 n_21_26_6 n_22_26_6 7.19750425309864
R18665 n_21_26_6 n_21_27_6 3500.555526543021
R18666 n_21_26_6 n_21_26_7 8.20515484853222
R18667 n_21_26_7 n_22_26_7 12.338578719597708
R18668 n_21_26_7 n_21_27_7 6000.952331216627
R18669 n_21_26_7 n_21_26_8 6.045903572602677
R18670 n_21_26_8 n_22_26_8 12.338578719597708
R18671 n_21_26_8 n_21_27_8 6000.952331216627
R18672 n_21_26_8 n_21_26_9 6.045903572602677
R18673 n_21_26_9 n_22_26_9 12.338578719597708
R18674 n_21_26_9 n_21_27_9 6000.952331216627
R18675 n_21_26_9 n_21_26_10 6.045903572602677
R18676 n_21_26_10 n_22_26_10 12.338578719597708
R18677 n_21_26_10 n_21_27_10 6000.952331216627
R18678 n_21_26_10 n_21_26_11 6.045903572602638
R18679 n_21_26_11 n_22_26_11 12.338578719597864
R18680 n_21_26_11 n_21_27_11 6000.952331216702
R18681 n_21_26_11 n_21_26_12 6.045903572602619
R18682 n_21_26_12 n_22_26_12 12.338578719597788
R18683 n_21_26_12 n_21_27_12 6000.952331216665
R18684 n_21_26_12 n_21_26_13 6.045903572602677
R18685 n_21_26_13 n_22_26_13 12.33857871959763
R18686 n_21_26_13 n_21_27_13 6000.952331216588
R18687 n_21_26_13 n_21_26_14 30.229517863013463
R18688 n_21_26_14 n_22_26_14 1.370953191066409
R18689 n_21_26_14 n_21_27_14 666.7724812462903
R18690 n_21_26_14 n_21_26_15 934.0921019671247
R18691 n_21_26_15 n_22_26_15 453.4427679452103
R18692 n_21_26_15 n_21_27_15 220534.99817220838
R18693 n_21_27_0 n_22_27_0 6.477753827788782
R18694 n_21_27_0 n_21_27_1 748.1805671095831
R18695 n_21_27_1 n_22_27_1 9.068855358904296
R18696 n_21_27_1 n_21_27_2 1700.410379794507
R18697 n_21_27_2 n_22_27_2 16.194384569471957
R18698 n_21_27_2 n_21_27_3 1591.5841154876584
R18699 n_21_27_3 n_22_27_3 226.72138397260719
R18700 n_21_27_3 n_21_27_4 21.16066250410944
R18701 n_21_27_4 n_22_27_4 6.870344968866884
R18702 n_21_27_4 n_21_27_5 17.48993533502923
R18703 n_21_27_5 n_22_27_5 43.18502551859185
R18704 n_21_27_5 n_21_27_6 6.045903572602696
R18705 n_21_27_6 n_22_27_6 7.19750425309864
R18706 n_21_27_6 n_21_27_7 8.20515484853222
R18707 n_21_27_7 n_22_27_7 12.338578719597708
R18708 n_21_27_7 n_21_27_8 6.045903572602677
R18709 n_21_27_8 n_22_27_8 12.338578719597708
R18710 n_21_27_8 n_21_27_9 6.045903572602677
R18711 n_21_27_9 n_22_27_9 12.338578719597708
R18712 n_21_27_9 n_21_27_10 6.045903572602677
R18713 n_21_27_10 n_22_27_10 12.338578719597708
R18714 n_21_27_10 n_21_27_11 6.045903572602638
R18715 n_21_27_11 n_22_27_11 12.338578719597864
R18716 n_21_27_11 n_21_27_12 6.045903572602619
R18717 n_21_27_12 n_22_27_12 12.338578719597788
R18718 n_21_27_12 n_21_27_13 6.045903572602677
R18719 n_21_27_13 n_22_27_13 12.33857871959763
R18720 n_21_27_13 n_21_27_14 30.229517863013463
R18721 n_21_27_14 n_22_27_14 1.370953191066409
R18722 n_21_27_14 n_21_27_15 934.0921019671247
R18723 n_21_27_15 n_22_27_15 453.4427679452103
R18724 n_22_0_0 n_23_0_0 6.4777532699256675
R18725 n_22_0_0 n_22_1_0 3150.5002452092954
R18726 n_22_0_0 n_22_0_1 748.1805026763932
R18727 n_22_0_1 n_23_0_1 9.068854577895932
R18728 n_22_0_1 n_22_1_1 4410.700343293014
R18729 n_22_0_1 n_22_0_2 1700.4102333554388
R18730 n_22_0_2 n_23_0_2 16.194383174814167
R18731 n_22_0_2 n_22_1_2 7876.25061302324
R18732 n_22_0_2 n_22_0_3 1591.5839784206908
R18733 n_22_0_3 n_23_0_3 226.7213644473981
R18734 n_22_0_3 n_22_1_3 110267.50858232524
R18735 n_22_0_3 n_22_0_4 21.160660681756593
R18736 n_22_0_4 n_23_0_4 6.870344377193882
R18737 n_22_0_4 n_22_1_4 3341.4396540098564
R18738 n_22_0_4 n_22_0_5 17.489933828798815
R18739 n_22_0_5 n_23_0_5 43.1850217995044
R18740 n_22_0_5 n_22_1_5 21003.33496806195
R18741 n_22_0_5 n_22_0_6 6.045903051930455
R18742 n_22_0_6 n_23_0_6 7.197503633250734
R18743 n_22_0_6 n_22_1_6 3500.5558280103255
R18744 n_22_0_6 n_22_0_7 8.205154141905608
R18745 n_22_0_7 n_23_0_7 12.338577657001295
R18746 n_22_0_7 n_22_1_7 6000.95284801772
R18747 n_22_0_7 n_22_0_8 6.045903051930436
R18748 n_22_0_8 n_23_0_8 12.338577657001295
R18749 n_22_0_8 n_22_1_8 6000.95284801772
R18750 n_22_0_8 n_22_0_9 6.045903051930436
R18751 n_22_0_9 n_23_0_9 12.338577657001295
R18752 n_22_0_9 n_22_1_9 6000.95284801772
R18753 n_22_0_9 n_22_0_10 6.045903051930436
R18754 n_22_0_10 n_23_0_10 12.338577657001295
R18755 n_22_0_10 n_22_1_10 6000.95284801772
R18756 n_22_0_10 n_22_0_11 6.045903051930397
R18757 n_22_0_11 n_23_0_11 12.338577657001453
R18758 n_22_0_11 n_22_1_11 6000.952848017796
R18759 n_22_0_11 n_22_0_12 6.045903051930377
R18760 n_22_0_12 n_23_0_12 12.338577657001379
R18761 n_22_0_12 n_22_1_12 6000.952848017758
R18762 n_22_0_12 n_22_0_13 6.045903051930436
R18763 n_22_0_13 n_23_0_13 12.338577657001219
R18764 n_22_0_13 n_22_1_13 6000.952848017681
R18765 n_22_0_13 n_22_0_14 30.229515259652253
R18766 n_22_0_14 n_23_0_14 1.3709530730001411
R18767 n_22_0_14 n_22_1_14 666.7725386686341
R18768 n_22_0_14 n_22_0_15 934.0920215232634
R18769 n_22_0_15 n_23_0_15 453.4427288947922
R18770 n_22_0_15 n_22_1_15 220535.01716464857
R18771 n_22_1_0 n_23_1_0 6.4777532699256675
R18772 n_22_1_0 n_22_2_0 3150.5002452092954
R18773 n_22_1_0 n_22_1_1 748.1805026763932
R18774 n_22_1_1 n_23_1_1 9.068854577895932
R18775 n_22_1_1 n_22_2_1 4410.700343293014
R18776 n_22_1_1 n_22_1_2 1700.4102333554388
R18777 n_22_1_2 n_23_1_2 16.194383174814167
R18778 n_22_1_2 n_22_2_2 7876.25061302324
R18779 n_22_1_2 n_22_1_3 1591.5839784206908
R18780 n_22_1_3 n_23_1_3 226.7213644473981
R18781 n_22_1_3 n_22_2_3 110267.50858232524
R18782 n_22_1_3 n_22_1_4 21.160660681756593
R18783 n_22_1_4 n_23_1_4 6.870344377193882
R18784 n_22_1_4 n_22_2_4 3341.4396540098564
R18785 n_22_1_4 n_22_1_5 17.489933828798815
R18786 n_22_1_5 n_23_1_5 43.1850217995044
R18787 n_22_1_5 n_22_2_5 21003.33496806195
R18788 n_22_1_5 n_22_1_6 6.045903051930455
R18789 n_22_1_6 n_23_1_6 7.197503633250734
R18790 n_22_1_6 n_22_2_6 3500.5558280103255
R18791 n_22_1_6 n_22_1_7 8.205154141905608
R18792 n_22_1_7 n_23_1_7 12.338577657001295
R18793 n_22_1_7 n_22_2_7 6000.95284801772
R18794 n_22_1_7 n_22_1_8 6.045903051930436
R18795 n_22_1_8 n_23_1_8 12.338577657001295
R18796 n_22_1_8 n_22_2_8 6000.95284801772
R18797 n_22_1_8 n_22_1_9 6.045903051930436
R18798 n_22_1_9 n_23_1_9 12.338577657001295
R18799 n_22_1_9 n_22_2_9 6000.95284801772
R18800 n_22_1_9 n_22_1_10 6.045903051930436
R18801 n_22_1_10 n_23_1_10 12.338577657001295
R18802 n_22_1_10 n_22_2_10 6000.95284801772
R18803 n_22_1_10 n_22_1_11 6.045903051930397
R18804 n_22_1_11 n_23_1_11 12.338577657001453
R18805 n_22_1_11 n_22_2_11 6000.952848017796
R18806 n_22_1_11 n_22_1_12 6.045903051930377
R18807 n_22_1_12 n_23_1_12 12.338577657001379
R18808 n_22_1_12 n_22_2_12 6000.952848017758
R18809 n_22_1_12 n_22_1_13 6.045903051930436
R18810 n_22_1_13 n_23_1_13 12.338577657001219
R18811 n_22_1_13 n_22_2_13 6000.952848017681
R18812 n_22_1_13 n_22_1_14 30.229515259652253
R18813 n_22_1_14 n_23_1_14 1.3709530730001411
R18814 n_22_1_14 n_22_2_14 666.7725386686341
R18815 n_22_1_14 n_22_1_15 934.0920215232634
R18816 n_22_1_15 n_23_1_15 453.4427288947922
R18817 n_22_1_15 n_22_2_15 220535.01716464857
R18818 n_22_2_0 n_23_2_0 6.4777532699256675
R18819 n_22_2_0 n_22_3_0 3150.5002452092954
R18820 n_22_2_0 n_22_2_1 748.1805026763932
R18821 n_22_2_1 n_23_2_1 9.068854577895932
R18822 n_22_2_1 n_22_3_1 4410.700343293014
R18823 n_22_2_1 n_22_2_2 1700.4102333554388
R18824 n_22_2_2 n_23_2_2 16.194383174814167
R18825 n_22_2_2 n_22_3_2 7876.25061302324
R18826 n_22_2_2 n_22_2_3 1591.5839784206908
R18827 n_22_2_3 n_23_2_3 226.7213644473981
R18828 n_22_2_3 n_22_3_3 110267.50858232524
R18829 n_22_2_3 n_22_2_4 21.160660681756593
R18830 n_22_2_4 n_23_2_4 6.870344377193882
R18831 n_22_2_4 n_22_3_4 3341.4396540098564
R18832 n_22_2_4 n_22_2_5 17.489933828798815
R18833 n_22_2_5 n_23_2_5 43.1850217995044
R18834 n_22_2_5 n_22_3_5 21003.33496806195
R18835 n_22_2_5 n_22_2_6 6.045903051930455
R18836 n_22_2_6 n_23_2_6 7.197503633250734
R18837 n_22_2_6 n_22_3_6 3500.5558280103255
R18838 n_22_2_6 n_22_2_7 8.205154141905608
R18839 n_22_2_7 n_23_2_7 12.338577657001295
R18840 n_22_2_7 n_22_3_7 6000.95284801772
R18841 n_22_2_7 n_22_2_8 6.045903051930436
R18842 n_22_2_8 n_23_2_8 12.338577657001295
R18843 n_22_2_8 n_22_3_8 6000.95284801772
R18844 n_22_2_8 n_22_2_9 6.045903051930436
R18845 n_22_2_9 n_23_2_9 12.338577657001295
R18846 n_22_2_9 n_22_3_9 6000.95284801772
R18847 n_22_2_9 n_22_2_10 6.045903051930436
R18848 n_22_2_10 n_23_2_10 12.338577657001295
R18849 n_22_2_10 n_22_3_10 6000.95284801772
R18850 n_22_2_10 n_22_2_11 6.045903051930397
R18851 n_22_2_11 n_23_2_11 12.338577657001453
R18852 n_22_2_11 n_22_3_11 6000.952848017796
R18853 n_22_2_11 n_22_2_12 6.045903051930377
R18854 n_22_2_12 n_23_2_12 12.338577657001379
R18855 n_22_2_12 n_22_3_12 6000.952848017758
R18856 n_22_2_12 n_22_2_13 6.045903051930436
R18857 n_22_2_13 n_23_2_13 12.338577657001219
R18858 n_22_2_13 n_22_3_13 6000.952848017681
R18859 n_22_2_13 n_22_2_14 30.229515259652253
R18860 n_22_2_14 n_23_2_14 1.3709530730001411
R18861 n_22_2_14 n_22_3_14 666.7725386686341
R18862 n_22_2_14 n_22_2_15 934.0920215232634
R18863 n_22_2_15 n_23_2_15 453.4427288947922
R18864 n_22_2_15 n_22_3_15 220535.01716464857
R18865 n_22_3_0 n_23_3_0 6.4777532699256675
R18866 n_22_3_0 n_22_4_0 1646.6785714285472
R18867 n_22_3_0 n_22_3_1 748.1805026763932
R18868 n_22_3_1 n_23_3_1 9.068854577895932
R18869 n_22_3_1 n_22_4_1 2305.3499999999667
R18870 n_22_3_1 n_22_3_2 1700.4102333554388
R18871 n_22_3_2 n_23_3_2 16.194383174814167
R18872 n_22_3_2 n_22_4_2 4116.696428571369
R18873 n_22_3_2 n_22_3_3 1591.5839784206908
R18874 n_22_3_3 n_23_3_3 226.7213644473981
R18875 n_22_3_3 n_22_4_3 57633.749999999105
R18876 n_22_3_3 n_22_3_4 21.160660681756593
R18877 n_22_3_4 n_23_3_4 6.870344377193882
R18878 n_22_3_4 n_22_4_4 1746.477272727246
R18879 n_22_3_4 n_22_3_5 17.489933828798815
R18880 n_22_3_5 n_23_3_5 43.1850217995044
R18881 n_22_3_5 n_22_3_6 6.045903051930455
R18882 n_22_3_6 n_23_3_6 7.197503633250734
R18883 n_22_3_6 n_22_3_7 8.205154141905608
R18884 n_22_3_7 n_23_3_7 12.338577657001295
R18885 n_22_3_7 n_22_3_8 6.045903051930436
R18886 n_22_3_8 n_23_3_8 12.338577657001295
R18887 n_22_3_8 n_22_3_9 6.045903051930436
R18888 n_22_3_9 n_23_3_9 12.338577657001295
R18889 n_22_3_9 n_22_3_10 6.045903051930436
R18890 n_22_3_10 n_23_3_10 12.338577657001295
R18891 n_22_3_10 n_22_3_11 6.045903051930397
R18892 n_22_3_11 n_23_3_11 12.338577657001453
R18893 n_22_3_11 n_22_3_12 6.045903051930377
R18894 n_22_3_12 n_23_3_12 12.338577657001379
R18895 n_22_3_12 n_22_3_13 6.045903051930436
R18896 n_22_3_13 n_23_3_13 12.338577657001219
R18897 n_22_3_13 n_22_3_14 30.229515259652253
R18898 n_22_3_14 n_23_3_14 1.3709530730001411
R18899 n_22_3_14 n_22_3_15 934.0920215232634
R18900 n_22_3_15 n_23_3_15 453.4427288947922
R18901 n_22_3_15 n_22_4_15 115267.4999999972
R18902 n_22_4_0 n_23_4_0 142.8573880669074
R18903 n_22_4_0 n_22_5_0 142.8568976478005
R18904 n_22_4_0 n_22_4_1 16500.028321727335
R18905 n_22_4_1 n_23_4_1 200.00034329367034
R18906 n_22_4_1 n_22_5_1 199.99965670692075
R18907 n_22_4_1 n_22_4_2 37500.064367562125
R18908 n_22_4_2 n_23_4_2 357.1434701672685
R18909 n_22_4_2 n_22_5_2 357.14224411950136
R18910 n_22_4_2 n_22_4_3 35100.06024803815
R18911 n_22_4_3 n_23_4_3 5000.008582341755
R18912 n_22_4_3 n_22_5_3 4999.9914176730135
R18913 n_22_4_3 n_22_4_4 466.66746768521796
R18914 n_22_4_4 n_23_4_4 151.51541158611377
R18915 n_22_4_4 n_22_5_4 151.5148914446368
R18916 n_22_4_15 n_23_4_15 10000.01716468342
R18917 n_22_4_15 n_22_5_15 9999.982835345938
R18918 n_22_5_0 n_23_5_0 142.8573880669049
R18919 n_22_5_0 n_22_6_0 142.8568976478018
R18920 n_22_5_0 n_22_5_1 16500.02832172704
R18921 n_22_5_1 n_23_5_1 200.0003432936668
R18922 n_22_5_1 n_22_6_1 199.9996567069225
R18923 n_22_5_1 n_22_5_2 37500.06436756146
R18924 n_22_5_2 n_23_5_2 357.14347016726214
R18925 n_22_5_2 n_22_6_2 357.1422441195045
R18926 n_22_5_2 n_22_5_3 35100.06024803753
R18927 n_22_5_3 n_23_5_3 5000.008582341666
R18928 n_22_5_3 n_22_6_3 4999.991417673058
R18929 n_22_5_3 n_22_5_4 466.66746768520966
R18930 n_22_5_4 n_23_5_4 151.51541158611107
R18931 n_22_5_4 n_22_6_4 151.51489144463812
R18932 n_22_5_15 n_23_5_15 10000.017164683242
R18933 n_22_5_15 n_22_6_15 9999.982835346027
R18934 n_22_6_0 n_23_6_0 142.8573880669049
R18935 n_22_6_0 n_22_7_0 142.8568976478005
R18936 n_22_6_0 n_22_6_1 16500.02832172704
R18937 n_22_6_1 n_23_6_1 200.0003432936668
R18938 n_22_6_1 n_22_7_1 199.99965670692075
R18939 n_22_6_1 n_22_6_2 37500.06436756146
R18940 n_22_6_2 n_23_6_2 357.14347016726214
R18941 n_22_6_2 n_22_7_2 357.14224411950136
R18942 n_22_6_2 n_22_6_3 35100.06024803753
R18943 n_22_6_3 n_23_6_3 5000.008582341666
R18944 n_22_6_3 n_22_7_3 4999.9914176730135
R18945 n_22_6_3 n_22_6_4 466.66746768520966
R18946 n_22_6_4 n_23_6_4 151.51541158611107
R18947 n_22_6_4 n_22_7_4 151.5148914446368
R18948 n_22_6_15 n_23_6_15 10000.017164683242
R18949 n_22_6_15 n_22_7_15 9999.982835345938
R18950 n_22_7_0 n_23_7_0 142.8573880669074
R18951 n_22_7_0 n_22_8_0 4174.885948823841
R18952 n_22_7_0 n_22_7_1 16500.028321727335
R18953 n_22_7_1 n_23_7_1 200.00034329367034
R18954 n_22_7_1 n_22_8_1 5844.840328353377
R18955 n_22_7_1 n_22_7_2 37500.064367562125
R18956 n_22_7_2 n_23_7_2 357.1434701672685
R18957 n_22_7_2 n_22_8_2 10437.214872059603
R18958 n_22_7_2 n_22_7_3 35100.06024803815
R18959 n_22_7_3 n_23_7_3 5000.008582341755
R18960 n_22_7_3 n_22_8_3 146121.00820883428
R18961 n_22_7_3 n_22_7_4 466.66746768521796
R18962 n_22_7_4 n_23_7_4 151.51541158611377
R18963 n_22_7_4 n_22_8_4 4427.909339661646
R18964 n_22_7_15 n_23_7_15 10000.01716468342
R18965 n_22_7_15 n_22_8_15 292242.01641766605
R18966 n_22_8_0 n_23_8_0 2.486703379443606
R18967 n_22_8_0 n_22_9_0 8206.914999999884
R18968 n_22_8_0 n_22_8_1 287.21424032572827
R18969 n_22_8_1 n_23_8_1 3.481384731221048
R18970 n_22_8_1 n_22_9_1 11489.680999999839
R18971 n_22_8_1 n_22_8_2 652.759637103928
R18972 n_22_8_2 n_23_8_2 6.216758448609014
R18973 n_22_8_2 n_22_9_2 20517.287499999715
R18974 n_22_8_2 n_22_8_3 610.9830203292765
R18975 n_22_8_3 n_23_8_3 87.03461828052613
R18976 n_22_8_3 n_22_9_3 287242.0249999957
R18977 n_22_8_3 n_22_8_4 8.123231039515554
R18978 n_22_8_4 n_23_8_4 2.6374126751674587
R18979 n_22_8_4 n_22_9_4 8704.30378787866
R18980 n_22_8_15 n_23_8_15 174.0692365610507
R18981 n_22_8_15 n_22_9_15 574484.0499999863
R18982 n_22_9_0 n_23_9_0 2.486703379443604
R18983 n_22_9_0 n_22_10_0 8206.914999999884
R18984 n_22_9_0 n_22_9_1 287.2142403257281
R18985 n_22_9_1 n_23_9_1 3.481384731221046
R18986 n_22_9_1 n_22_10_1 11489.680999999839
R18987 n_22_9_1 n_22_9_2 652.7596371039276
R18988 n_22_9_2 n_23_9_2 6.216758448609011
R18989 n_22_9_2 n_22_10_2 20517.287499999715
R18990 n_22_9_2 n_22_9_3 610.9830203292762
R18991 n_22_9_3 n_23_9_3 87.03461828052608
R18992 n_22_9_3 n_22_10_3 287242.0249999957
R18993 n_22_9_3 n_22_9_4 8.123231039515549
R18994 n_22_9_4 n_23_9_4 2.637412675167457
R18995 n_22_9_4 n_22_10_4 8704.30378787866
R18996 n_22_9_15 n_23_9_15 174.06923656105062
R18997 n_22_9_15 n_22_10_15 574484.0499999863
R18998 n_22_10_0 n_23_10_0 2.486703379443606
R18999 n_22_10_0 n_22_11_0 8206.914999999883
R19000 n_22_10_0 n_22_10_1 287.21424032572827
R19001 n_22_10_1 n_23_10_1 3.481384731221048
R19002 n_22_10_1 n_22_11_1 11489.680999999835
R19003 n_22_10_1 n_22_10_2 652.759637103928
R19004 n_22_10_2 n_23_10_2 6.216758448609014
R19005 n_22_10_2 n_22_11_2 20517.287499999708
R19006 n_22_10_2 n_22_10_3 610.9830203292765
R19007 n_22_10_3 n_23_10_3 87.03461828052613
R19008 n_22_10_3 n_22_11_3 287242.0249999956
R19009 n_22_10_3 n_22_10_4 8.123231039515554
R19010 n_22_10_4 n_23_10_4 2.6374126751674587
R19011 n_22_10_4 n_22_11_4 8704.303787878656
R19012 n_22_10_15 n_23_10_15 174.0692365610507
R19013 n_22_10_15 n_22_11_15 574484.0499999862
R19014 n_22_11_0 n_23_11_0 2.486703379443606
R19015 n_22_11_0 n_22_12_0 4174.886071428513
R19016 n_22_11_0 n_22_11_1 287.21424032572827
R19017 n_22_11_1 n_23_11_1 3.481384731221048
R19018 n_22_11_1 n_22_12_1 5844.8404999999175
R19019 n_22_11_1 n_22_11_2 652.759637103928
R19020 n_22_11_2 n_23_11_2 6.216758448609014
R19021 n_22_11_2 n_22_12_2 10437.215178571283
R19022 n_22_11_2 n_22_11_3 610.9830203292765
R19023 n_22_11_3 n_23_11_3 87.03461828052613
R19024 n_22_11_3 n_22_12_3 146121.0124999978
R19025 n_22_11_3 n_22_11_4 8.123231039515554
R19026 n_22_11_4 n_23_11_4 2.6374126751674587
R19027 n_22_11_4 n_22_12_4 4427.909469696904
R19028 n_22_11_15 n_23_11_15 174.0692365610507
R19029 n_22_11_15 n_22_12_15 292242.02499999304
R19030 n_22_12_0 n_23_12_0 142.85714285714286
R19031 n_22_12_0 n_22_13_0 142.85714285714286
R19032 n_22_12_0 n_22_12_1 16499.99999999953
R19033 n_22_12_1 n_23_12_1 200.00000000000003
R19034 n_22_12_1 n_22_13_1 200.00000000000003
R19035 n_22_12_1 n_22_12_2 37499.99999999893
R19036 n_22_12_2 n_23_12_2 357.1428571428572
R19037 n_22_12_2 n_22_13_2 357.1428571428572
R19038 n_22_12_2 n_22_12_3 35099.999999999
R19039 n_22_12_3 n_23_12_3 4999.999999999996
R19040 n_22_12_3 n_22_13_3 4999.999999999996
R19041 n_22_12_3 n_22_12_4 466.66666666665384
R19042 n_22_12_4 n_23_12_4 151.51515151515142
R19043 n_22_12_4 n_22_13_4 151.51515151515142
R19044 n_22_12_15 n_23_12_15 9999.999999999904
R19045 n_22_12_15 n_22_13_15 9999.999999999904
R19046 n_22_13_0 n_23_13_0 142.85714285714286
R19047 n_22_13_0 n_22_14_0 142.85714285714286
R19048 n_22_13_0 n_22_13_1 16499.99999999953
R19049 n_22_13_1 n_23_13_1 200.00000000000003
R19050 n_22_13_1 n_22_14_1 200.00000000000003
R19051 n_22_13_1 n_22_13_2 37499.99999999893
R19052 n_22_13_2 n_23_13_2 357.1428571428572
R19053 n_22_13_2 n_22_14_2 357.1428571428572
R19054 n_22_13_2 n_22_13_3 35099.999999999
R19055 n_22_13_3 n_23_13_3 4999.999999999996
R19056 n_22_13_3 n_22_14_3 4999.999999999996
R19057 n_22_13_3 n_22_13_4 466.66666666665384
R19058 n_22_13_4 n_23_13_4 151.51515151515142
R19059 n_22_13_4 n_22_14_4 151.51515151515142
R19060 n_22_13_15 n_23_13_15 9999.999999999904
R19061 n_22_13_15 n_22_14_15 9999.999999999904
R19062 n_22_14_0 n_23_14_0 142.85714285714286
R19063 n_22_14_0 n_22_15_0 142.85714285714286
R19064 n_22_14_0 n_22_14_1 16499.99999999953
R19065 n_22_14_1 n_23_14_1 200.00000000000003
R19066 n_22_14_1 n_22_15_1 200.00000000000003
R19067 n_22_14_1 n_22_14_2 37499.99999999893
R19068 n_22_14_2 n_23_14_2 357.1428571428572
R19069 n_22_14_2 n_22_15_2 357.1428571428572
R19070 n_22_14_2 n_22_14_3 35099.999999999
R19071 n_22_14_3 n_23_14_3 4999.999999999996
R19072 n_22_14_3 n_22_15_3 4999.999999999996
R19073 n_22_14_3 n_22_14_4 466.66666666665384
R19074 n_22_14_4 n_23_14_4 151.51515151515142
R19075 n_22_14_4 n_22_15_4 151.51515151515142
R19076 n_22_14_15 n_23_14_15 9999.999999999904
R19077 n_22_14_15 n_22_15_15 9999.999999999904
R19078 n_22_15_0 n_23_15_0 142.85714285714286
R19079 n_22_15_0 n_22_16_0 4174.88607142851
R19080 n_22_15_0 n_22_15_1 16499.99999999953
R19081 n_22_15_1 n_23_15_1 200.00000000000003
R19082 n_22_15_1 n_22_16_1 5844.840499999915
R19083 n_22_15_1 n_22_15_2 37499.99999999893
R19084 n_22_15_2 n_23_15_2 357.1428571428572
R19085 n_22_15_2 n_22_16_2 10437.215178571278
R19086 n_22_15_2 n_22_15_3 35099.999999999
R19087 n_22_15_3 n_23_15_3 4999.999999999996
R19088 n_22_15_3 n_22_16_3 146121.0124999977
R19089 n_22_15_3 n_22_15_4 466.66666666665384
R19090 n_22_15_4 n_23_15_4 151.51515151515142
R19091 n_22_15_4 n_22_16_4 4427.909469696901
R19092 n_22_15_15 n_23_15_15 9999.999999999904
R19093 n_22_15_15 n_22_16_15 292242.02499999286
R19094 n_22_16_0 n_23_16_0 2.486703379443608
R19095 n_22_16_0 n_22_17_0 8206.914999999883
R19096 n_22_16_0 n_22_16_1 287.21424032572844
R19097 n_22_16_1 n_23_16_1 3.48138473122105
R19098 n_22_16_1 n_22_17_1 11489.680999999837
R19099 n_22_16_1 n_22_16_2 652.7596371039283
R19100 n_22_16_2 n_23_16_2 6.216758448609019
R19101 n_22_16_2 n_22_17_2 20517.287499999708
R19102 n_22_16_2 n_22_16_3 610.9830203292769
R19103 n_22_16_3 n_23_16_3 87.03461828052617
R19104 n_22_16_3 n_22_17_3 287242.0249999956
R19105 n_22_16_3 n_22_16_4 8.12323103951556
R19106 n_22_16_4 n_23_16_4 2.6374126751674596
R19107 n_22_16_4 n_22_17_4 8704.303787878656
R19108 n_22_16_15 n_23_16_15 174.06923656105081
R19109 n_22_16_15 n_22_17_15 574484.0499999862
R19110 n_22_17_0 n_23_17_0 2.486703379443604
R19111 n_22_17_0 n_22_18_0 8206.914999999888
R19112 n_22_17_0 n_22_17_1 287.2142403257281
R19113 n_22_17_1 n_23_17_1 3.481384731221046
R19114 n_22_17_1 n_22_18_1 11489.680999999842
R19115 n_22_17_1 n_22_17_2 652.7596371039276
R19116 n_22_17_2 n_23_17_2 6.216758448609011
R19117 n_22_17_2 n_22_18_2 20517.287499999722
R19118 n_22_17_2 n_22_17_3 610.9830203292762
R19119 n_22_17_3 n_23_17_3 87.03461828052608
R19120 n_22_17_3 n_22_18_3 287242.0249999958
R19121 n_22_17_3 n_22_17_4 8.123231039515549
R19122 n_22_17_4 n_23_17_4 2.637412675167457
R19123 n_22_17_4 n_22_18_4 8704.303787878662
R19124 n_22_17_15 n_23_17_15 174.06923656105062
R19125 n_22_17_15 n_22_18_15 574484.0499999865
R19126 n_22_18_0 n_23_18_0 2.486703379443604
R19127 n_22_18_0 n_22_19_0 8206.914999999883
R19128 n_22_18_0 n_22_18_1 287.2142403257281
R19129 n_22_18_1 n_23_18_1 3.481384731221046
R19130 n_22_18_1 n_22_19_1 11489.680999999837
R19131 n_22_18_1 n_22_18_2 652.7596371039276
R19132 n_22_18_2 n_23_18_2 6.216758448609011
R19133 n_22_18_2 n_22_19_2 20517.287499999708
R19134 n_22_18_2 n_22_18_3 610.9830203292762
R19135 n_22_18_3 n_23_18_3 87.03461828052608
R19136 n_22_18_3 n_22_19_3 287242.0249999956
R19137 n_22_18_3 n_22_18_4 8.123231039515549
R19138 n_22_18_4 n_23_18_4 2.637412675167457
R19139 n_22_18_4 n_22_19_4 8704.303787878656
R19140 n_22_18_15 n_23_18_15 174.06923656105062
R19141 n_22_18_15 n_22_19_15 574484.0499999862
R19142 n_22_19_0 n_23_19_0 2.486703379443608
R19143 n_22_19_0 n_22_20_0 4174.886084484129
R19144 n_22_19_0 n_22_19_1 287.21424032572844
R19145 n_22_19_1 n_23_19_1 3.48138473122105
R19146 n_22_19_1 n_22_20_1 5844.8405182777815
R19147 n_22_19_1 n_22_19_2 652.7596371039283
R19148 n_22_19_2 n_23_19_2 6.216758448609019
R19149 n_22_19_2 n_22_20_2 10437.215211210323
R19150 n_22_19_2 n_22_19_3 610.9830203292769
R19151 n_22_19_3 n_23_19_3 87.03461828052617
R19152 n_22_19_3 n_22_20_3 146121.01295694438
R19153 n_22_19_3 n_22_19_4 8.12323103951556
R19154 n_22_19_4 n_23_19_4 2.6374126751674596
R19155 n_22_19_4 n_22_20_4 4427.90948354377
R19156 n_22_19_15 n_23_19_15 174.06923656105081
R19157 n_22_19_15 n_22_20_15 292242.0259138862
R19158 n_22_20_0 n_23_20_0 142.85711674591005
R19159 n_22_20_0 n_22_21_0 142.85716896838048
R19160 n_22_20_0 n_22_20_1 16499.996984152138
R19161 n_22_20_1 n_23_20_1 199.99996344427402
R19162 n_22_20_1 n_22_21_1 200.00003655573266
R19163 n_22_20_1 n_22_20_2 37499.99314580031
R19164 n_22_20_2 n_23_20_2 357.1427918647751
R19165 n_22_20_2 n_22_21_2 357.1429224209512
R19166 n_22_20_2 n_22_20_3 35099.99358446909
R19167 n_22_20_3 n_23_20_3 4999.999086106846
R19168 n_22_20_3 n_22_21_3 5000.000913893312
R19169 n_22_20_3 n_22_20_4 466.66658136996
R19170 n_22_20_4 n_23_20_4 151.51512382141962
R19171 n_22_20_4 n_22_21_4 151.51517920888827
R19172 n_22_20_15 n_23_20_15 9999.998172213604
R19173 n_22_20_15 n_22_21_15 10000.001827786537
R19174 n_22_21_0 n_23_21_0 142.85711674591005
R19175 n_22_21_0 n_22_22_0 142.8571689683754
R19176 n_22_21_0 n_22_21_1 16499.996984152138
R19177 n_22_21_1 n_23_21_1 199.99996344427402
R19178 n_22_21_1 n_22_22_1 200.00003655572556
R19179 n_22_21_1 n_22_21_2 37499.99314580031
R19180 n_22_21_2 n_23_21_2 357.1427918647751
R19181 n_22_21_2 n_22_22_2 357.14292242093853
R19182 n_22_21_2 n_22_21_3 35099.99358446909
R19183 n_22_21_3 n_23_21_3 4999.999086106846
R19184 n_22_21_3 n_22_22_3 5000.000913893135
R19185 n_22_21_3 n_22_21_4 466.66658136996
R19186 n_22_21_4 n_23_21_4 151.51512382141962
R19187 n_22_21_4 n_22_22_4 151.5151792088829
R19188 n_22_21_15 n_23_21_15 9999.998172213604
R19189 n_22_21_15 n_22_22_15 10000.001827786182
R19190 n_22_22_0 n_23_22_0 142.85711674592017
R19191 n_22_22_0 n_22_23_0 142.8571689683754
R19192 n_22_22_0 n_22_22_1 16499.99698415331
R19193 n_22_22_1 n_23_22_1 199.99996344428826
R19194 n_22_22_1 n_22_23_1 200.00003655572556
R19195 n_22_22_1 n_22_22_2 37499.99314580298
R19196 n_22_22_2 n_23_22_2 357.1427918648005
R19197 n_22_22_2 n_22_23_2 357.14292242093853
R19198 n_22_22_2 n_22_22_3 35099.99358447159
R19199 n_22_22_3 n_23_22_3 4999.999086107202
R19200 n_22_22_3 n_22_23_3 5000.000913893135
R19201 n_22_22_3 n_22_22_4 466.66658136999297
R19202 n_22_22_4 n_23_22_4 151.51512382143036
R19203 n_22_22_4 n_22_23_4 151.5151792088829
R19204 n_22_22_15 n_23_22_15 9999.998172214315
R19205 n_22_22_15 n_22_23_15 10000.001827786182
R19206 n_22_23_0 n_23_23_0 142.85711674591005
R19207 n_22_23_0 n_22_24_0 1646.678571428551
R19208 n_22_23_0 n_22_23_1 16499.996984152138
R19209 n_22_23_1 n_23_23_1 199.99996344427402
R19210 n_22_23_1 n_22_24_1 2305.3499999999717
R19211 n_22_23_1 n_22_23_2 37499.99314580031
R19212 n_22_23_2 n_23_23_2 357.1427918647751
R19213 n_22_23_2 n_22_24_2 4116.696428571378
R19214 n_22_23_2 n_22_23_3 35099.99358446909
R19215 n_22_23_3 n_23_23_3 4999.999086106846
R19216 n_22_23_3 n_22_24_3 57633.749999999236
R19217 n_22_23_3 n_22_23_4 466.66658136996
R19218 n_22_23_4 n_23_23_4 151.51512382141962
R19219 n_22_23_4 n_22_24_4 1746.4772727272498
R19220 n_22_23_15 n_23_23_15 9999.998172213604
R19221 n_22_23_15 n_22_24_15 115267.49999999745
R19222 n_22_24_0 n_23_24_0 6.477753827788782
R19223 n_22_24_0 n_22_25_0 3150.499973888717
R19224 n_22_24_0 n_22_24_1 748.1805671095831
R19225 n_22_24_1 n_23_24_1 9.068855358904296
R19226 n_22_24_1 n_22_25_1 4410.699963444204
R19227 n_22_24_1 n_22_24_2 1700.410379794507
R19228 n_22_24_2 n_23_24_2 16.194384569471957
R19229 n_22_24_2 n_22_25_2 7876.249934721793
R19230 n_22_24_2 n_22_24_3 1591.5841154876584
R19231 n_22_24_3 n_23_24_3 226.72138397260719
R19232 n_22_24_3 n_22_25_3 110267.49908610499
R19233 n_22_24_3 n_22_24_4 21.16066250410944
R19234 n_22_24_4 n_23_24_4 6.870344968866884
R19235 n_22_24_4 n_22_25_4 3341.439366245606
R19236 n_22_24_4 n_22_24_5 17.48993533502923
R19237 n_22_24_5 n_23_24_5 43.18502551859185
R19238 n_22_24_5 n_22_25_5 21003.33315925809
R19239 n_22_24_5 n_22_24_6 6.045903572602696
R19240 n_22_24_6 n_23_24_6 7.19750425309864
R19241 n_22_24_6 n_22_25_6 3500.5555265430157
R19242 n_22_24_6 n_22_24_7 8.20515484853222
R19243 n_22_24_7 n_23_24_7 12.338578719597708
R19244 n_22_24_7 n_22_25_7 6000.952331216617
R19245 n_22_24_7 n_22_24_8 6.045903572602677
R19246 n_22_24_8 n_23_24_8 12.338578719597708
R19247 n_22_24_8 n_22_25_8 6000.952331216617
R19248 n_22_24_8 n_22_24_9 6.045903572602677
R19249 n_22_24_9 n_23_24_9 12.338578719597708
R19250 n_22_24_9 n_22_25_9 6000.952331216617
R19251 n_22_24_9 n_22_24_10 6.045903572602677
R19252 n_22_24_10 n_23_24_10 12.338578719597708
R19253 n_22_24_10 n_22_25_10 6000.952331216617
R19254 n_22_24_10 n_22_24_11 6.045903572602638
R19255 n_22_24_11 n_23_24_11 12.338578719597864
R19256 n_22_24_11 n_22_25_11 6000.952331216693
R19257 n_22_24_11 n_22_24_12 6.045903572602619
R19258 n_22_24_12 n_23_24_12 12.338578719597788
R19259 n_22_24_12 n_22_25_12 6000.952331216655
R19260 n_22_24_12 n_22_24_13 6.045903572602677
R19261 n_22_24_13 n_23_24_13 12.33857871959763
R19262 n_22_24_13 n_22_25_13 6000.952331216578
R19263 n_22_24_13 n_22_24_14 30.229517863013463
R19264 n_22_24_14 n_23_24_14 1.370953191066409
R19265 n_22_24_14 n_22_25_14 666.7724812462893
R19266 n_22_24_14 n_22_24_15 934.0921019671247
R19267 n_22_24_15 n_23_24_15 453.4427679452103
R19268 n_22_24_15 n_22_25_15 220534.99817220803
R19269 n_22_25_0 n_23_25_0 6.477753827788804
R19270 n_22_25_0 n_22_26_0 3150.499973888717
R19271 n_22_25_0 n_22_25_1 748.1805671095855
R19272 n_22_25_1 n_23_25_1 9.068855358904324
R19273 n_22_25_1 n_22_26_1 4410.699963444204
R19274 n_22_25_1 n_22_25_2 1700.4103797945122
R19275 n_22_25_2 n_23_25_2 16.19438456947201
R19276 n_22_25_2 n_22_26_2 7876.249934721793
R19277 n_22_25_2 n_22_25_3 1591.5841154876634
R19278 n_22_25_3 n_23_25_3 226.72138397260792
R19279 n_22_25_3 n_22_26_3 110267.49908610499
R19280 n_22_25_3 n_22_25_4 21.160662504109506
R19281 n_22_25_4 n_23_25_4 6.870344968866907
R19282 n_22_25_4 n_22_26_4 3341.439366245606
R19283 n_22_25_4 n_22_25_5 17.489935335029287
R19284 n_22_25_5 n_23_25_5 43.185025518591985
R19285 n_22_25_5 n_22_26_5 21003.33315925809
R19286 n_22_25_5 n_22_25_6 6.0459035726027155
R19287 n_22_25_6 n_23_25_6 7.197504253098664
R19288 n_22_25_6 n_22_26_6 3500.5555265430157
R19289 n_22_25_6 n_22_25_7 8.205154848532247
R19290 n_22_25_7 n_23_25_7 12.338578719597749
R19291 n_22_25_7 n_22_26_7 6000.952331216617
R19292 n_22_25_7 n_22_25_8 6.045903572602697
R19293 n_22_25_8 n_23_25_8 12.338578719597749
R19294 n_22_25_8 n_22_26_8 6000.952331216617
R19295 n_22_25_8 n_22_25_9 6.045903572602697
R19296 n_22_25_9 n_23_25_9 12.338578719597749
R19297 n_22_25_9 n_22_26_9 6000.952331216617
R19298 n_22_25_9 n_22_25_10 6.045903572602697
R19299 n_22_25_10 n_23_25_10 12.338578719597749
R19300 n_22_25_10 n_22_26_10 6000.952331216617
R19301 n_22_25_10 n_22_25_11 6.045903572602658
R19302 n_22_25_11 n_23_25_11 12.338578719597907
R19303 n_22_25_11 n_22_26_11 6000.952331216693
R19304 n_22_25_11 n_22_25_12 6.045903572602638
R19305 n_22_25_12 n_23_25_12 12.338578719597823
R19306 n_22_25_12 n_22_26_12 6000.952331216655
R19307 n_22_25_12 n_22_25_13 6.045903572602697
R19308 n_22_25_13 n_23_25_13 12.338578719597672
R19309 n_22_25_13 n_22_26_13 6000.952331216578
R19310 n_22_25_13 n_22_25_14 30.22951786301356
R19311 n_22_25_14 n_23_25_14 1.3709531910664134
R19312 n_22_25_14 n_22_26_14 666.7724812462893
R19313 n_22_25_14 n_22_25_15 934.0921019671276
R19314 n_22_25_15 n_23_25_15 453.44276794521176
R19315 n_22_25_15 n_22_26_15 220534.99817220803
R19316 n_22_26_0 n_23_26_0 6.477753827788782
R19317 n_22_26_0 n_22_27_0 3150.499973888722
R19318 n_22_26_0 n_22_26_1 748.1805671095831
R19319 n_22_26_1 n_23_26_1 9.068855358904296
R19320 n_22_26_1 n_22_27_1 4410.699963444211
R19321 n_22_26_1 n_22_26_2 1700.410379794507
R19322 n_22_26_2 n_23_26_2 16.194384569471957
R19323 n_22_26_2 n_22_27_2 7876.249934721805
R19324 n_22_26_2 n_22_26_3 1591.5841154876584
R19325 n_22_26_3 n_23_26_3 226.72138397260719
R19326 n_22_26_3 n_22_27_3 110267.49908610516
R19327 n_22_26_3 n_22_26_4 21.16066250410944
R19328 n_22_26_4 n_23_26_4 6.870344968866884
R19329 n_22_26_4 n_22_27_4 3341.4393662456114
R19330 n_22_26_4 n_22_26_5 17.48993533502923
R19331 n_22_26_5 n_23_26_5 43.18502551859185
R19332 n_22_26_5 n_22_27_5 21003.333159258123
R19333 n_22_26_5 n_22_26_6 6.045903572602696
R19334 n_22_26_6 n_23_26_6 7.19750425309864
R19335 n_22_26_6 n_22_27_6 3500.555526543021
R19336 n_22_26_6 n_22_26_7 8.20515484853222
R19337 n_22_26_7 n_23_26_7 12.338578719597708
R19338 n_22_26_7 n_22_27_7 6000.952331216627
R19339 n_22_26_7 n_22_26_8 6.045903572602677
R19340 n_22_26_8 n_23_26_8 12.338578719597708
R19341 n_22_26_8 n_22_27_8 6000.952331216627
R19342 n_22_26_8 n_22_26_9 6.045903572602677
R19343 n_22_26_9 n_23_26_9 12.338578719597708
R19344 n_22_26_9 n_22_27_9 6000.952331216627
R19345 n_22_26_9 n_22_26_10 6.045903572602677
R19346 n_22_26_10 n_23_26_10 12.338578719597708
R19347 n_22_26_10 n_22_27_10 6000.952331216627
R19348 n_22_26_10 n_22_26_11 6.045903572602638
R19349 n_22_26_11 n_23_26_11 12.338578719597864
R19350 n_22_26_11 n_22_27_11 6000.952331216702
R19351 n_22_26_11 n_22_26_12 6.045903572602619
R19352 n_22_26_12 n_23_26_12 12.338578719597788
R19353 n_22_26_12 n_22_27_12 6000.952331216665
R19354 n_22_26_12 n_22_26_13 6.045903572602677
R19355 n_22_26_13 n_23_26_13 12.33857871959763
R19356 n_22_26_13 n_22_27_13 6000.952331216588
R19357 n_22_26_13 n_22_26_14 30.229517863013463
R19358 n_22_26_14 n_23_26_14 1.370953191066409
R19359 n_22_26_14 n_22_27_14 666.7724812462903
R19360 n_22_26_14 n_22_26_15 934.0921019671247
R19361 n_22_26_15 n_23_26_15 453.4427679452103
R19362 n_22_26_15 n_22_27_15 220534.99817220838
R19363 n_22_27_0 n_23_27_0 6.477753827788782
R19364 n_22_27_0 n_22_27_1 748.1805671095831
R19365 n_22_27_1 n_23_27_1 9.068855358904296
R19366 n_22_27_1 n_22_27_2 1700.410379794507
R19367 n_22_27_2 n_23_27_2 16.194384569471957
R19368 n_22_27_2 n_22_27_3 1591.5841154876584
R19369 n_22_27_3 n_23_27_3 226.72138397260719
R19370 n_22_27_3 n_22_27_4 21.16066250410944
R19371 n_22_27_4 n_23_27_4 6.870344968866884
R19372 n_22_27_4 n_22_27_5 17.48993533502923
R19373 n_22_27_5 n_23_27_5 43.18502551859185
R19374 n_22_27_5 n_22_27_6 6.045903572602696
R19375 n_22_27_6 n_23_27_6 7.19750425309864
R19376 n_22_27_6 n_22_27_7 8.20515484853222
R19377 n_22_27_7 n_23_27_7 12.338578719597708
R19378 n_22_27_7 n_22_27_8 6.045903572602677
R19379 n_22_27_8 n_23_27_8 12.338578719597708
R19380 n_22_27_8 n_22_27_9 6.045903572602677
R19381 n_22_27_9 n_23_27_9 12.338578719597708
R19382 n_22_27_9 n_22_27_10 6.045903572602677
R19383 n_22_27_10 n_23_27_10 12.338578719597708
R19384 n_22_27_10 n_22_27_11 6.045903572602638
R19385 n_22_27_11 n_23_27_11 12.338578719597864
R19386 n_22_27_11 n_22_27_12 6.045903572602619
R19387 n_22_27_12 n_23_27_12 12.338578719597788
R19388 n_22_27_12 n_22_27_13 6.045903572602677
R19389 n_22_27_13 n_23_27_13 12.33857871959763
R19390 n_22_27_13 n_22_27_14 30.229517863013463
R19391 n_22_27_14 n_23_27_14 1.370953191066409
R19392 n_22_27_14 n_22_27_15 934.0921019671247
R19393 n_22_27_15 n_23_27_15 453.4427679452103
R19394 n_23_0_0 n_24_0_0 125.67181420979068
R19395 n_23_0_0 n_23_1_0 3150.5002452092954
R19396 n_23_0_0 n_23_0_1 748.1805026763932
R19397 n_23_0_1 n_24_0_1 175.9405398937069
R19398 n_23_0_1 n_23_1_1 4410.700343293014
R19399 n_23_0_1 n_23_0_2 1700.4102333554388
R19400 n_23_0_2 n_24_0_2 314.1795355244767
R19401 n_23_0_2 n_23_1_2 7876.25061302324
R19402 n_23_0_2 n_23_0_3 1591.5839784206908
R19403 n_23_0_3 n_24_0_3 4398.513497342668
R19404 n_23_0_3 n_23_1_3 110267.50858232524
R19405 n_23_0_3 n_23_0_4 21.160660681756593
R19406 n_23_0_4 n_24_0_4 133.2882877982627
R19407 n_23_0_4 n_23_1_4 3341.4396540098564
R19408 n_23_0_4 n_23_0_5 17.489933828798815
R19409 n_23_0_5 n_24_0_5 837.8120947319369
R19410 n_23_0_5 n_23_1_5 21003.33496806195
R19411 n_23_0_5 n_23_0_6 6.045903051930455
R19412 n_23_0_6 n_24_0_6 139.6353491219895
R19413 n_23_0_6 n_23_1_6 3500.5558280103255
R19414 n_23_0_6 n_23_0_7 8.205154141905608
R19415 n_23_0_7 n_24_0_7 239.37488420912558
R19416 n_23_0_7 n_23_1_7 6000.95284801772
R19417 n_23_0_7 n_23_0_8 6.045903051930436
R19418 n_23_0_8 n_24_0_8 239.37488420912558
R19419 n_23_0_8 n_23_1_8 6000.95284801772
R19420 n_23_0_8 n_23_0_9 6.045903051930436
R19421 n_23_0_9 n_24_0_9 239.37488420912558
R19422 n_23_0_9 n_23_1_9 6000.95284801772
R19423 n_23_0_9 n_23_0_10 6.045903051930436
R19424 n_23_0_10 n_24_0_10 239.37488420912558
R19425 n_23_0_10 n_23_1_10 6000.95284801772
R19426 n_23_0_10 n_23_0_11 6.045903051930397
R19427 n_23_0_11 n_24_0_11 239.37488420912865
R19428 n_23_0_11 n_23_1_11 6000.952848017796
R19429 n_23_0_11 n_23_0_12 6.045903051930377
R19430 n_23_0_12 n_24_0_12 239.3748842091272
R19431 n_23_0_12 n_23_1_12 6000.952848017758
R19432 n_23_0_12 n_23_0_13 6.045903051930436
R19433 n_23_0_13 n_24_0_13 239.3748842091241
R19434 n_23_0_13 n_23_1_13 6000.952848017681
R19435 n_23_0_13 n_23_0_14 30.229515259652253
R19436 n_23_0_14 n_24_0_14 26.597209356569458
R19437 n_23_0_14 n_23_1_14 666.7725386686341
R19438 n_23_0_14 n_23_0_15 934.0920215232634
R19439 n_23_0_15 n_24_0_15 8797.02699468526
R19440 n_23_0_15 n_23_1_15 220535.01716464857
R19441 n_23_1_0 n_24_1_0 125.67181420979068
R19442 n_23_1_0 n_23_2_0 3150.5002452092954
R19443 n_23_1_0 n_23_1_1 748.1805026763932
R19444 n_23_1_1 n_24_1_1 175.9405398937069
R19445 n_23_1_1 n_23_2_1 4410.700343293014
R19446 n_23_1_1 n_23_1_2 1700.4102333554388
R19447 n_23_1_2 n_24_1_2 314.1795355244767
R19448 n_23_1_2 n_23_2_2 7876.25061302324
R19449 n_23_1_2 n_23_1_3 1591.5839784206908
R19450 n_23_1_3 n_24_1_3 4398.513497342668
R19451 n_23_1_3 n_23_2_3 110267.50858232524
R19452 n_23_1_3 n_23_1_4 21.160660681756593
R19453 n_23_1_4 n_24_1_4 133.2882877982627
R19454 n_23_1_4 n_23_2_4 3341.4396540098564
R19455 n_23_1_4 n_23_1_5 17.489933828798815
R19456 n_23_1_5 n_24_1_5 837.8120947319369
R19457 n_23_1_5 n_23_2_5 21003.33496806195
R19458 n_23_1_5 n_23_1_6 6.045903051930455
R19459 n_23_1_6 n_24_1_6 139.6353491219895
R19460 n_23_1_6 n_23_2_6 3500.5558280103255
R19461 n_23_1_6 n_23_1_7 8.205154141905608
R19462 n_23_1_7 n_24_1_7 239.37488420912558
R19463 n_23_1_7 n_23_2_7 6000.95284801772
R19464 n_23_1_7 n_23_1_8 6.045903051930436
R19465 n_23_1_8 n_24_1_8 239.37488420912558
R19466 n_23_1_8 n_23_2_8 6000.95284801772
R19467 n_23_1_8 n_23_1_9 6.045903051930436
R19468 n_23_1_9 n_24_1_9 239.37488420912558
R19469 n_23_1_9 n_23_2_9 6000.95284801772
R19470 n_23_1_9 n_23_1_10 6.045903051930436
R19471 n_23_1_10 n_24_1_10 239.37488420912558
R19472 n_23_1_10 n_23_2_10 6000.95284801772
R19473 n_23_1_10 n_23_1_11 6.045903051930397
R19474 n_23_1_11 n_24_1_11 239.37488420912865
R19475 n_23_1_11 n_23_2_11 6000.952848017796
R19476 n_23_1_11 n_23_1_12 6.045903051930377
R19477 n_23_1_12 n_24_1_12 239.3748842091272
R19478 n_23_1_12 n_23_2_12 6000.952848017758
R19479 n_23_1_12 n_23_1_13 6.045903051930436
R19480 n_23_1_13 n_24_1_13 239.3748842091241
R19481 n_23_1_13 n_23_2_13 6000.952848017681
R19482 n_23_1_13 n_23_1_14 30.229515259652253
R19483 n_23_1_14 n_24_1_14 26.597209356569458
R19484 n_23_1_14 n_23_2_14 666.7725386686341
R19485 n_23_1_14 n_23_1_15 934.0920215232634
R19486 n_23_1_15 n_24_1_15 8797.02699468526
R19487 n_23_1_15 n_23_2_15 220535.01716464857
R19488 n_23_2_0 n_24_2_0 125.67181420979068
R19489 n_23_2_0 n_23_3_0 3150.5002452092954
R19490 n_23_2_0 n_23_2_1 748.1805026763932
R19491 n_23_2_1 n_24_2_1 175.9405398937069
R19492 n_23_2_1 n_23_3_1 4410.700343293014
R19493 n_23_2_1 n_23_2_2 1700.4102333554388
R19494 n_23_2_2 n_24_2_2 314.1795355244767
R19495 n_23_2_2 n_23_3_2 7876.25061302324
R19496 n_23_2_2 n_23_2_3 1591.5839784206908
R19497 n_23_2_3 n_24_2_3 4398.513497342668
R19498 n_23_2_3 n_23_3_3 110267.50858232524
R19499 n_23_2_3 n_23_2_4 21.160660681756593
R19500 n_23_2_4 n_24_2_4 133.2882877982627
R19501 n_23_2_4 n_23_3_4 3341.4396540098564
R19502 n_23_2_4 n_23_2_5 17.489933828798815
R19503 n_23_2_5 n_24_2_5 837.8120947319369
R19504 n_23_2_5 n_23_3_5 21003.33496806195
R19505 n_23_2_5 n_23_2_6 6.045903051930455
R19506 n_23_2_6 n_24_2_6 139.6353491219895
R19507 n_23_2_6 n_23_3_6 3500.5558280103255
R19508 n_23_2_6 n_23_2_7 8.205154141905608
R19509 n_23_2_7 n_24_2_7 239.37488420912558
R19510 n_23_2_7 n_23_3_7 6000.95284801772
R19511 n_23_2_7 n_23_2_8 6.045903051930436
R19512 n_23_2_8 n_24_2_8 239.37488420912558
R19513 n_23_2_8 n_23_3_8 6000.95284801772
R19514 n_23_2_8 n_23_2_9 6.045903051930436
R19515 n_23_2_9 n_24_2_9 239.37488420912558
R19516 n_23_2_9 n_23_3_9 6000.95284801772
R19517 n_23_2_9 n_23_2_10 6.045903051930436
R19518 n_23_2_10 n_24_2_10 239.37488420912558
R19519 n_23_2_10 n_23_3_10 6000.95284801772
R19520 n_23_2_10 n_23_2_11 6.045903051930397
R19521 n_23_2_11 n_24_2_11 239.37488420912865
R19522 n_23_2_11 n_23_3_11 6000.952848017796
R19523 n_23_2_11 n_23_2_12 6.045903051930377
R19524 n_23_2_12 n_24_2_12 239.3748842091272
R19525 n_23_2_12 n_23_3_12 6000.952848017758
R19526 n_23_2_12 n_23_2_13 6.045903051930436
R19527 n_23_2_13 n_24_2_13 239.3748842091241
R19528 n_23_2_13 n_23_3_13 6000.952848017681
R19529 n_23_2_13 n_23_2_14 30.229515259652253
R19530 n_23_2_14 n_24_2_14 26.597209356569458
R19531 n_23_2_14 n_23_3_14 666.7725386686341
R19532 n_23_2_14 n_23_2_15 934.0920215232634
R19533 n_23_2_15 n_24_2_15 8797.02699468526
R19534 n_23_2_15 n_23_3_15 220535.01716464857
R19535 n_23_3_0 n_24_3_0 125.67181420979068
R19536 n_23_3_0 n_23_4_0 1646.6785714285472
R19537 n_23_3_0 n_23_3_1 748.1805026763932
R19538 n_23_3_1 n_24_3_1 175.9405398937069
R19539 n_23_3_1 n_23_4_1 2305.3499999999667
R19540 n_23_3_1 n_23_3_2 1700.4102333554388
R19541 n_23_3_2 n_24_3_2 314.1795355244767
R19542 n_23_3_2 n_23_4_2 4116.696428571369
R19543 n_23_3_2 n_23_3_3 1591.5839784206908
R19544 n_23_3_3 n_24_3_3 4398.513497342668
R19545 n_23_3_3 n_23_4_3 57633.749999999105
R19546 n_23_3_3 n_23_3_4 21.160660681756593
R19547 n_23_3_4 n_24_3_4 133.2882877982627
R19548 n_23_3_4 n_23_4_4 1746.477272727246
R19549 n_23_3_4 n_23_3_5 17.489933828798815
R19550 n_23_3_5 n_24_3_5 837.8120947319369
R19551 n_23_3_5 n_23_3_6 6.045903051930455
R19552 n_23_3_6 n_24_3_6 139.6353491219895
R19553 n_23_3_6 n_23_3_7 8.205154141905608
R19554 n_23_3_7 n_24_3_7 239.37488420912558
R19555 n_23_3_7 n_23_3_8 6.045903051930436
R19556 n_23_3_8 n_24_3_8 239.37488420912558
R19557 n_23_3_8 n_23_3_9 6.045903051930436
R19558 n_23_3_9 n_24_3_9 239.37488420912558
R19559 n_23_3_9 n_23_3_10 6.045903051930436
R19560 n_23_3_10 n_24_3_10 239.37488420912558
R19561 n_23_3_10 n_23_3_11 6.045903051930397
R19562 n_23_3_11 n_24_3_11 239.37488420912865
R19563 n_23_3_11 n_23_3_12 6.045903051930377
R19564 n_23_3_12 n_24_3_12 239.3748842091272
R19565 n_23_3_12 n_23_3_13 6.045903051930436
R19566 n_23_3_13 n_24_3_13 239.3748842091241
R19567 n_23_3_13 n_23_3_14 30.229515259652253
R19568 n_23_3_14 n_24_3_14 26.597209356569458
R19569 n_23_3_14 n_23_3_15 934.0920215232634
R19570 n_23_3_15 n_24_3_15 8797.02699468526
R19571 n_23_3_15 n_23_4_15 115267.4999999972
R19572 n_23_4_0 n_24_4_0 2771.508327585062
R19573 n_23_4_0 n_23_5_0 142.8568976478005
R19574 n_23_4_0 n_23_4_1 16500.028321727335
R19575 n_23_4_1 n_24_4_1 3880.111658619087
R19576 n_23_4_1 n_23_5_1 199.99965670692075
R19577 n_23_4_1 n_23_4_2 37500.064367562125
R19578 n_23_4_2 n_24_4_2 6928.7708189626555
R19579 n_23_4_2 n_23_5_2 357.14224411950136
R19580 n_23_4_2 n_23_4_3 35100.06024803815
R19581 n_23_4_3 n_24_4_3 97002.7914654771
R19582 n_23_4_3 n_23_5_3 4999.9914176730135
R19583 n_23_4_3 n_23_4_4 466.66746768521796
R19584 n_23_4_4 n_24_4_4 2939.4785292568818
R19585 n_23_4_4 n_23_5_4 151.5148914446368
R19586 n_23_4_15 n_24_4_15 194005.58293095249
R19587 n_23_4_15 n_23_5_15 9999.982835345938
R19588 n_23_5_0 n_24_5_0 2771.5083275850134
R19589 n_23_5_0 n_23_6_0 142.8568976478018
R19590 n_23_5_0 n_23_5_1 16500.02832172704
R19591 n_23_5_1 n_24_5_1 3880.111658619018
R19592 n_23_5_1 n_23_6_1 199.9996567069225
R19593 n_23_5_1 n_23_5_2 37500.06436756146
R19594 n_23_5_2 n_24_5_2 6928.770818962533
R19595 n_23_5_2 n_23_6_2 357.1422441195045
R19596 n_23_5_2 n_23_5_3 35100.06024803753
R19597 n_23_5_3 n_24_5_3 97002.79146547537
R19598 n_23_5_3 n_23_6_3 4999.991417673058
R19599 n_23_5_3 n_23_5_4 466.66746768520966
R19600 n_23_5_4 n_24_5_4 2939.4785292568295
R19601 n_23_5_4 n_23_6_4 151.51489144463812
R19602 n_23_5_15 n_24_5_15 194005.58293094902
R19603 n_23_5_15 n_23_6_15 9999.982835346027
R19604 n_23_6_0 n_24_6_0 2771.5083275850134
R19605 n_23_6_0 n_23_7_0 142.8568976478005
R19606 n_23_6_0 n_23_6_1 16500.02832172704
R19607 n_23_6_1 n_24_6_1 3880.111658619018
R19608 n_23_6_1 n_23_7_1 199.99965670692075
R19609 n_23_6_1 n_23_6_2 37500.06436756146
R19610 n_23_6_2 n_24_6_2 6928.770818962533
R19611 n_23_6_2 n_23_7_2 357.14224411950136
R19612 n_23_6_2 n_23_6_3 35100.06024803753
R19613 n_23_6_3 n_24_6_3 97002.79146547537
R19614 n_23_6_3 n_23_7_3 4999.9914176730135
R19615 n_23_6_3 n_23_6_4 466.66746768520966
R19616 n_23_6_4 n_24_6_4 2939.4785292568295
R19617 n_23_6_4 n_23_7_4 151.5148914446368
R19618 n_23_6_15 n_24_6_15 194005.58293094902
R19619 n_23_6_15 n_23_7_15 9999.982835345938
R19620 n_23_7_0 n_24_7_0 2771.508327585062
R19621 n_23_7_0 n_23_8_0 4174.885948823841
R19622 n_23_7_0 n_23_7_1 16500.028321727335
R19623 n_23_7_1 n_24_7_1 3880.111658619087
R19624 n_23_7_1 n_23_8_1 5844.840328353377
R19625 n_23_7_1 n_23_7_2 37500.064367562125
R19626 n_23_7_2 n_24_7_2 6928.7708189626555
R19627 n_23_7_2 n_23_8_2 10437.214872059603
R19628 n_23_7_2 n_23_7_3 35100.06024803815
R19629 n_23_7_3 n_24_7_3 97002.7914654771
R19630 n_23_7_3 n_23_8_3 146121.00820883428
R19631 n_23_7_3 n_23_7_4 466.66746768521796
R19632 n_23_7_4 n_24_7_4 2939.4785292568818
R19633 n_23_7_4 n_23_8_4 4427.909339661646
R19634 n_23_7_15 n_24_7_15 194005.58293095249
R19635 n_23_7_15 n_23_8_15 292242.01641766605
R19636 n_23_8_0 n_24_8_0 48.24335106234782
R19637 n_23_8_0 n_23_9_0 8206.914999999884
R19638 n_23_8_0 n_23_8_1 287.21424032572827
R19639 n_23_8_1 n_24_8_1 67.54069148728694
R19640 n_23_8_1 n_23_9_1 11489.680999999839
R19641 n_23_8_1 n_23_8_2 652.759637103928
R19642 n_23_8_2 n_24_8_2 120.60837765586953
R19643 n_23_8_2 n_23_9_2 20517.287499999715
R19644 n_23_8_2 n_23_8_3 610.9830203292765
R19645 n_23_8_3 n_24_8_3 1688.517287182172
R19646 n_23_8_3 n_23_9_3 287242.0249999957
R19647 n_23_8_3 n_23_8_4 8.123231039515554
R19648 n_23_8_4 n_24_8_4 51.16719052067188
R19649 n_23_8_4 n_23_9_4 8704.30378787866
R19650 n_23_8_15 n_24_8_15 3377.034574364314
R19651 n_23_8_15 n_23_9_15 574484.0499999863
R19652 n_23_9_0 n_24_9_0 48.243351062347784
R19653 n_23_9_0 n_23_10_0 8206.914999999884
R19654 n_23_9_0 n_23_9_1 287.2142403257281
R19655 n_23_9_1 n_24_9_1 67.5406914872869
R19656 n_23_9_1 n_23_10_1 11489.680999999839
R19657 n_23_9_1 n_23_9_2 652.7596371039276
R19658 n_23_9_2 n_24_9_2 120.60837765586945
R19659 n_23_9_2 n_23_10_2 20517.287499999715
R19660 n_23_9_2 n_23_9_3 610.9830203292762
R19661 n_23_9_3 n_24_9_3 1688.517287182171
R19662 n_23_9_3 n_23_10_3 287242.0249999957
R19663 n_23_9_3 n_23_9_4 8.123231039515549
R19664 n_23_9_4 n_24_9_4 51.167190520671845
R19665 n_23_9_4 n_23_10_4 8704.30378787866
R19666 n_23_9_15 n_24_9_15 3377.034574364312
R19667 n_23_9_15 n_23_10_15 574484.0499999863
R19668 n_23_10_0 n_24_10_0 48.24335106234782
R19669 n_23_10_0 n_23_11_0 8206.914999999883
R19670 n_23_10_0 n_23_10_1 287.21424032572827
R19671 n_23_10_1 n_24_10_1 67.54069148728694
R19672 n_23_10_1 n_23_11_1 11489.680999999835
R19673 n_23_10_1 n_23_10_2 652.759637103928
R19674 n_23_10_2 n_24_10_2 120.60837765586953
R19675 n_23_10_2 n_23_11_2 20517.287499999708
R19676 n_23_10_2 n_23_10_3 610.9830203292765
R19677 n_23_10_3 n_24_10_3 1688.517287182172
R19678 n_23_10_3 n_23_11_3 287242.0249999956
R19679 n_23_10_3 n_23_10_4 8.123231039515554
R19680 n_23_10_4 n_24_10_4 51.16719052067188
R19681 n_23_10_4 n_23_11_4 8704.303787878656
R19682 n_23_10_15 n_24_10_15 3377.034574364314
R19683 n_23_10_15 n_23_11_15 574484.0499999862
R19684 n_23_11_0 n_24_11_0 48.24335106234782
R19685 n_23_11_0 n_23_12_0 4174.886071428513
R19686 n_23_11_0 n_23_11_1 287.21424032572827
R19687 n_23_11_1 n_24_11_1 67.54069148728694
R19688 n_23_11_1 n_23_12_1 5844.8404999999175
R19689 n_23_11_1 n_23_11_2 652.759637103928
R19690 n_23_11_2 n_24_11_2 120.60837765586953
R19691 n_23_11_2 n_23_12_2 10437.215178571283
R19692 n_23_11_2 n_23_11_3 610.9830203292765
R19693 n_23_11_3 n_24_11_3 1688.517287182172
R19694 n_23_11_3 n_23_12_3 146121.0124999978
R19695 n_23_11_3 n_23_11_4 8.123231039515554
R19696 n_23_11_4 n_24_11_4 51.16719052067188
R19697 n_23_11_4 n_23_12_4 4427.909469696904
R19698 n_23_11_15 n_24_11_15 3377.034574364314
R19699 n_23_11_15 n_23_12_15 292242.02499999304
R19700 n_23_12_0 n_24_12_0 2771.5035703868975
R19701 n_23_12_0 n_23_13_0 142.85714285714286
R19702 n_23_12_0 n_23_12_1 16499.99999999953
R19703 n_23_12_1 n_24_12_1 3880.104998541656
R19704 n_23_12_1 n_23_13_1 200.00000000000003
R19705 n_23_12_1 n_23_12_2 37499.99999999893
R19706 n_23_12_2 n_24_12_2 6928.758925967244
R19707 n_23_12_2 n_23_13_2 357.1428571428572
R19708 n_23_12_2 n_23_12_3 35099.999999999
R19709 n_23_12_3 n_24_12_3 97002.62496354131
R19710 n_23_12_3 n_23_13_3 4999.999999999996
R19711 n_23_12_3 n_23_12_4 466.66666666665384
R19712 n_23_12_4 n_24_12_4 2939.4734837436763
R19713 n_23_12_4 n_23_13_4 151.51515151515142
R19714 n_23_12_15 n_24_12_15 194005.2499270809
R19715 n_23_12_15 n_23_13_15 9999.999999999904
R19716 n_23_13_0 n_24_13_0 2771.5035703868975
R19717 n_23_13_0 n_23_14_0 142.85714285714286
R19718 n_23_13_0 n_23_13_1 16499.99999999953
R19719 n_23_13_1 n_24_13_1 3880.104998541656
R19720 n_23_13_1 n_23_14_1 200.00000000000003
R19721 n_23_13_1 n_23_13_2 37499.99999999893
R19722 n_23_13_2 n_24_13_2 6928.758925967244
R19723 n_23_13_2 n_23_14_2 357.1428571428572
R19724 n_23_13_2 n_23_13_3 35099.999999999
R19725 n_23_13_3 n_24_13_3 97002.62496354131
R19726 n_23_13_3 n_23_14_3 4999.999999999996
R19727 n_23_13_3 n_23_13_4 466.66666666665384
R19728 n_23_13_4 n_24_13_4 2939.4734837436763
R19729 n_23_13_4 n_23_14_4 151.51515151515142
R19730 n_23_13_15 n_24_13_15 194005.2499270809
R19731 n_23_13_15 n_23_14_15 9999.999999999904
R19732 n_23_14_0 n_24_14_0 2771.5035703868975
R19733 n_23_14_0 n_23_15_0 142.85714285714286
R19734 n_23_14_0 n_23_14_1 16499.99999999953
R19735 n_23_14_1 n_24_14_1 3880.104998541656
R19736 n_23_14_1 n_23_15_1 200.00000000000003
R19737 n_23_14_1 n_23_14_2 37499.99999999893
R19738 n_23_14_2 n_24_14_2 6928.758925967244
R19739 n_23_14_2 n_23_15_2 357.1428571428572
R19740 n_23_14_2 n_23_14_3 35099.999999999
R19741 n_23_14_3 n_24_14_3 97002.62496354131
R19742 n_23_14_3 n_23_15_3 4999.999999999996
R19743 n_23_14_3 n_23_14_4 466.66666666665384
R19744 n_23_14_4 n_24_14_4 2939.4734837436763
R19745 n_23_14_4 n_23_15_4 151.51515151515142
R19746 n_23_14_15 n_24_14_15 194005.2499270809
R19747 n_23_14_15 n_23_15_15 9999.999999999904
R19748 n_23_15_0 n_24_15_0 2771.5035703868975
R19749 n_23_15_0 n_23_16_0 4174.88607142851
R19750 n_23_15_0 n_23_15_1 16499.99999999953
R19751 n_23_15_1 n_24_15_1 3880.104998541656
R19752 n_23_15_1 n_23_16_1 5844.840499999915
R19753 n_23_15_1 n_23_15_2 37499.99999999893
R19754 n_23_15_2 n_24_15_2 6928.758925967244
R19755 n_23_15_2 n_23_16_2 10437.215178571278
R19756 n_23_15_2 n_23_15_3 35099.999999999
R19757 n_23_15_3 n_24_15_3 97002.62496354131
R19758 n_23_15_3 n_23_16_3 146121.0124999977
R19759 n_23_15_3 n_23_15_4 466.66666666665384
R19760 n_23_15_4 n_24_15_4 2939.4734837436763
R19761 n_23_15_4 n_23_16_4 4427.909469696901
R19762 n_23_15_15 n_24_15_15 194005.2499270809
R19763 n_23_15_15 n_23_16_15 292242.02499999286
R19764 n_23_16_0 n_24_16_0 48.243351062347855
R19765 n_23_16_0 n_23_17_0 8206.914999999883
R19766 n_23_16_0 n_23_16_1 287.21424032572844
R19767 n_23_16_1 n_24_16_1 67.54069148728698
R19768 n_23_16_1 n_23_17_1 11489.680999999837
R19769 n_23_16_1 n_23_16_2 652.7596371039283
R19770 n_23_16_2 n_24_16_2 120.60837765586962
R19771 n_23_16_2 n_23_17_2 20517.287499999708
R19772 n_23_16_2 n_23_16_3 610.9830203292769
R19773 n_23_16_3 n_24_16_3 1688.5172871821728
R19774 n_23_16_3 n_23_17_3 287242.0249999956
R19775 n_23_16_3 n_23_16_4 8.12323103951556
R19776 n_23_16_4 n_24_16_4 51.167190520671895
R19777 n_23_16_4 n_23_17_4 8704.303787878656
R19778 n_23_16_15 n_24_16_15 3377.034574364316
R19779 n_23_16_15 n_23_17_15 574484.0499999862
R19780 n_23_17_0 n_24_17_0 48.243351062347784
R19781 n_23_17_0 n_23_18_0 8206.914999999888
R19782 n_23_17_0 n_23_17_1 287.2142403257281
R19783 n_23_17_1 n_24_17_1 67.5406914872869
R19784 n_23_17_1 n_23_18_1 11489.680999999842
R19785 n_23_17_1 n_23_17_2 652.7596371039276
R19786 n_23_17_2 n_24_17_2 120.60837765586945
R19787 n_23_17_2 n_23_18_2 20517.287499999722
R19788 n_23_17_2 n_23_17_3 610.9830203292762
R19789 n_23_17_3 n_24_17_3 1688.517287182171
R19790 n_23_17_3 n_23_18_3 287242.0249999958
R19791 n_23_17_3 n_23_17_4 8.123231039515549
R19792 n_23_17_4 n_24_17_4 51.167190520671845
R19793 n_23_17_4 n_23_18_4 8704.303787878662
R19794 n_23_17_15 n_24_17_15 3377.034574364312
R19795 n_23_17_15 n_23_18_15 574484.0499999865
R19796 n_23_18_0 n_24_18_0 48.243351062347784
R19797 n_23_18_0 n_23_19_0 8206.914999999883
R19798 n_23_18_0 n_23_18_1 287.2142403257281
R19799 n_23_18_1 n_24_18_1 67.5406914872869
R19800 n_23_18_1 n_23_19_1 11489.680999999837
R19801 n_23_18_1 n_23_18_2 652.7596371039276
R19802 n_23_18_2 n_24_18_2 120.60837765586945
R19803 n_23_18_2 n_23_19_2 20517.287499999708
R19804 n_23_18_2 n_23_18_3 610.9830203292762
R19805 n_23_18_3 n_24_18_3 1688.517287182171
R19806 n_23_18_3 n_23_19_3 287242.0249999956
R19807 n_23_18_3 n_23_18_4 8.123231039515549
R19808 n_23_18_4 n_24_18_4 51.167190520671845
R19809 n_23_18_4 n_23_19_4 8704.303787878656
R19810 n_23_18_15 n_24_18_15 3377.034574364312
R19811 n_23_18_15 n_23_19_15 574484.0499999862
R19812 n_23_19_0 n_24_19_0 48.243351062347855
R19813 n_23_19_0 n_23_20_0 4174.886084484129
R19814 n_23_19_0 n_23_19_1 287.21424032572844
R19815 n_23_19_1 n_24_19_1 67.54069148728698
R19816 n_23_19_1 n_23_20_1 5844.8405182777815
R19817 n_23_19_1 n_23_19_2 652.7596371039283
R19818 n_23_19_2 n_24_19_2 120.60837765586962
R19819 n_23_19_2 n_23_20_2 10437.215211210323
R19820 n_23_19_2 n_23_19_3 610.9830203292769
R19821 n_23_19_3 n_24_19_3 1688.5172871821728
R19822 n_23_19_3 n_23_20_3 146121.01295694438
R19823 n_23_19_3 n_23_19_4 8.12323103951556
R19824 n_23_19_4 n_24_19_4 51.167190520671895
R19825 n_23_19_4 n_23_20_4 4427.90948354377
R19826 n_23_19_15 n_24_19_15 3377.034574364316
R19827 n_23_19_15 n_23_20_15 292242.0259138862
R19828 n_23_20_0 n_24_20_0 2771.5030638152725
R19829 n_23_20_0 n_23_21_0 142.85716896838048
R19830 n_23_20_0 n_23_20_1 16499.996984152138
R19831 n_23_20_1 n_24_20_1 3880.10428934138
R19832 n_23_20_1 n_23_21_1 200.00003655573266
R19833 n_23_20_1 n_23_20_2 37499.99314580031
R19834 n_23_20_2 n_24_20_2 6928.757659538181
R19835 n_23_20_2 n_23_21_2 357.1429224209512
R19836 n_23_20_2 n_23_20_3 35099.99358446909
R19837 n_23_20_3 n_24_20_3 97002.60723353442
R19838 n_23_20_3 n_23_21_3 5000.000913893312
R19839 n_23_20_3 n_23_20_4 466.66658136996
R19840 n_23_20_4 n_24_20_4 2939.47294647074
R19841 n_23_20_4 n_23_21_4 151.51517920888827
R19842 n_23_20_15 n_24_20_15 194005.21446706713
R19843 n_23_20_15 n_23_21_15 10000.001827786537
R19844 n_23_21_0 n_24_21_0 2771.5030638152725
R19845 n_23_21_0 n_23_22_0 142.8571689683754
R19846 n_23_21_0 n_23_21_1 16499.996984152138
R19847 n_23_21_1 n_24_21_1 3880.10428934138
R19848 n_23_21_1 n_23_22_1 200.00003655572556
R19849 n_23_21_1 n_23_21_2 37499.99314580031
R19850 n_23_21_2 n_24_21_2 6928.757659538181
R19851 n_23_21_2 n_23_22_2 357.14292242093853
R19852 n_23_21_2 n_23_21_3 35099.99358446909
R19853 n_23_21_3 n_24_21_3 97002.60723353442
R19854 n_23_21_3 n_23_22_3 5000.000913893135
R19855 n_23_21_3 n_23_21_4 466.66658136996
R19856 n_23_21_4 n_24_21_4 2939.47294647074
R19857 n_23_21_4 n_23_22_4 151.5151792088829
R19858 n_23_21_15 n_24_21_15 194005.21446706713
R19859 n_23_21_15 n_23_22_15 10000.001827786182
R19860 n_23_22_0 n_24_22_0 2771.503063815469
R19861 n_23_22_0 n_23_23_0 142.8571689683754
R19862 n_23_22_0 n_23_22_1 16499.99698415331
R19863 n_23_22_1 n_24_22_1 3880.1042893416566
R19864 n_23_22_1 n_23_23_1 200.00003655572556
R19865 n_23_22_1 n_23_22_2 37499.99314580298
R19866 n_23_22_2 n_24_22_2 6928.757659538673
R19867 n_23_22_2 n_23_23_2 357.14292242093853
R19868 n_23_22_2 n_23_22_3 35099.99358447159
R19869 n_23_22_3 n_24_22_3 97002.60723354133
R19870 n_23_22_3 n_23_23_3 5000.000913893135
R19871 n_23_22_3 n_23_22_4 466.66658136999297
R19872 n_23_22_4 n_24_22_4 2939.472946470949
R19873 n_23_22_4 n_23_23_4 151.5151792088829
R19874 n_23_22_15 n_24_22_15 194005.21446708092
R19875 n_23_22_15 n_23_23_15 10000.001827786182
R19876 n_23_23_0 n_24_23_0 2771.5030638152725
R19877 n_23_23_0 n_23_24_0 1646.678571428551
R19878 n_23_23_0 n_23_23_1 16499.996984152138
R19879 n_23_23_1 n_24_23_1 3880.10428934138
R19880 n_23_23_1 n_23_24_1 2305.3499999999717
R19881 n_23_23_1 n_23_23_2 37499.99314580031
R19882 n_23_23_2 n_24_23_2 6928.757659538181
R19883 n_23_23_2 n_23_24_2 4116.696428571378
R19884 n_23_23_2 n_23_23_3 35099.99358446909
R19885 n_23_23_3 n_24_23_3 97002.60723353442
R19886 n_23_23_3 n_23_24_3 57633.749999999236
R19887 n_23_23_3 n_23_23_4 466.66658136996
R19888 n_23_23_4 n_24_23_4 2939.47294647074
R19889 n_23_23_4 n_23_24_4 1746.4772727272498
R19890 n_23_23_15 n_24_23_15 194005.21446706713
R19891 n_23_23_15 n_23_24_15 115267.49999999745
R19892 n_23_24_0 n_24_24_0 125.67182503262799
R19893 n_23_24_0 n_23_25_0 3150.499973888717
R19894 n_23_24_0 n_23_24_1 748.1805671095831
R19895 n_23_24_1 n_24_24_1 175.94055504567916
R19896 n_23_24_1 n_23_25_1 4410.699963444204
R19897 n_23_24_1 n_23_24_2 1700.410379794507
R19898 n_23_24_2 n_24_24_2 314.17956258157
R19899 n_23_24_2 n_23_25_2 7876.249934721793
R19900 n_23_24_2 n_23_24_3 1591.5841154876584
R19901 n_23_24_3 n_24_24_3 4398.513876141976
R19902 n_23_24_3 n_23_25_3 110267.49908610499
R19903 n_23_24_3 n_23_24_4 21.16066250410944
R19904 n_23_24_4 n_24_24_4 133.28829927702958
R19905 n_23_24_4 n_23_25_4 3341.439366245606
R19906 n_23_24_4 n_23_24_5 17.48993533502923
R19907 n_23_24_5 n_24_24_5 837.8121668841859
R19908 n_23_24_5 n_23_25_5 21003.33315925809
R19909 n_23_24_5 n_23_24_6 6.045903572602696
R19910 n_23_24_6 n_24_24_6 139.6353611473643
R19911 n_23_24_6 n_23_25_6 3500.5555265430157
R19912 n_23_24_6 n_23_24_7 8.20515484853222
R19913 n_23_24_7 n_24_24_7 239.37490482405383
R19914 n_23_24_7 n_23_25_7 6000.952331216617
R19915 n_23_24_7 n_23_24_8 6.045903572602677
R19916 n_23_24_8 n_24_24_8 239.37490482405383
R19917 n_23_24_8 n_23_25_8 6000.952331216617
R19918 n_23_24_8 n_23_24_9 6.045903572602677
R19919 n_23_24_9 n_24_24_9 239.37490482405383
R19920 n_23_24_9 n_23_25_9 6000.952331216617
R19921 n_23_24_9 n_23_24_10 6.045903572602677
R19922 n_23_24_10 n_24_24_10 239.37490482405383
R19923 n_23_24_10 n_23_25_10 6000.952331216617
R19924 n_23_24_10 n_23_24_11 6.045903572602638
R19925 n_23_24_11 n_24_24_11 239.3749048240569
R19926 n_23_24_11 n_23_25_11 6000.952331216693
R19927 n_23_24_11 n_23_24_12 6.045903572602619
R19928 n_23_24_12 n_24_24_12 239.37490482405536
R19929 n_23_24_12 n_23_25_12 6000.952331216655
R19930 n_23_24_12 n_23_24_13 6.045903572602677
R19931 n_23_24_13 n_24_24_13 239.37490482405235
R19932 n_23_24_13 n_23_25_13 6000.952331216578
R19933 n_23_24_13 n_23_24_14 30.229517863013463
R19934 n_23_24_14 n_24_24_14 26.597211647117035
R19935 n_23_24_14 n_23_25_14 666.7724812462893
R19936 n_23_24_14 n_23_24_15 934.0921019671247
R19937 n_23_24_15 n_24_24_15 8797.027752283871
R19938 n_23_24_15 n_23_25_15 220534.99817220803
R19939 n_23_25_0 n_24_25_0 125.6718250326284
R19940 n_23_25_0 n_23_26_0 3150.499973888717
R19941 n_23_25_0 n_23_25_1 748.1805671095855
R19942 n_23_25_1 n_24_25_1 175.94055504567976
R19943 n_23_25_1 n_23_26_1 4410.699963444204
R19944 n_23_25_1 n_23_25_2 1700.4103797945122
R19945 n_23_25_2 n_24_25_2 314.179562581571
R19946 n_23_25_2 n_23_26_2 7876.249934721793
R19947 n_23_25_2 n_23_25_3 1591.5841154876634
R19948 n_23_25_3 n_24_25_3 4398.51387614199
R19949 n_23_25_3 n_23_26_3 110267.49908610499
R19950 n_23_25_3 n_23_25_4 21.160662504109506
R19951 n_23_25_4 n_24_25_4 133.28829927703
R19952 n_23_25_4 n_23_26_4 3341.439366245606
R19953 n_23_25_4 n_23_25_5 17.489935335029287
R19954 n_23_25_5 n_24_25_5 837.8121668841885
R19955 n_23_25_5 n_23_26_5 21003.33315925809
R19956 n_23_25_5 n_23_25_6 6.0459035726027155
R19957 n_23_25_6 n_24_25_6 139.63536114736476
R19958 n_23_25_6 n_23_26_6 3500.5555265430157
R19959 n_23_25_6 n_23_25_7 8.205154848532247
R19960 n_23_25_7 n_24_25_7 239.37490482405465
R19961 n_23_25_7 n_23_26_7 6000.952331216617
R19962 n_23_25_7 n_23_25_8 6.045903572602697
R19963 n_23_25_8 n_24_25_8 239.37490482405465
R19964 n_23_25_8 n_23_26_8 6000.952331216617
R19965 n_23_25_8 n_23_25_9 6.045903572602697
R19966 n_23_25_9 n_24_25_9 239.37490482405465
R19967 n_23_25_9 n_23_26_9 6000.952331216617
R19968 n_23_25_9 n_23_25_10 6.045903572602697
R19969 n_23_25_10 n_24_25_10 239.37490482405465
R19970 n_23_25_10 n_23_26_10 6000.952331216617
R19971 n_23_25_10 n_23_25_11 6.045903572602658
R19972 n_23_25_11 n_24_25_11 239.3749048240577
R19973 n_23_25_11 n_23_26_11 6000.952331216693
R19974 n_23_25_11 n_23_25_12 6.045903572602638
R19975 n_23_25_12 n_24_25_12 239.37490482405607
R19976 n_23_25_12 n_23_26_12 6000.952331216655
R19977 n_23_25_12 n_23_25_13 6.045903572602697
R19978 n_23_25_13 n_24_25_13 239.37490482405312
R19979 n_23_25_13 n_23_26_13 6000.952331216578
R19980 n_23_25_13 n_23_25_14 30.22951786301356
R19981 n_23_25_14 n_24_25_14 26.59721164711712
R19982 n_23_25_14 n_23_26_14 666.7724812462893
R19983 n_23_25_14 n_23_25_15 934.0921019671276
R19984 n_23_25_15 n_24_25_15 8797.027752283902
R19985 n_23_25_15 n_23_26_15 220534.99817220803
R19986 n_23_26_0 n_24_26_0 125.67182503262799
R19987 n_23_26_0 n_23_27_0 3150.499973888722
R19988 n_23_26_0 n_23_26_1 748.1805671095831
R19989 n_23_26_1 n_24_26_1 175.94055504567916
R19990 n_23_26_1 n_23_27_1 4410.699963444211
R19991 n_23_26_1 n_23_26_2 1700.410379794507
R19992 n_23_26_2 n_24_26_2 314.17956258157
R19993 n_23_26_2 n_23_27_2 7876.249934721805
R19994 n_23_26_2 n_23_26_3 1591.5841154876584
R19995 n_23_26_3 n_24_26_3 4398.513876141976
R19996 n_23_26_3 n_23_27_3 110267.49908610516
R19997 n_23_26_3 n_23_26_4 21.16066250410944
R19998 n_23_26_4 n_24_26_4 133.28829927702958
R19999 n_23_26_4 n_23_27_4 3341.4393662456114
R20000 n_23_26_4 n_23_26_5 17.48993533502923
R20001 n_23_26_5 n_24_26_5 837.8121668841859
R20002 n_23_26_5 n_23_27_5 21003.333159258123
R20003 n_23_26_5 n_23_26_6 6.045903572602696
R20004 n_23_26_6 n_24_26_6 139.6353611473643
R20005 n_23_26_6 n_23_27_6 3500.555526543021
R20006 n_23_26_6 n_23_26_7 8.20515484853222
R20007 n_23_26_7 n_24_26_7 239.37490482405383
R20008 n_23_26_7 n_23_27_7 6000.952331216627
R20009 n_23_26_7 n_23_26_8 6.045903572602677
R20010 n_23_26_8 n_24_26_8 239.37490482405383
R20011 n_23_26_8 n_23_27_8 6000.952331216627
R20012 n_23_26_8 n_23_26_9 6.045903572602677
R20013 n_23_26_9 n_24_26_9 239.37490482405383
R20014 n_23_26_9 n_23_27_9 6000.952331216627
R20015 n_23_26_9 n_23_26_10 6.045903572602677
R20016 n_23_26_10 n_24_26_10 239.37490482405383
R20017 n_23_26_10 n_23_27_10 6000.952331216627
R20018 n_23_26_10 n_23_26_11 6.045903572602638
R20019 n_23_26_11 n_24_26_11 239.3749048240569
R20020 n_23_26_11 n_23_27_11 6000.952331216702
R20021 n_23_26_11 n_23_26_12 6.045903572602619
R20022 n_23_26_12 n_24_26_12 239.37490482405536
R20023 n_23_26_12 n_23_27_12 6000.952331216665
R20024 n_23_26_12 n_23_26_13 6.045903572602677
R20025 n_23_26_13 n_24_26_13 239.37490482405235
R20026 n_23_26_13 n_23_27_13 6000.952331216588
R20027 n_23_26_13 n_23_26_14 30.229517863013463
R20028 n_23_26_14 n_24_26_14 26.597211647117035
R20029 n_23_26_14 n_23_27_14 666.7724812462903
R20030 n_23_26_14 n_23_26_15 934.0921019671247
R20031 n_23_26_15 n_24_26_15 8797.027752283871
R20032 n_23_26_15 n_23_27_15 220534.99817220838
R20033 n_23_27_0 n_24_27_0 125.67182503262799
R20034 n_23_27_0 n_23_27_1 748.1805671095831
R20035 n_23_27_1 n_24_27_1 175.94055504567916
R20036 n_23_27_1 n_23_27_2 1700.410379794507
R20037 n_23_27_2 n_24_27_2 314.17956258157
R20038 n_23_27_2 n_23_27_3 1591.5841154876584
R20039 n_23_27_3 n_24_27_3 4398.513876141976
R20040 n_23_27_3 n_23_27_4 21.16066250410944
R20041 n_23_27_4 n_24_27_4 133.28829927702958
R20042 n_23_27_4 n_23_27_5 17.48993533502923
R20043 n_23_27_5 n_24_27_5 837.8121668841859
R20044 n_23_27_5 n_23_27_6 6.045903572602696
R20045 n_23_27_6 n_24_27_6 139.6353611473643
R20046 n_23_27_6 n_23_27_7 8.20515484853222
R20047 n_23_27_7 n_24_27_7 239.37490482405383
R20048 n_23_27_7 n_23_27_8 6.045903572602677
R20049 n_23_27_8 n_24_27_8 239.37490482405383
R20050 n_23_27_8 n_23_27_9 6.045903572602677
R20051 n_23_27_9 n_24_27_9 239.37490482405383
R20052 n_23_27_9 n_23_27_10 6.045903572602677
R20053 n_23_27_10 n_24_27_10 239.37490482405383
R20054 n_23_27_10 n_23_27_11 6.045903572602638
R20055 n_23_27_11 n_24_27_11 239.3749048240569
R20056 n_23_27_11 n_23_27_12 6.045903572602619
R20057 n_23_27_12 n_24_27_12 239.37490482405536
R20058 n_23_27_12 n_23_27_13 6.045903572602677
R20059 n_23_27_13 n_24_27_13 239.37490482405235
R20060 n_23_27_13 n_23_27_14 30.229517863013463
R20061 n_23_27_14 n_24_27_14 26.597211647117035
R20062 n_23_27_14 n_23_27_15 934.0921019671247
R20063 n_23_27_15 n_24_27_15 8797.027752283871
R20064 n_24_0_0 n_25_0_0 244.8658751496557
R20065 n_24_0_0 n_24_1_0 83.34425224761593
R20066 n_24_0_0 n_24_0_1 19.792585205041586
R20067 n_24_0_1 n_25_0_1 342.81222520951786
R20068 n_24_0_1 n_24_1_1 116.6819531466623
R20069 n_24_0_1 n_24_0_2 44.98314819327633
R20070 n_24_0_2 n_25_0_2 612.1646878741392
R20071 n_24_0_2 n_24_1_2 208.3606306190398
R20072 n_24_0_2 n_24_0_3 42.104226708906644
R20073 n_24_0_3 n_25_0_3 8570.30563023794
R20074 n_24_0_3 n_24_1_3 2917.048828666555
R20075 n_24_0_3 n_24_0_4 0.5597902886274392
R20076 n_24_0_4 n_25_0_4 259.7062312193315
R20077 n_24_0_4 n_24_1_4 88.39541905050166
R20078 n_24_0_4 n_24_0_5 0.4626838099879854
R20079 n_24_0_5 n_25_0_5 1632.4391676643693
R20080 n_24_0_5 n_24_1_5 555.6283483174391
R20081 n_24_0_5 n_24_0_6 0.15994008246498265
R20082 n_24_0_6 n_25_0_6 272.07319461072825
R20083 n_24_0_6 n_24_1_6 92.60472471957317
R20084 n_24_0_6 n_24_0_7 0.21706154048819049
R20085 n_24_0_7 n_25_0_7 466.4111907612499
R20086 n_24_0_7 n_24_1_7 158.75095666212593
R20087 n_24_0_7 n_24_0_8 0.15994008246498215
R20088 n_24_0_8 n_25_0_8 466.4111907612499
R20089 n_24_0_8 n_24_1_8 158.75095666212593
R20090 n_24_0_8 n_24_0_9 0.15994008246498215
R20091 n_24_0_9 n_25_0_9 466.4111907612499
R20092 n_24_0_9 n_24_1_9 158.75095666212593
R20093 n_24_0_9 n_24_0_10 0.15994008246498215
R20094 n_24_0_10 n_25_0_10 466.4111907612499
R20095 n_24_0_10 n_24_1_10 158.75095666212593
R20096 n_24_0_10 n_24_0_11 0.15994008246498112
R20097 n_24_0_11 n_25_0_11 466.41119076125585
R20098 n_24_0_11 n_24_1_11 158.75095666212795
R20099 n_24_0_11 n_24_0_12 0.1599400824649806
R20100 n_24_0_12 n_25_0_12 466.411190761253
R20101 n_24_0_12 n_24_1_12 158.7509566621269
R20102 n_24_0_12 n_24_0_13 0.15994008246498215
R20103 n_24_0_13 n_25_0_13 466.411190761247
R20104 n_24_0_13 n_24_1_13 158.75095666212493
R20105 n_24_0_13 n_24_0_14 0.7997004123249127
R20106 n_24_0_14 n_25_0_14 51.82346564013877
R20107 n_24_0_14 n_24_1_14 17.638995184680617
R20108 n_24_0_14 n_24_0_15 24.710742740840033
R20109 n_24_0_15 n_25_0_15 17140.61126047573
R20110 n_24_0_15 n_24_1_15 5834.097657333058
R20111 n_24_1_0 n_25_1_0 244.8658751496557
R20112 n_24_1_0 n_24_2_0 83.34425224761593
R20113 n_24_1_0 n_24_1_1 19.792585205041586
R20114 n_24_1_1 n_25_1_1 342.81222520951786
R20115 n_24_1_1 n_24_2_1 116.6819531466623
R20116 n_24_1_1 n_24_1_2 44.98314819327633
R20117 n_24_1_2 n_25_1_2 612.1646878741392
R20118 n_24_1_2 n_24_2_2 208.3606306190398
R20119 n_24_1_2 n_24_1_3 42.104226708906644
R20120 n_24_1_3 n_25_1_3 8570.30563023794
R20121 n_24_1_3 n_24_2_3 2917.048828666555
R20122 n_24_1_3 n_24_1_4 0.5597902886274392
R20123 n_24_1_4 n_25_1_4 259.7062312193315
R20124 n_24_1_4 n_24_2_4 88.39541905050166
R20125 n_24_1_4 n_24_1_5 0.4626838099879854
R20126 n_24_1_5 n_25_1_5 1632.4391676643693
R20127 n_24_1_5 n_24_2_5 555.6283483174391
R20128 n_24_1_5 n_24_1_6 0.15994008246498265
R20129 n_24_1_6 n_25_1_6 272.07319461072825
R20130 n_24_1_6 n_24_2_6 92.60472471957317
R20131 n_24_1_6 n_24_1_7 0.21706154048819049
R20132 n_24_1_7 n_25_1_7 466.4111907612499
R20133 n_24_1_7 n_24_2_7 158.75095666212593
R20134 n_24_1_7 n_24_1_8 0.15994008246498215
R20135 n_24_1_8 n_25_1_8 466.4111907612499
R20136 n_24_1_8 n_24_2_8 158.75095666212593
R20137 n_24_1_8 n_24_1_9 0.15994008246498215
R20138 n_24_1_9 n_25_1_9 466.4111907612499
R20139 n_24_1_9 n_24_2_9 158.75095666212593
R20140 n_24_1_9 n_24_1_10 0.15994008246498215
R20141 n_24_1_10 n_25_1_10 466.4111907612499
R20142 n_24_1_10 n_24_2_10 158.75095666212593
R20143 n_24_1_10 n_24_1_11 0.15994008246498112
R20144 n_24_1_11 n_25_1_11 466.41119076125585
R20145 n_24_1_11 n_24_2_11 158.75095666212795
R20146 n_24_1_11 n_24_1_12 0.1599400824649806
R20147 n_24_1_12 n_25_1_12 466.411190761253
R20148 n_24_1_12 n_24_2_12 158.7509566621269
R20149 n_24_1_12 n_24_1_13 0.15994008246498215
R20150 n_24_1_13 n_25_1_13 466.411190761247
R20151 n_24_1_13 n_24_2_13 158.75095666212493
R20152 n_24_1_13 n_24_1_14 0.7997004123249127
R20153 n_24_1_14 n_25_1_14 51.82346564013877
R20154 n_24_1_14 n_24_2_14 17.638995184680617
R20155 n_24_1_14 n_24_1_15 24.710742740840033
R20156 n_24_1_15 n_25_1_15 17140.61126047573
R20157 n_24_1_15 n_24_2_15 5834.097657333058
R20158 n_24_2_0 n_25_2_0 244.8658751496557
R20159 n_24_2_0 n_24_3_0 83.34425224761593
R20160 n_24_2_0 n_24_2_1 19.792585205041586
R20161 n_24_2_1 n_25_2_1 342.81222520951786
R20162 n_24_2_1 n_24_3_1 116.6819531466623
R20163 n_24_2_1 n_24_2_2 44.98314819327633
R20164 n_24_2_2 n_25_2_2 612.1646878741392
R20165 n_24_2_2 n_24_3_2 208.3606306190398
R20166 n_24_2_2 n_24_2_3 42.104226708906644
R20167 n_24_2_3 n_25_2_3 8570.30563023794
R20168 n_24_2_3 n_24_3_3 2917.048828666555
R20169 n_24_2_3 n_24_2_4 0.5597902886274392
R20170 n_24_2_4 n_25_2_4 259.7062312193315
R20171 n_24_2_4 n_24_3_4 88.39541905050166
R20172 n_24_2_4 n_24_2_5 0.4626838099879854
R20173 n_24_2_5 n_25_2_5 1632.4391676643693
R20174 n_24_2_5 n_24_3_5 555.6283483174391
R20175 n_24_2_5 n_24_2_6 0.15994008246498265
R20176 n_24_2_6 n_25_2_6 272.07319461072825
R20177 n_24_2_6 n_24_3_6 92.60472471957317
R20178 n_24_2_6 n_24_2_7 0.21706154048819049
R20179 n_24_2_7 n_25_2_7 466.4111907612499
R20180 n_24_2_7 n_24_3_7 158.75095666212593
R20181 n_24_2_7 n_24_2_8 0.15994008246498215
R20182 n_24_2_8 n_25_2_8 466.4111907612499
R20183 n_24_2_8 n_24_3_8 158.75095666212593
R20184 n_24_2_8 n_24_2_9 0.15994008246498215
R20185 n_24_2_9 n_25_2_9 466.4111907612499
R20186 n_24_2_9 n_24_3_9 158.75095666212593
R20187 n_24_2_9 n_24_2_10 0.15994008246498215
R20188 n_24_2_10 n_25_2_10 466.4111907612499
R20189 n_24_2_10 n_24_3_10 158.75095666212593
R20190 n_24_2_10 n_24_2_11 0.15994008246498112
R20191 n_24_2_11 n_25_2_11 466.41119076125585
R20192 n_24_2_11 n_24_3_11 158.75095666212795
R20193 n_24_2_11 n_24_2_12 0.1599400824649806
R20194 n_24_2_12 n_25_2_12 466.411190761253
R20195 n_24_2_12 n_24_3_12 158.7509566621269
R20196 n_24_2_12 n_24_2_13 0.15994008246498215
R20197 n_24_2_13 n_25_2_13 466.411190761247
R20198 n_24_2_13 n_24_3_13 158.75095666212493
R20199 n_24_2_13 n_24_2_14 0.7997004123249127
R20200 n_24_2_14 n_25_2_14 51.82346564013877
R20201 n_24_2_14 n_24_3_14 17.638995184680617
R20202 n_24_2_14 n_24_2_15 24.710742740840033
R20203 n_24_2_15 n_25_2_15 17140.61126047573
R20204 n_24_2_15 n_24_3_15 5834.097657333058
R20205 n_24_3_0 n_25_3_0 244.8658751496557
R20206 n_24_3_0 n_24_4_0 43.561715139230984
R20207 n_24_3_0 n_24_3_1 19.792585205041586
R20208 n_24_3_1 n_25_3_1 342.81222520951786
R20209 n_24_3_1 n_24_4_1 60.986401194923374
R20210 n_24_3_1 n_24_3_2 44.98314819327633
R20211 n_24_3_2 n_25_3_2 612.1646878741392
R20212 n_24_3_2 n_24_4_2 108.90428784807744
R20213 n_24_3_2 n_24_3_3 42.104226708906644
R20214 n_24_3_3 n_25_3_3 8570.30563023794
R20215 n_24_3_3 n_24_4_3 1524.6600298730832
R20216 n_24_3_3 n_24_3_4 0.5597902886274392
R20217 n_24_3_4 n_25_3_4 259.7062312193315
R20218 n_24_3_4 n_24_4_4 46.20181908706312
R20219 n_24_3_4 n_24_3_5 0.4626838099879854
R20220 n_24_3_5 n_25_3_5 1632.4391676643693
R20221 n_24_3_5 n_24_3_6 0.15994008246498265
R20222 n_24_3_6 n_25_3_6 272.07319461072825
R20223 n_24_3_6 n_24_3_7 0.21706154048819049
R20224 n_24_3_7 n_25_3_7 466.4111907612499
R20225 n_24_3_7 n_24_3_8 0.15994008246498215
R20226 n_24_3_8 n_25_3_8 466.4111907612499
R20227 n_24_3_8 n_24_3_9 0.15994008246498215
R20228 n_24_3_9 n_25_3_9 466.4111907612499
R20229 n_24_3_9 n_24_3_10 0.15994008246498215
R20230 n_24_3_10 n_25_3_10 466.4111907612499
R20231 n_24_3_10 n_24_3_11 0.15994008246498112
R20232 n_24_3_11 n_25_3_11 466.41119076125585
R20233 n_24_3_11 n_24_3_12 0.1599400824649806
R20234 n_24_3_12 n_25_3_12 466.411190761253
R20235 n_24_3_12 n_24_3_13 0.15994008246498215
R20236 n_24_3_13 n_25_3_13 466.411190761247
R20237 n_24_3_13 n_24_3_14 0.7997004123249127
R20238 n_24_3_14 n_25_3_14 51.82346564013877
R20239 n_24_3_14 n_24_3_15 24.710742740840033
R20240 n_24_3_15 n_25_3_15 17140.61126047573
R20241 n_24_3_15 n_24_4_15 3049.320059746139
R20242 n_24_4_0 n_25_4_0 5400.159267103217
R20243 n_24_4_0 n_24_5_0 3.779178030846073
R20244 n_24_4_0 n_24_4_1 436.49656102391225
R20245 n_24_4_1 n_25_4_1 7560.222973944504
R20246 n_24_4_1 n_24_5_1 5.290849243184502
R20247 n_24_4_1 n_24_4_2 992.0376386907095
R20248 n_24_4_2 n_25_4_2 13500.398167758043
R20249 n_24_4_2 n_24_5_2 9.447945077115182
R20250 n_24_4_2 n_24_4_3 928.547229814504
R20251 n_24_4_3 n_25_4_3 189005.57434861246
R20252 n_24_4_3 n_24_5_3 132.27123107961245
R20253 n_24_4_3 n_24_4_4 12.345357281484397
R20254 n_24_4_4 n_25_4_4 5727.441646927649
R20255 n_24_4_4 n_24_5_4 4.008219123624619
R20256 n_24_4_15 n_25_4_15 378011.14869722154
R20257 n_24_4_15 n_24_5_15 264.5424621592225
R20258 n_24_5_0 n_25_5_0 5400.159267103122
R20259 n_24_5_0 n_24_6_0 3.7791780308461065
R20260 n_24_5_0 n_24_5_1 436.49656102390446
R20261 n_24_5_1 n_25_5_1 7560.222973944369
R20262 n_24_5_1 n_24_6_1 5.290849243184549
R20263 n_24_5_1 n_24_5_2 992.0376386906918
R20264 n_24_5_2 n_25_5_2 13500.398167757803
R20265 n_24_5_2 n_24_6_2 9.447945077115266
R20266 n_24_5_2 n_24_5_3 928.5472298144875
R20267 n_24_5_3 n_25_5_3 189005.57434860908
R20268 n_24_5_3 n_24_6_3 132.2712310796136
R20269 n_24_5_3 n_24_5_4 12.345357281484178
R20270 n_24_5_4 n_25_5_4 5727.4416469275475
R20271 n_24_5_4 n_24_6_4 4.008219123624655
R20272 n_24_5_15 n_25_5_15 378011.1486972148
R20273 n_24_5_15 n_24_6_15 264.5424621592249
R20274 n_24_6_0 n_25_6_0 5400.159267103122
R20275 n_24_6_0 n_24_7_0 3.779178030846073
R20276 n_24_6_0 n_24_6_1 436.49656102390446
R20277 n_24_6_1 n_25_6_1 7560.222973944369
R20278 n_24_6_1 n_24_7_1 5.290849243184502
R20279 n_24_6_1 n_24_6_2 992.0376386906918
R20280 n_24_6_2 n_25_6_2 13500.398167757803
R20281 n_24_6_2 n_24_7_2 9.447945077115182
R20282 n_24_6_2 n_24_6_3 928.5472298144875
R20283 n_24_6_3 n_25_6_3 189005.57434860908
R20284 n_24_6_3 n_24_7_3 132.27123107961245
R20285 n_24_6_3 n_24_6_4 12.345357281484178
R20286 n_24_6_4 n_25_6_4 5727.4416469275475
R20287 n_24_6_4 n_24_7_4 4.008219123624619
R20288 n_24_6_15 n_25_6_15 378011.1486972148
R20289 n_24_6_15 n_24_7_15 264.5424621592225
R20290 n_24_7_0 n_25_7_0 5400.159267103217
R20291 n_24_7_0 n_24_8_0 110.44365038628528
R20292 n_24_7_0 n_24_7_1 436.49656102391225
R20293 n_24_7_1 n_25_7_1 7560.222973944504
R20294 n_24_7_1 n_24_8_1 154.62111054079944
R20295 n_24_7_1 n_24_7_2 992.0376386907095
R20296 n_24_7_2 n_25_7_2 13500.398167758043
R20297 n_24_7_2 n_24_8_2 276.10912596571325
R20298 n_24_7_2 n_24_7_3 928.547229814504
R20299 n_24_7_3 n_25_7_3 189005.57434861246
R20300 n_24_7_3 n_24_8_3 3865.5277635199823
R20301 n_24_7_3 n_24_7_4 12.345357281484397
R20302 n_24_7_4 n_25_7_4 5727.441646927649
R20303 n_24_7_4 n_24_8_4 117.13720495515096
R20304 n_24_7_15 n_25_7_15 378011.14869722154
R20305 n_24_7_15 n_24_8_15 7731.055527039895
R20306 n_24_8_0 n_25_8_0 93.99999874525203
R20307 n_24_8_0 n_24_9_0 217.10812274172463
R20308 n_24_8_0 n_24_8_1 7.598049272084611
R20309 n_24_8_1 n_25_8_1 131.59999824335281
R20310 n_24_8_1 n_24_9_1 303.9513718384145
R20311 n_24_8_1 n_24_8_2 17.268293800192296
R20312 n_24_8_2 n_25_8_2 234.99999686313004
R20313 n_24_8_2 n_24_9_2 542.7703068543115
R20314 n_24_8_2 n_24_8_3 16.16312299697999
R20315 n_24_8_3 n_25_8_3 3289.999956083818
R20316 n_24_8_3 n_24_9_3 7598.784295960355
R20317 n_24_8_3 n_24_8_4 0.2148943228468377
R20318 n_24_8_4 n_25_8_4 99.6969683661763
R20319 n_24_8_4 n_24_9_4 230.26619078667744
R20320 n_24_8_4 n_24_8_5 0.2148943228468377
R20321 n_24_8_5 n_25_8_5 3289.999956083818
R20322 n_24_8_5 n_24_9_5 7598.784295960355
R20323 n_24_8_5 n_24_8_6 0.4144390512046156
R20324 n_24_8_6 n_25_8_6 731.1111013519594
R20325 n_24_8_6 n_24_9_6 1688.6187324356342
R20326 n_24_8_6 n_24_8_7 0.5832845905842732
R20327 n_24_8_7 n_25_8_7 1253.333316603363
R20328 n_24_8_7 n_24_9_7 2894.774969889668
R20329 n_24_8_7 n_24_8_8 0.4297886456936741
R20330 n_24_8_8 n_25_8_8 1253.333316603363
R20331 n_24_8_8 n_24_9_8 2894.774969889668
R20332 n_24_8_8 n_24_8_9 0.4297886456936741
R20333 n_24_8_9 n_25_8_9 1253.333316603363
R20334 n_24_8_9 n_24_9_9 2894.774969889668
R20335 n_24_8_9 n_24_8_10 0.4297886456936741
R20336 n_24_8_10 n_25_8_10 1253.333316603363
R20337 n_24_8_10 n_24_9_10 2894.774969889668
R20338 n_24_8_10 n_24_8_11 0.42978864569367137
R20339 n_24_8_11 n_25_8_11 1253.333316603379
R20340 n_24_8_11 n_24_9_11 2894.774969889705
R20341 n_24_8_11 n_24_8_12 0.4297886456936699
R20342 n_24_8_12 n_25_8_12 1253.333316603371
R20343 n_24_8_12 n_24_9_12 2894.7749698896864
R20344 n_24_8_12 n_24_8_13 0.42978864569367403
R20345 n_24_8_13 n_25_8_13 1253.3333166033551
R20346 n_24_8_13 n_24_9_13 2894.77496988965
R20347 n_24_8_13 n_24_8_14 2.148943228468376
R20348 n_24_8_14 n_25_8_14 139.25925740037337
R20349 n_24_8_14 n_24_9_14 321.64166332107345
R20350 n_24_8_14 n_24_8_15 11.14380559905752
R20351 n_24_8_15 n_25_8_15 6579.999912167577
R20352 n_24_8_15 n_24_9_15 15197.568591920575
R20353 n_24_9_0 n_25_9_0 93.99999874525196
R20354 n_24_9_0 n_24_10_0 217.10812274172463
R20355 n_24_9_0 n_24_9_1 7.598049272084607
R20356 n_24_9_1 n_25_9_1 131.59999824335276
R20357 n_24_9_1 n_24_10_1 303.9513718384145
R20358 n_24_9_1 n_24_9_2 17.268293800192286
R20359 n_24_9_2 n_25_9_2 234.9999968631299
R20360 n_24_9_2 n_24_10_2 542.7703068543115
R20361 n_24_9_2 n_24_9_3 16.16312299697998
R20362 n_24_9_3 n_25_9_3 3289.999956083816
R20363 n_24_9_3 n_24_10_3 7598.784295960355
R20364 n_24_9_3 n_24_9_4 0.21489432284683754
R20365 n_24_9_4 n_25_9_4 99.69696836617624
R20366 n_24_9_4 n_24_10_4 230.26619078667744
R20367 n_24_9_4 n_24_9_5 0.21489432284683754
R20368 n_24_9_5 n_25_9_5 3289.999956083816
R20369 n_24_9_5 n_24_10_5 7598.784295960355
R20370 n_24_9_5 n_24_9_6 0.41443905120461527
R20371 n_24_9_6 n_25_9_6 731.111101351959
R20372 n_24_9_6 n_24_10_6 1688.6187324356342
R20373 n_24_9_6 n_24_9_7 0.5832845905842726
R20374 n_24_9_7 n_25_9_7 1253.3333166033622
R20375 n_24_9_7 n_24_10_7 2894.774969889668
R20376 n_24_9_7 n_24_9_8 0.4297886456936737
R20377 n_24_9_8 n_25_9_8 1253.3333166033622
R20378 n_24_9_8 n_24_10_8 2894.774969889668
R20379 n_24_9_8 n_24_9_9 0.4297886456936737
R20380 n_24_9_9 n_25_9_9 1253.3333166033622
R20381 n_24_9_9 n_24_10_9 2894.774969889668
R20382 n_24_9_9 n_24_9_10 0.4297886456936737
R20383 n_24_9_10 n_25_9_10 1253.3333166033622
R20384 n_24_9_10 n_24_10_10 2894.774969889668
R20385 n_24_9_10 n_24_9_11 0.429788645693671
R20386 n_24_9_11 n_25_9_11 1253.3333166033783
R20387 n_24_9_11 n_24_10_11 2894.774969889705
R20388 n_24_9_11 n_24_9_12 0.4297886456936696
R20389 n_24_9_12 n_25_9_12 1253.3333166033703
R20390 n_24_9_12 n_24_10_12 2894.7749698896864
R20391 n_24_9_12 n_24_9_13 0.4297886456936737
R20392 n_24_9_13 n_25_9_13 1253.3333166033542
R20393 n_24_9_13 n_24_10_13 2894.77496988965
R20394 n_24_9_13 n_24_9_14 2.148943228468374
R20395 n_24_9_14 n_25_9_14 139.2592574003733
R20396 n_24_9_14 n_24_10_14 321.64166332107345
R20397 n_24_9_14 n_24_9_15 11.143805599057513
R20398 n_24_9_15 n_25_9_15 6579.999912167574
R20399 n_24_9_15 n_24_10_15 15197.568591920575
R20400 n_24_10_0 n_25_10_0 93.99999874525203
R20401 n_24_10_0 n_24_11_0 217.10812274172454
R20402 n_24_10_0 n_24_10_1 7.598049272084611
R20403 n_24_10_1 n_25_10_1 131.59999824335281
R20404 n_24_10_1 n_24_11_1 303.9513718384144
R20405 n_24_10_1 n_24_10_2 17.268293800192296
R20406 n_24_10_2 n_25_10_2 234.99999686313004
R20407 n_24_10_2 n_24_11_2 542.7703068543113
R20408 n_24_10_2 n_24_10_3 16.16312299697999
R20409 n_24_10_3 n_25_10_3 3289.999956083818
R20410 n_24_10_3 n_24_11_3 7598.784295960353
R20411 n_24_10_3 n_24_10_4 0.2148943228468377
R20412 n_24_10_4 n_25_10_4 99.6969683661763
R20413 n_24_10_4 n_24_11_4 230.26619078667736
R20414 n_24_10_4 n_24_10_5 0.2148943228468377
R20415 n_24_10_5 n_25_10_5 3289.999956083818
R20416 n_24_10_5 n_24_11_5 7598.784295960353
R20417 n_24_10_5 n_24_10_6 0.4144390512046156
R20418 n_24_10_6 n_25_10_6 731.1111013519594
R20419 n_24_10_6 n_24_11_6 1688.6187324356338
R20420 n_24_10_6 n_24_10_7 0.5832845905842732
R20421 n_24_10_7 n_25_10_7 1253.333316603363
R20422 n_24_10_7 n_24_11_7 2894.774969889667
R20423 n_24_10_7 n_24_10_8 0.4297886456936741
R20424 n_24_10_8 n_25_10_8 1253.333316603363
R20425 n_24_10_8 n_24_11_8 2894.774969889667
R20426 n_24_10_8 n_24_10_9 0.4297886456936741
R20427 n_24_10_9 n_25_10_9 1253.333316603363
R20428 n_24_10_9 n_24_11_9 2894.774969889667
R20429 n_24_10_9 n_24_10_10 0.4297886456936741
R20430 n_24_10_10 n_25_10_10 1253.333316603363
R20431 n_24_10_10 n_24_11_10 2894.774969889667
R20432 n_24_10_10 n_24_10_11 0.42978864569367137
R20433 n_24_10_11 n_25_10_11 1253.333316603379
R20434 n_24_10_11 n_24_11_11 2894.774969889704
R20435 n_24_10_11 n_24_10_12 0.4297886456936699
R20436 n_24_10_12 n_25_10_12 1253.333316603371
R20437 n_24_10_12 n_24_11_12 2894.7749698896855
R20438 n_24_10_12 n_24_10_13 0.42978864569367403
R20439 n_24_10_13 n_25_10_13 1253.3333166033551
R20440 n_24_10_13 n_24_11_13 2894.774969889649
R20441 n_24_10_13 n_24_10_14 2.148943228468376
R20442 n_24_10_14 n_25_10_14 139.25925740037337
R20443 n_24_10_14 n_24_11_14 321.6416633210734
R20444 n_24_10_14 n_24_10_15 11.14380559905752
R20445 n_24_10_15 n_25_10_15 6579.999912167577
R20446 n_24_10_15 n_24_11_15 15197.56859192057
R20447 n_24_11_0 n_25_11_0 93.99999874525203
R20448 n_24_11_0 n_24_12_0 110.44365362970504
R20449 n_24_11_0 n_24_11_1 7.598049272084611
R20450 n_24_11_1 n_25_11_1 131.59999824335281
R20451 n_24_11_1 n_24_12_1 154.62111508158705
R20452 n_24_11_1 n_24_11_2 17.268293800192296
R20453 n_24_11_2 n_25_11_2 234.99999686313004
R20454 n_24_11_2 n_24_12_2 276.10913407426256
R20455 n_24_11_2 n_24_11_3 16.16312299697999
R20456 n_24_11_3 n_25_11_3 3289.999956083818
R20457 n_24_11_3 n_24_12_3 3865.527877039673
R20458 n_24_11_3 n_24_11_4 0.2148943228468377
R20459 n_24_11_4 n_25_11_4 99.6969683661763
R20460 n_24_11_4 n_24_12_4 117.13720839514161
R20461 n_24_11_4 n_24_11_5 0.2148943228468377
R20462 n_24_11_5 n_25_11_5 3289.999956083818
R20463 n_24_11_5 n_24_11_6 0.4144390512046156
R20464 n_24_11_6 n_25_11_6 731.1111013519594
R20465 n_24_11_6 n_24_11_7 0.5832845905842732
R20466 n_24_11_7 n_25_11_7 1253.333316603363
R20467 n_24_11_7 n_24_11_8 0.4297886456936741
R20468 n_24_11_8 n_25_11_8 1253.333316603363
R20469 n_24_11_8 n_24_11_9 0.4297886456936741
R20470 n_24_11_9 n_25_11_9 1253.333316603363
R20471 n_24_11_9 n_24_11_10 0.4297886456936741
R20472 n_24_11_10 n_25_11_10 1253.333316603363
R20473 n_24_11_10 n_24_11_11 0.42978864569367137
R20474 n_24_11_11 n_25_11_11 1253.333316603379
R20475 n_24_11_11 n_24_11_12 0.4297886456936699
R20476 n_24_11_12 n_25_11_12 1253.333316603371
R20477 n_24_11_12 n_24_11_13 0.42978864569367403
R20478 n_24_11_13 n_25_11_13 1253.3333166033551
R20479 n_24_11_13 n_24_11_14 2.148943228468376
R20480 n_24_11_14 n_25_11_14 139.25925740037337
R20481 n_24_11_14 n_24_11_15 11.14380559905752
R20482 n_24_11_15 n_25_11_15 6579.999912167577
R20483 n_24_11_15 n_24_12_15 7731.055754079277
R20484 n_24_12_0 n_25_12_0 5400.149997916652
R20485 n_24_12_0 n_24_13_0 3.7791845176855245
R20486 n_24_12_0 n_24_12_1 436.4958117926656
R20487 n_24_12_1 n_25_12_1 7560.209997083312
R20488 n_24_12_1 n_24_13_1 5.290858324759735
R20489 n_24_12_1 n_24_12_2 992.0359358924218
R20490 n_24_12_2 n_25_12_2 13500.374994791631
R20491 n_24_12_2 n_24_13_2 9.447961294213812
R20492 n_24_12_2 n_24_12_3 928.5456359953067
R20493 n_24_12_3 n_25_12_3 189005.24992708262
R20494 n_24_12_3 n_24_13_3 132.27145811899325
R20495 n_24_12_3 n_24_12_4 12.345336091105704
R20496 n_24_12_4 n_25_12_4 5727.431815972202
R20497 n_24_12_4 n_24_13_4 4.008226003605856
R20498 n_24_12_15 n_25_12_15 378010.4998541619
R20499 n_24_12_15 n_24_13_15 264.5429162379842
R20500 n_24_13_0 n_25_13_0 5400.149997916652
R20501 n_24_13_0 n_24_14_0 3.7791845176855245
R20502 n_24_13_0 n_24_13_1 436.4958117926656
R20503 n_24_13_1 n_25_13_1 7560.209997083312
R20504 n_24_13_1 n_24_14_1 5.290858324759735
R20505 n_24_13_1 n_24_13_2 992.0359358924218
R20506 n_24_13_2 n_25_13_2 13500.374994791631
R20507 n_24_13_2 n_24_14_2 9.447961294213812
R20508 n_24_13_2 n_24_13_3 928.5456359953067
R20509 n_24_13_3 n_25_13_3 189005.24992708262
R20510 n_24_13_3 n_24_14_3 132.27145811899325
R20511 n_24_13_3 n_24_13_4 12.345336091105704
R20512 n_24_13_4 n_25_13_4 5727.431815972202
R20513 n_24_13_4 n_24_14_4 4.008226003605856
R20514 n_24_13_15 n_25_13_15 378010.4998541619
R20515 n_24_13_15 n_24_14_15 264.5429162379842
R20516 n_24_14_0 n_25_14_0 5400.149997916652
R20517 n_24_14_0 n_24_15_0 3.7791845176855245
R20518 n_24_14_0 n_24_14_1 436.4958117926656
R20519 n_24_14_1 n_25_14_1 7560.209997083312
R20520 n_24_14_1 n_24_15_1 5.290858324759735
R20521 n_24_14_1 n_24_14_2 992.0359358924218
R20522 n_24_14_2 n_25_14_2 13500.374994791631
R20523 n_24_14_2 n_24_15_2 9.447961294213812
R20524 n_24_14_2 n_24_14_3 928.5456359953067
R20525 n_24_14_3 n_25_14_3 189005.24992708262
R20526 n_24_14_3 n_24_15_3 132.27145811899325
R20527 n_24_14_3 n_24_14_4 12.345336091105704
R20528 n_24_14_4 n_25_14_4 5727.431815972202
R20529 n_24_14_4 n_24_15_4 4.008226003605856
R20530 n_24_14_15 n_25_14_15 378010.4998541619
R20531 n_24_14_15 n_24_15_15 264.5429162379842
R20532 n_24_15_0 n_25_15_0 5400.149997916652
R20533 n_24_15_0 n_24_16_0 110.44365362970498
R20534 n_24_15_0 n_24_15_1 436.4958117926656
R20535 n_24_15_1 n_25_15_1 7560.209997083312
R20536 n_24_15_1 n_24_16_1 154.62111508158694
R20537 n_24_15_1 n_24_15_2 992.0359358924218
R20538 n_24_15_2 n_25_15_2 13500.374994791631
R20539 n_24_15_2 n_24_16_2 276.1091340742624
R20540 n_24_15_2 n_24_15_3 928.5456359953067
R20541 n_24_15_3 n_25_15_3 189005.24992708262
R20542 n_24_15_3 n_24_16_3 3865.527877039671
R20543 n_24_15_3 n_24_15_4 12.345336091105704
R20544 n_24_15_4 n_25_15_4 5727.431815972202
R20545 n_24_15_4 n_24_16_4 117.13720839514153
R20546 n_24_15_15 n_25_15_15 378010.4998541619
R20547 n_24_15_15 n_24_16_15 7731.055754079272
R20548 n_24_16_0 n_25_16_0 93.9999987452521
R20549 n_24_16_0 n_24_17_0 217.10812274172457
R20550 n_24_16_0 n_24_16_1 7.598049272084617
R20551 n_24_16_1 n_25_16_1 131.5999982433529
R20552 n_24_16_1 n_24_17_1 303.9513718384144
R20553 n_24_16_1 n_24_16_2 17.26829380019231
R20554 n_24_16_2 n_25_16_2 234.9999968631302
R20555 n_24_16_2 n_24_17_2 542.7703068543113
R20556 n_24_16_2 n_24_16_3 16.16312299698
R20557 n_24_16_3 n_25_16_3 3289.9999560838196
R20558 n_24_16_3 n_24_17_3 7598.784295960353
R20559 n_24_16_3 n_24_16_4 0.21489432284683782
R20560 n_24_16_4 n_25_16_4 99.69696836617634
R20561 n_24_16_4 n_24_17_4 230.26619078667736
R20562 n_24_16_4 n_24_16_5 0.21489432284683782
R20563 n_24_16_5 n_25_16_5 3289.9999560838196
R20564 n_24_16_5 n_24_17_5 7598.784295960353
R20565 n_24_16_5 n_24_16_6 0.4144390512046158
R20566 n_24_16_6 n_25_16_6 731.11110135196
R20567 n_24_16_6 n_24_17_6 1688.6187324356338
R20568 n_24_16_6 n_24_16_7 0.5832845905842734
R20569 n_24_16_7 n_25_16_7 1253.3333166033638
R20570 n_24_16_7 n_24_17_7 2894.774969889667
R20571 n_24_16_7 n_24_16_8 0.4297886456936743
R20572 n_24_16_8 n_25_16_8 1253.3333166033638
R20573 n_24_16_8 n_24_17_8 2894.774969889667
R20574 n_24_16_8 n_24_16_9 0.4297886456936743
R20575 n_24_16_9 n_25_16_9 1253.3333166033638
R20576 n_24_16_9 n_24_17_9 2894.774969889667
R20577 n_24_16_9 n_24_16_10 0.4297886456936743
R20578 n_24_16_10 n_25_16_10 1253.3333166033638
R20579 n_24_16_10 n_24_17_10 2894.774969889667
R20580 n_24_16_10 n_24_16_11 0.4297886456936716
R20581 n_24_16_11 n_25_16_11 1253.3333166033797
R20582 n_24_16_11 n_24_17_11 2894.774969889704
R20583 n_24_16_11 n_24_16_12 0.42978864569367015
R20584 n_24_16_12 n_25_16_12 1253.3333166033717
R20585 n_24_16_12 n_24_17_12 2894.7749698896855
R20586 n_24_16_12 n_24_16_13 0.42978864569367425
R20587 n_24_16_13 n_25_16_13 1253.333316603356
R20588 n_24_16_13 n_24_17_13 2894.774969889649
R20589 n_24_16_13 n_24_16_14 2.1489432284683767
R20590 n_24_16_14 n_25_16_14 139.25925740037346
R20591 n_24_16_14 n_24_17_14 321.6416633210734
R20592 n_24_16_14 n_24_16_15 11.143805599057526
R20593 n_24_16_15 n_25_16_15 6579.999912167581
R20594 n_24_16_15 n_24_17_15 15197.56859192057
R20595 n_24_17_0 n_25_17_0 93.99999874525196
R20596 n_24_17_0 n_24_18_0 217.10812274172469
R20597 n_24_17_0 n_24_17_1 7.598049272084607
R20598 n_24_17_1 n_25_17_1 131.59999824335276
R20599 n_24_17_1 n_24_18_1 303.95137183841456
R20600 n_24_17_1 n_24_17_2 17.268293800192286
R20601 n_24_17_2 n_25_17_2 234.9999968631299
R20602 n_24_17_2 n_24_18_2 542.7703068543117
R20603 n_24_17_2 n_24_17_3 16.16312299697998
R20604 n_24_17_3 n_25_17_3 3289.999956083816
R20605 n_24_17_3 n_24_18_3 7598.784295960358
R20606 n_24_17_3 n_24_17_4 0.21489432284683754
R20607 n_24_17_4 n_25_17_4 99.69696836617624
R20608 n_24_17_4 n_24_18_4 230.2661907866775
R20609 n_24_17_4 n_24_17_5 0.21489432284683754
R20610 n_24_17_5 n_25_17_5 3289.999956083816
R20611 n_24_17_5 n_24_18_5 7598.784295960358
R20612 n_24_17_5 n_24_17_6 0.41443905120461527
R20613 n_24_17_6 n_25_17_6 731.111101351959
R20614 n_24_17_6 n_24_18_6 1688.6187324356347
R20615 n_24_17_6 n_24_17_7 0.5832845905842726
R20616 n_24_17_7 n_25_17_7 1253.3333166033622
R20617 n_24_17_7 n_24_18_7 2894.7749698896687
R20618 n_24_17_7 n_24_17_8 0.4297886456936737
R20619 n_24_17_8 n_25_17_8 1253.3333166033622
R20620 n_24_17_8 n_24_18_8 2894.7749698896687
R20621 n_24_17_8 n_24_17_9 0.4297886456936737
R20622 n_24_17_9 n_25_17_9 1253.3333166033622
R20623 n_24_17_9 n_24_18_9 2894.7749698896687
R20624 n_24_17_9 n_24_17_10 0.4297886456936737
R20625 n_24_17_10 n_25_17_10 1253.3333166033622
R20626 n_24_17_10 n_24_18_10 2894.7749698896687
R20627 n_24_17_10 n_24_17_11 0.429788645693671
R20628 n_24_17_11 n_25_17_11 1253.3333166033783
R20629 n_24_17_11 n_24_18_11 2894.774969889706
R20630 n_24_17_11 n_24_17_12 0.4297886456936696
R20631 n_24_17_12 n_25_17_12 1253.3333166033703
R20632 n_24_17_12 n_24_18_12 2894.7749698896873
R20633 n_24_17_12 n_24_17_13 0.4297886456936737
R20634 n_24_17_13 n_25_17_13 1253.3333166033542
R20635 n_24_17_13 n_24_18_13 2894.774969889651
R20636 n_24_17_13 n_24_17_14 2.148943228468374
R20637 n_24_17_14 n_25_17_14 139.2592574003733
R20638 n_24_17_14 n_24_18_14 321.64166332107357
R20639 n_24_17_14 n_24_17_15 11.143805599057513
R20640 n_24_17_15 n_25_17_15 6579.999912167574
R20641 n_24_17_15 n_24_18_15 15197.568591920579
R20642 n_24_18_0 n_25_18_0 93.99999874525196
R20643 n_24_18_0 n_24_19_0 217.10812274172457
R20644 n_24_18_0 n_24_18_1 7.598049272084607
R20645 n_24_18_1 n_25_18_1 131.59999824335276
R20646 n_24_18_1 n_24_19_1 303.9513718384144
R20647 n_24_18_1 n_24_18_2 17.268293800192286
R20648 n_24_18_2 n_25_18_2 234.9999968631299
R20649 n_24_18_2 n_24_19_2 542.7703068543113
R20650 n_24_18_2 n_24_18_3 16.16312299697998
R20651 n_24_18_3 n_25_18_3 3289.999956083816
R20652 n_24_18_3 n_24_19_3 7598.784295960353
R20653 n_24_18_3 n_24_18_4 0.21489432284683754
R20654 n_24_18_4 n_25_18_4 99.69696836617624
R20655 n_24_18_4 n_24_19_4 230.26619078667736
R20656 n_24_18_4 n_24_18_5 0.21489432284683754
R20657 n_24_18_5 n_25_18_5 3289.999956083816
R20658 n_24_18_5 n_24_19_5 7598.784295960353
R20659 n_24_18_5 n_24_18_6 0.41443905120461527
R20660 n_24_18_6 n_25_18_6 731.111101351959
R20661 n_24_18_6 n_24_19_6 1688.6187324356338
R20662 n_24_18_6 n_24_18_7 0.5832845905842726
R20663 n_24_18_7 n_25_18_7 1253.3333166033622
R20664 n_24_18_7 n_24_19_7 2894.774969889667
R20665 n_24_18_7 n_24_18_8 0.4297886456936737
R20666 n_24_18_8 n_25_18_8 1253.3333166033622
R20667 n_24_18_8 n_24_19_8 2894.774969889667
R20668 n_24_18_8 n_24_18_9 0.4297886456936737
R20669 n_24_18_9 n_25_18_9 1253.3333166033622
R20670 n_24_18_9 n_24_19_9 2894.774969889667
R20671 n_24_18_9 n_24_18_10 0.4297886456936737
R20672 n_24_18_10 n_25_18_10 1253.3333166033622
R20673 n_24_18_10 n_24_19_10 2894.774969889667
R20674 n_24_18_10 n_24_18_11 0.429788645693671
R20675 n_24_18_11 n_25_18_11 1253.3333166033783
R20676 n_24_18_11 n_24_19_11 2894.774969889704
R20677 n_24_18_11 n_24_18_12 0.4297886456936696
R20678 n_24_18_12 n_25_18_12 1253.3333166033703
R20679 n_24_18_12 n_24_19_12 2894.7749698896855
R20680 n_24_18_12 n_24_18_13 0.4297886456936737
R20681 n_24_18_13 n_25_18_13 1253.3333166033542
R20682 n_24_18_13 n_24_19_13 2894.774969889649
R20683 n_24_18_13 n_24_18_14 2.148943228468374
R20684 n_24_18_14 n_25_18_14 139.2592574003733
R20685 n_24_18_14 n_24_19_14 321.6416633210734
R20686 n_24_18_14 n_24_18_15 11.143805599057513
R20687 n_24_18_15 n_25_18_15 6579.999912167574
R20688 n_24_18_15 n_24_19_15 15197.56859192057
R20689 n_24_19_0 n_25_19_0 93.9999987452521
R20690 n_24_19_0 n_24_20_0 110.44365397508213
R20691 n_24_19_0 n_24_19_1 7.598049272084617
R20692 n_24_19_1 n_25_19_1 131.5999982433529
R20693 n_24_19_1 n_24_20_1 154.62111556511496
R20694 n_24_19_1 n_24_19_2 17.26829380019231
R20695 n_24_19_2 n_25_19_2 234.9999968631302
R20696 n_24_19_2 n_24_20_2 276.1091349377053
R20697 n_24_19_2 n_24_19_3 16.16312299698
R20698 n_24_19_3 n_25_19_3 3289.9999560838196
R20699 n_24_19_3 n_24_20_3 3865.5278891278713
R20700 n_24_19_3 n_24_19_4 0.21489432284683782
R20701 n_24_19_4 n_25_19_4 99.69696836617634
R20702 n_24_19_4 n_24_20_4 117.13720876145064
R20703 n_24_19_4 n_24_19_5 0.21489432284683782
R20704 n_24_19_5 n_25_19_5 3289.9999560838196
R20705 n_24_19_5 n_24_19_6 0.4144390512046158
R20706 n_24_19_6 n_25_19_6 731.11110135196
R20707 n_24_19_6 n_24_19_7 0.5832845905842734
R20708 n_24_19_7 n_25_19_7 1253.3333166033638
R20709 n_24_19_7 n_24_19_8 0.4297886456936743
R20710 n_24_19_8 n_25_19_8 1253.3333166033638
R20711 n_24_19_8 n_24_19_9 0.4297886456936743
R20712 n_24_19_9 n_25_19_9 1253.3333166033638
R20713 n_24_19_9 n_24_19_10 0.4297886456936743
R20714 n_24_19_10 n_25_19_10 1253.3333166033638
R20715 n_24_19_10 n_24_19_11 0.4297886456936716
R20716 n_24_19_11 n_25_19_11 1253.3333166033797
R20717 n_24_19_11 n_24_19_12 0.42978864569367015
R20718 n_24_19_12 n_25_19_12 1253.3333166033717
R20719 n_24_19_12 n_24_19_13 0.42978864569367425
R20720 n_24_19_13 n_25_19_13 1253.333316603356
R20721 n_24_19_13 n_24_19_14 2.1489432284683767
R20722 n_24_19_14 n_25_19_14 139.25925740037346
R20723 n_24_19_14 n_24_19_15 11.143805599057526
R20724 n_24_19_15 n_25_19_15 6579.999912167581
R20725 n_24_19_15 n_24_20_15 7731.0557782556725
R20726 n_24_20_0 n_25_20_0 5400.149010884635
R20727 n_24_20_0 n_24_21_0 3.7791852084398188
R20728 n_24_20_0 n_24_20_1 436.4957320105592
R20729 n_24_20_1 n_25_20_1 7560.208615238486
R20730 n_24_20_1 n_24_21_1 5.290859291815746
R20731 n_24_20_1 n_24_20_2 992.0357545694527
R20732 n_24_20_2 n_25_20_2 13500.372527211586
R20733 n_24_20_2 n_24_21_2 9.447963021099547
R20734 n_24_20_2 n_24_20_3 928.5454662770078
R20735 n_24_20_3 n_25_20_3 189005.215380962
R20736 n_24_20_3 n_24_21_3 132.27148229539355
R20737 n_24_20_3 n_24_20_4 12.34533383464209
R20738 n_24_20_4 n_25_20_4 5727.430769120061
R20739 n_24_20_4 n_24_21_4 4.008226736224047
R20740 n_24_20_15 n_25_20_15 378010.43076192064
R20741 n_24_20_15 n_24_21_15 264.5429645907847
R20742 n_24_21_0 n_25_21_0 5400.149010884635
R20743 n_24_21_0 n_24_22_0 3.7791852084396846
R20744 n_24_21_0 n_24_21_1 436.4957320105592
R20745 n_24_21_1 n_25_21_1 7560.208615238486
R20746 n_24_21_1 n_24_22_1 5.290859291815558
R20747 n_24_21_1 n_24_21_2 992.0357545694527
R20748 n_24_21_2 n_25_21_2 13500.372527211586
R20749 n_24_21_2 n_24_22_2 9.447963021099211
R20750 n_24_21_2 n_24_21_3 928.5454662770078
R20751 n_24_21_3 n_25_21_3 189005.215380962
R20752 n_24_21_3 n_24_22_3 132.27148229538886
R20753 n_24_21_3 n_24_21_4 12.34533383464209
R20754 n_24_21_4 n_25_21_4 5727.430769120061
R20755 n_24_21_4 n_24_22_4 4.008226736223905
R20756 n_24_21_15 n_25_21_15 378010.43076192064
R20757 n_24_21_15 n_24_22_15 264.54296459077534
R20758 n_24_22_0 n_25_22_0 5400.149010885018
R20759 n_24_22_0 n_24_23_0 3.7791852084396846
R20760 n_24_22_0 n_24_22_1 436.49573201059025
R20761 n_24_22_1 n_25_22_1 7560.208615239025
R20762 n_24_22_1 n_24_23_1 5.290859291815558
R20763 n_24_22_1 n_24_22_2 992.0357545695232
R20764 n_24_22_2 n_25_22_2 13500.372527212545
R20765 n_24_22_2 n_24_23_2 9.447963021099211
R20766 n_24_22_2 n_24_22_3 928.5454662770737
R20767 n_24_22_3 n_25_22_3 189005.21538097545
R20768 n_24_22_3 n_24_23_3 132.27148229538886
R20769 n_24_22_3 n_24_22_4 12.345333834642968
R20770 n_24_22_4 n_25_22_4 5727.430769120468
R20771 n_24_22_4 n_24_23_4 4.008226736223905
R20772 n_24_22_15 n_25_22_15 378010.43076194753
R20773 n_24_22_15 n_24_23_15 264.54296459077534
R20774 n_24_23_0 n_25_23_0 5400.149010884635
R20775 n_24_23_0 n_24_24_0 43.561715139231076
R20776 n_24_23_0 n_24_23_1 436.4957320105592
R20777 n_24_23_1 n_25_23_1 7560.208615238486
R20778 n_24_23_1 n_24_24_1 60.98640119492351
R20779 n_24_23_1 n_24_23_2 992.0357545694527
R20780 n_24_23_2 n_25_23_2 13500.372527211586
R20781 n_24_23_2 n_24_24_2 108.90428784807769
R20782 n_24_23_2 n_24_23_3 928.5454662770078
R20783 n_24_23_3 n_25_23_3 189005.215380962
R20784 n_24_23_3 n_24_24_3 1524.6600298730866
R20785 n_24_23_3 n_24_23_4 12.34533383464209
R20786 n_24_23_4 n_25_23_4 5727.430769120061
R20787 n_24_23_4 n_24_24_4 46.20181908706322
R20788 n_24_23_15 n_25_23_15 378010.43076192064
R20789 n_24_23_15 n_24_24_15 3049.3200597461455
R20790 n_24_24_0 n_25_24_0 244.8658962374672
R20791 n_24_24_0 n_24_25_0 83.3442450700222
R20792 n_24_24_0 n_24_24_1 19.79258690957598
R20793 n_24_24_1 n_25_24_1 342.81225473245405
R20794 n_24_24_1 n_24_25_1 116.68194309803108
R20795 n_24_24_1 n_24_24_2 44.983152067218136
R20796 n_24_24_2 n_25_24_2 612.1647405936681
R20797 n_24_24_2 n_24_25_2 208.3606126750555
R20798 n_24_24_2 n_24_24_3 42.10423033491618
R20799 n_24_24_3 n_25_24_3 8570.306368311345
R20800 n_24_24_3 n_24_25_3 2917.048577450775
R20801 n_24_24_3 n_24_24_4 0.5597903368364929
R20802 n_24_24_4 n_25_24_4 259.70625358519226
R20803 n_24_24_4 n_24_25_4 88.39541143790225
R20804 n_24_24_4 n_24_24_5 0.46268384983424415
R20805 n_24_24_5 n_25_24_5 1632.43930824978
R20806 n_24_24_5 n_24_25_5 555.6283004668143
R20807 n_24_24_5 n_24_24_6 0.15994009623899796
R20808 n_24_24_6 n_25_24_6 272.07321804162996
R20809 n_24_24_6 n_24_25_6 92.60471674446904
R20810 n_24_24_6 n_24_24_7 0.217061559181497
R20811 n_24_24_7 n_25_24_7 466.41123092850995
R20812 n_24_24_7 n_24_25_7 158.75094299051884
R20813 n_24_24_7 n_24_24_8 0.15994009623899746
R20814 n_24_24_8 n_25_24_8 466.41123092850995
R20815 n_24_24_8 n_24_25_8 158.75094299051884
R20816 n_24_24_8 n_24_24_9 0.15994009623899746
R20817 n_24_24_9 n_25_24_9 466.41123092850995
R20818 n_24_24_9 n_24_25_9 158.75094299051884
R20819 n_24_24_9 n_24_24_10 0.15994009623899746
R20820 n_24_24_10 n_25_24_10 466.41123092850995
R20821 n_24_24_10 n_24_25_10 158.75094299051884
R20822 n_24_24_10 n_24_24_11 0.15994009623899644
R20823 n_24_24_11 n_25_24_11 466.4112309285159
R20824 n_24_24_11 n_24_25_11 158.75094299052085
R20825 n_24_24_11 n_24_24_12 0.1599400962389959
R20826 n_24_24_12 n_25_24_12 466.41123092851296
R20827 n_24_24_12 n_24_25_12 158.75094299051983
R20828 n_24_24_12 n_24_24_13 0.15994009623899746
R20829 n_24_24_13 n_25_24_13 466.41123092850705
R20830 n_24_24_13 n_24_25_13 158.75094299051784
R20831 n_24_24_13 n_24_24_14 0.7997004811949894
R20832 n_24_24_14 n_25_24_14 51.823470103167665
R20833 n_24_24_14 n_24_25_14 17.638993665613164
R20834 n_24_24_14 n_24_24_15 24.7107448689254
R20835 n_24_24_15 n_25_24_15 17140.612736622534
R20836 n_24_24_15 n_24_25_15 5834.097154901498
R20837 n_24_25_0 n_25_25_0 244.865896237468
R20838 n_24_25_0 n_24_26_0 83.3442450700222
R20839 n_24_25_0 n_24_25_1 19.792586909576038
R20840 n_24_25_1 n_25_25_1 342.8122547324552
R20841 n_24_25_1 n_24_26_1 116.68194309803108
R20842 n_24_25_1 n_24_25_2 44.983152067218285
R20843 n_24_25_2 n_25_25_2 612.16474059367
R20844 n_24_25_2 n_24_26_2 208.3606126750555
R20845 n_24_25_2 n_24_25_3 42.104230334916316
R20846 n_24_25_3 n_25_25_3 8570.306368311372
R20847 n_24_25_3 n_24_26_3 2917.048577450775
R20848 n_24_25_3 n_24_25_4 0.5597903368364947
R20849 n_24_25_4 n_25_25_4 259.7062535851931
R20850 n_24_25_4 n_24_26_4 88.39541143790225
R20851 n_24_25_4 n_24_25_5 0.46268384983424565
R20852 n_24_25_5 n_25_25_5 1632.439308249785
R20853 n_24_25_5 n_24_26_5 555.6283004668143
R20854 n_24_25_5 n_24_25_6 0.1599400962389985
R20855 n_24_25_6 n_25_25_6 272.07321804163087
R20856 n_24_25_6 n_24_26_6 92.60471674446904
R20857 n_24_25_6 n_24_25_7 0.21706155918149772
R20858 n_24_25_7 n_25_25_7 466.41123092851154
R20859 n_24_25_7 n_24_26_7 158.75094299051884
R20860 n_24_25_7 n_24_25_8 0.159940096238998
R20861 n_24_25_8 n_25_25_8 466.41123092851154
R20862 n_24_25_8 n_24_26_8 158.75094299051884
R20863 n_24_25_8 n_24_25_9 0.159940096238998
R20864 n_24_25_9 n_25_25_9 466.41123092851154
R20865 n_24_25_9 n_24_26_9 158.75094299051884
R20866 n_24_25_9 n_24_25_10 0.159940096238998
R20867 n_24_25_10 n_25_25_10 466.41123092851154
R20868 n_24_25_10 n_24_26_10 158.75094299051884
R20869 n_24_25_10 n_24_25_11 0.15994009623899696
R20870 n_24_25_11 n_25_25_11 466.41123092851745
R20871 n_24_25_11 n_24_26_11 158.75094299052085
R20872 n_24_25_11 n_24_25_12 0.15994009623899647
R20873 n_24_25_12 n_25_25_12 466.4112309285143
R20874 n_24_25_12 n_24_26_12 158.75094299051983
R20875 n_24_25_12 n_24_25_13 0.15994009623899796
R20876 n_24_25_13 n_25_25_13 466.4112309285086
R20877 n_24_25_13 n_24_26_13 158.75094299051784
R20878 n_24_25_13 n_24_25_14 0.7997004811949919
R20879 n_24_25_14 n_25_25_14 51.82347010316783
R20880 n_24_25_14 n_24_26_14 17.638993665613164
R20881 n_24_25_14 n_24_25_15 24.71074486892548
R20882 n_24_25_15 n_25_25_15 17140.612736622592
R20883 n_24_25_15 n_24_26_15 5834.097154901498
R20884 n_24_26_0 n_25_26_0 244.8658962374672
R20885 n_24_26_0 n_24_27_0 83.34424507002234
R20886 n_24_26_0 n_24_26_1 19.79258690957598
R20887 n_24_26_1 n_25_26_1 342.81225473245405
R20888 n_24_26_1 n_24_27_1 116.68194309803127
R20889 n_24_26_1 n_24_26_2 44.983152067218136
R20890 n_24_26_2 n_25_26_2 612.1647405936681
R20891 n_24_26_2 n_24_27_2 208.36061267505582
R20892 n_24_26_2 n_24_26_3 42.10423033491618
R20893 n_24_26_3 n_25_26_3 8570.306368311345
R20894 n_24_26_3 n_24_27_3 2917.0485774507797
R20895 n_24_26_3 n_24_26_4 0.5597903368364929
R20896 n_24_26_4 n_25_26_4 259.70625358519226
R20897 n_24_26_4 n_24_27_4 88.3954114379024
R20898 n_24_26_4 n_24_26_5 0.46268384983424415
R20899 n_24_26_5 n_25_26_5 1632.43930824978
R20900 n_24_26_5 n_24_27_5 555.6283004668152
R20901 n_24_26_5 n_24_26_6 0.15994009623899796
R20902 n_24_26_6 n_25_26_6 272.07321804162996
R20903 n_24_26_6 n_24_27_6 92.60471674446919
R20904 n_24_26_6 n_24_26_7 0.217061559181497
R20905 n_24_26_7 n_25_26_7 466.41123092850995
R20906 n_24_26_7 n_24_27_7 158.7509429905191
R20907 n_24_26_7 n_24_26_8 0.15994009623899746
R20908 n_24_26_8 n_25_26_8 466.41123092850995
R20909 n_24_26_8 n_24_27_8 158.7509429905191
R20910 n_24_26_8 n_24_26_9 0.15994009623899746
R20911 n_24_26_9 n_25_26_9 466.41123092850995
R20912 n_24_26_9 n_24_27_9 158.7509429905191
R20913 n_24_26_9 n_24_26_10 0.15994009623899746
R20914 n_24_26_10 n_25_26_10 466.41123092850995
R20915 n_24_26_10 n_24_27_10 158.7509429905191
R20916 n_24_26_10 n_24_26_11 0.15994009623899644
R20917 n_24_26_11 n_25_26_11 466.4112309285159
R20918 n_24_26_11 n_24_27_11 158.7509429905211
R20919 n_24_26_11 n_24_26_12 0.1599400962389959
R20920 n_24_26_12 n_25_26_12 466.41123092851296
R20921 n_24_26_12 n_24_27_12 158.7509429905201
R20922 n_24_26_12 n_24_26_13 0.15994009623899746
R20923 n_24_26_13 n_25_26_13 466.41123092850705
R20924 n_24_26_13 n_24_27_13 158.7509429905181
R20925 n_24_26_13 n_24_26_14 0.7997004811949894
R20926 n_24_26_14 n_25_26_14 51.823470103167665
R20927 n_24_26_14 n_24_27_14 17.638993665613192
R20928 n_24_26_14 n_24_26_15 24.7107448689254
R20929 n_24_26_15 n_25_26_15 17140.612736622534
R20930 n_24_26_15 n_24_27_15 5834.097154901507
R20931 n_24_27_0 n_25_27_0 244.8658962374672
R20932 n_24_27_0 n_24_27_1 19.79258690957598
R20933 n_24_27_1 n_25_27_1 342.81225473245405
R20934 n_24_27_1 n_24_27_2 44.983152067218136
R20935 n_24_27_2 n_25_27_2 612.1647405936681
R20936 n_24_27_2 n_24_27_3 42.10423033491618
R20937 n_24_27_3 n_25_27_3 8570.306368311345
R20938 n_24_27_3 n_24_27_4 0.5597903368364929
R20939 n_24_27_4 n_25_27_4 259.70625358519226
R20940 n_24_27_4 n_24_27_5 0.46268384983424415
R20941 n_24_27_5 n_25_27_5 1632.43930824978
R20942 n_24_27_5 n_24_27_6 0.15994009623899796
R20943 n_24_27_6 n_25_27_6 272.07321804162996
R20944 n_24_27_6 n_24_27_7 0.217061559181497
R20945 n_24_27_7 n_25_27_7 466.41123092850995
R20946 n_24_27_7 n_24_27_8 0.15994009623899746
R20947 n_24_27_8 n_25_27_8 466.41123092850995
R20948 n_24_27_8 n_24_27_9 0.15994009623899746
R20949 n_24_27_9 n_25_27_9 466.41123092850995
R20950 n_24_27_9 n_24_27_10 0.15994009623899746
R20951 n_24_27_10 n_25_27_10 466.41123092850995
R20952 n_24_27_10 n_24_27_11 0.15994009623899644
R20953 n_24_27_11 n_25_27_11 466.4112309285159
R20954 n_24_27_11 n_24_27_12 0.1599400962389959
R20955 n_24_27_12 n_25_27_12 466.41123092851296
R20956 n_24_27_12 n_24_27_13 0.15994009623899746
R20957 n_24_27_13 n_25_27_13 466.41123092850705
R20958 n_24_27_13 n_24_27_14 0.7997004811949894
R20959 n_24_27_14 n_25_27_14 51.823470103167665
R20960 n_24_27_14 n_24_27_15 24.7107448689254
R20961 n_24_27_15 n_25_27_15 17140.612736622534
R20962 n_25_0_0 n_26_0_0 244.86587514965544
R20963 n_25_0_0 n_25_1_0 83.34425224761593
R20964 n_25_0_0 n_25_0_1 19.792585205041586
R20965 n_25_0_1 n_26_0_1 342.8122252095176
R20966 n_25_0_1 n_25_1_1 116.6819531466623
R20967 n_25_0_1 n_25_0_2 44.98314819327633
R20968 n_25_0_2 n_26_0_2 612.1646878741385
R20969 n_25_0_2 n_25_1_2 208.3606306190398
R20970 n_25_0_2 n_25_0_3 42.104226708906644
R20971 n_25_0_3 n_26_0_3 8570.30563023793
R20972 n_25_0_3 n_25_1_3 2917.048828666555
R20973 n_25_0_3 n_25_0_4 0.5597902886274392
R20974 n_25_0_4 n_26_0_4 259.70623121933124
R20975 n_25_0_4 n_25_1_4 88.39541905050166
R20976 n_25_0_4 n_25_0_5 0.4626838099879854
R20977 n_25_0_5 n_26_0_5 1632.4391676643677
R20978 n_25_0_5 n_25_1_5 555.6283483174391
R20979 n_25_0_5 n_25_0_6 0.15994008246498265
R20980 n_25_0_6 n_26_0_6 272.073194610728
R20981 n_25_0_6 n_25_1_6 92.60472471957317
R20982 n_25_0_6 n_25_0_7 0.21706154048819049
R20983 n_25_0_7 n_26_0_7 466.41119076124943
R20984 n_25_0_7 n_25_1_7 158.75095666212593
R20985 n_25_0_7 n_25_0_8 0.15994008246498215
R20986 n_25_0_8 n_26_0_8 466.41119076124943
R20987 n_25_0_8 n_25_1_8 158.75095666212593
R20988 n_25_0_8 n_25_0_9 0.15994008246498215
R20989 n_25_0_9 n_26_0_9 466.41119076124943
R20990 n_25_0_9 n_25_1_9 158.75095666212593
R20991 n_25_0_9 n_25_0_10 0.15994008246498215
R20992 n_25_0_10 n_26_0_10 466.41119076124943
R20993 n_25_0_10 n_25_1_10 158.75095666212593
R20994 n_25_0_10 n_25_0_11 0.15994008246498112
R20995 n_25_0_11 n_26_0_11 466.4111907612554
R20996 n_25_0_11 n_25_1_11 158.75095666212795
R20997 n_25_0_11 n_25_0_12 0.1599400824649806
R20998 n_25_0_12 n_26_0_12 466.41119076125256
R20999 n_25_0_12 n_25_1_12 158.7509566621269
R21000 n_25_0_12 n_25_0_13 0.15994008246498215
R21001 n_25_0_13 n_26_0_13 466.41119076124653
R21002 n_25_0_13 n_25_1_13 158.75095666212493
R21003 n_25_0_13 n_25_0_14 0.7997004123249127
R21004 n_25_0_14 n_26_0_14 51.82346564013872
R21005 n_25_0_14 n_25_1_14 17.638995184680617
R21006 n_25_0_14 n_25_0_15 24.710742740840033
R21007 n_25_0_15 n_26_0_15 17140.611260475715
R21008 n_25_0_15 n_25_1_15 5834.097657333058
R21009 n_25_1_0 n_26_1_0 244.86587514965544
R21010 n_25_1_0 n_25_2_0 83.34425224761593
R21011 n_25_1_0 n_25_1_1 19.792585205041586
R21012 n_25_1_1 n_26_1_1 342.8122252095176
R21013 n_25_1_1 n_25_2_1 116.6819531466623
R21014 n_25_1_1 n_25_1_2 44.98314819327633
R21015 n_25_1_2 n_26_1_2 612.1646878741385
R21016 n_25_1_2 n_25_2_2 208.3606306190398
R21017 n_25_1_2 n_25_1_3 42.104226708906644
R21018 n_25_1_3 n_26_1_3 8570.30563023793
R21019 n_25_1_3 n_25_2_3 2917.048828666555
R21020 n_25_1_3 n_25_1_4 0.5597902886274392
R21021 n_25_1_4 n_26_1_4 259.70623121933124
R21022 n_25_1_4 n_25_2_4 88.39541905050166
R21023 n_25_1_4 n_25_1_5 0.4626838099879854
R21024 n_25_1_5 n_26_1_5 1632.4391676643677
R21025 n_25_1_5 n_25_2_5 555.6283483174391
R21026 n_25_1_5 n_25_1_6 0.15994008246498265
R21027 n_25_1_6 n_26_1_6 272.073194610728
R21028 n_25_1_6 n_25_2_6 92.60472471957317
R21029 n_25_1_6 n_25_1_7 0.21706154048819049
R21030 n_25_1_7 n_26_1_7 466.41119076124943
R21031 n_25_1_7 n_25_2_7 158.75095666212593
R21032 n_25_1_7 n_25_1_8 0.15994008246498215
R21033 n_25_1_8 n_26_1_8 466.41119076124943
R21034 n_25_1_8 n_25_2_8 158.75095666212593
R21035 n_25_1_8 n_25_1_9 0.15994008246498215
R21036 n_25_1_9 n_26_1_9 466.41119076124943
R21037 n_25_1_9 n_25_2_9 158.75095666212593
R21038 n_25_1_9 n_25_1_10 0.15994008246498215
R21039 n_25_1_10 n_26_1_10 466.41119076124943
R21040 n_25_1_10 n_25_2_10 158.75095666212593
R21041 n_25_1_10 n_25_1_11 0.15994008246498112
R21042 n_25_1_11 n_26_1_11 466.4111907612554
R21043 n_25_1_11 n_25_2_11 158.75095666212795
R21044 n_25_1_11 n_25_1_12 0.1599400824649806
R21045 n_25_1_12 n_26_1_12 466.41119076125256
R21046 n_25_1_12 n_25_2_12 158.7509566621269
R21047 n_25_1_12 n_25_1_13 0.15994008246498215
R21048 n_25_1_13 n_26_1_13 466.41119076124653
R21049 n_25_1_13 n_25_2_13 158.75095666212493
R21050 n_25_1_13 n_25_1_14 0.7997004123249127
R21051 n_25_1_14 n_26_1_14 51.82346564013872
R21052 n_25_1_14 n_25_2_14 17.638995184680617
R21053 n_25_1_14 n_25_1_15 24.710742740840033
R21054 n_25_1_15 n_26_1_15 17140.611260475715
R21055 n_25_1_15 n_25_2_15 5834.097657333058
R21056 n_25_2_0 n_26_2_0 244.86587514965544
R21057 n_25_2_0 n_25_3_0 83.34425224761593
R21058 n_25_2_0 n_25_2_1 19.792585205041586
R21059 n_25_2_1 n_26_2_1 342.8122252095176
R21060 n_25_2_1 n_25_3_1 116.6819531466623
R21061 n_25_2_1 n_25_2_2 44.98314819327633
R21062 n_25_2_2 n_26_2_2 612.1646878741385
R21063 n_25_2_2 n_25_3_2 208.3606306190398
R21064 n_25_2_2 n_25_2_3 42.104226708906644
R21065 n_25_2_3 n_26_2_3 8570.30563023793
R21066 n_25_2_3 n_25_3_3 2917.048828666555
R21067 n_25_2_3 n_25_2_4 0.5597902886274392
R21068 n_25_2_4 n_26_2_4 259.70623121933124
R21069 n_25_2_4 n_25_3_4 88.39541905050166
R21070 n_25_2_4 n_25_2_5 0.4626838099879854
R21071 n_25_2_5 n_26_2_5 1632.4391676643677
R21072 n_25_2_5 n_25_3_5 555.6283483174391
R21073 n_25_2_5 n_25_2_6 0.15994008246498265
R21074 n_25_2_6 n_26_2_6 272.073194610728
R21075 n_25_2_6 n_25_3_6 92.60472471957317
R21076 n_25_2_6 n_25_2_7 0.21706154048819049
R21077 n_25_2_7 n_26_2_7 466.41119076124943
R21078 n_25_2_7 n_25_3_7 158.75095666212593
R21079 n_25_2_7 n_25_2_8 0.15994008246498215
R21080 n_25_2_8 n_26_2_8 466.41119076124943
R21081 n_25_2_8 n_25_3_8 158.75095666212593
R21082 n_25_2_8 n_25_2_9 0.15994008246498215
R21083 n_25_2_9 n_26_2_9 466.41119076124943
R21084 n_25_2_9 n_25_3_9 158.75095666212593
R21085 n_25_2_9 n_25_2_10 0.15994008246498215
R21086 n_25_2_10 n_26_2_10 466.41119076124943
R21087 n_25_2_10 n_25_3_10 158.75095666212593
R21088 n_25_2_10 n_25_2_11 0.15994008246498112
R21089 n_25_2_11 n_26_2_11 466.4111907612554
R21090 n_25_2_11 n_25_3_11 158.75095666212795
R21091 n_25_2_11 n_25_2_12 0.1599400824649806
R21092 n_25_2_12 n_26_2_12 466.41119076125256
R21093 n_25_2_12 n_25_3_12 158.7509566621269
R21094 n_25_2_12 n_25_2_13 0.15994008246498215
R21095 n_25_2_13 n_26_2_13 466.41119076124653
R21096 n_25_2_13 n_25_3_13 158.75095666212493
R21097 n_25_2_13 n_25_2_14 0.7997004123249127
R21098 n_25_2_14 n_26_2_14 51.82346564013872
R21099 n_25_2_14 n_25_3_14 17.638995184680617
R21100 n_25_2_14 n_25_2_15 24.710742740840033
R21101 n_25_2_15 n_26_2_15 17140.611260475715
R21102 n_25_2_15 n_25_3_15 5834.097657333058
R21103 n_25_3_0 n_26_3_0 244.86587514965544
R21104 n_25_3_0 n_25_4_0 43.561715139230984
R21105 n_25_3_0 n_25_3_1 19.792585205041586
R21106 n_25_3_1 n_26_3_1 342.8122252095176
R21107 n_25_3_1 n_25_4_1 60.986401194923374
R21108 n_25_3_1 n_25_3_2 44.98314819327633
R21109 n_25_3_2 n_26_3_2 612.1646878741385
R21110 n_25_3_2 n_25_4_2 108.90428784807744
R21111 n_25_3_2 n_25_3_3 42.104226708906644
R21112 n_25_3_3 n_26_3_3 8570.30563023793
R21113 n_25_3_3 n_25_4_3 1524.6600298730832
R21114 n_25_3_3 n_25_3_4 0.5597902886274392
R21115 n_25_3_4 n_26_3_4 259.70623121933124
R21116 n_25_3_4 n_25_4_4 46.20181908706312
R21117 n_25_3_4 n_25_3_5 0.4626838099879854
R21118 n_25_3_5 n_26_3_5 1632.4391676643677
R21119 n_25_3_5 n_25_3_6 0.15994008246498265
R21120 n_25_3_6 n_26_3_6 272.073194610728
R21121 n_25_3_6 n_25_3_7 0.21706154048819049
R21122 n_25_3_7 n_26_3_7 466.41119076124943
R21123 n_25_3_7 n_25_3_8 0.15994008246498215
R21124 n_25_3_8 n_26_3_8 466.41119076124943
R21125 n_25_3_8 n_25_3_9 0.15994008246498215
R21126 n_25_3_9 n_26_3_9 466.41119076124943
R21127 n_25_3_9 n_25_3_10 0.15994008246498215
R21128 n_25_3_10 n_26_3_10 466.41119076124943
R21129 n_25_3_10 n_25_3_11 0.15994008246498112
R21130 n_25_3_11 n_26_3_11 466.4111907612554
R21131 n_25_3_11 n_25_3_12 0.1599400824649806
R21132 n_25_3_12 n_26_3_12 466.41119076125256
R21133 n_25_3_12 n_25_3_13 0.15994008246498215
R21134 n_25_3_13 n_26_3_13 466.41119076124653
R21135 n_25_3_13 n_25_3_14 0.7997004123249127
R21136 n_25_3_14 n_26_3_14 51.82346564013872
R21137 n_25_3_14 n_25_3_15 24.710742740840033
R21138 n_25_3_15 n_26_3_15 17140.611260475715
R21139 n_25_3_15 n_25_4_15 3049.320059746139
R21140 n_25_4_0 n_26_4_0 5400.159267103212
R21141 n_25_4_0 n_25_5_0 3.779178030846073
R21142 n_25_4_0 n_25_4_1 436.49656102391225
R21143 n_25_4_1 n_26_4_1 7560.2229739444965
R21144 n_25_4_1 n_25_5_1 5.290849243184502
R21145 n_25_4_1 n_25_4_2 992.0376386907095
R21146 n_25_4_2 n_26_4_2 13500.39816775803
R21147 n_25_4_2 n_25_5_2 9.447945077115182
R21148 n_25_4_2 n_25_4_3 928.547229814504
R21149 n_25_4_3 n_26_4_3 189005.57434861228
R21150 n_25_4_3 n_25_5_3 132.27123107961245
R21151 n_25_4_3 n_25_4_4 12.345357281484397
R21152 n_25_4_4 n_26_4_4 5727.441646927644
R21153 n_25_4_4 n_25_5_4 4.008219123624619
R21154 n_25_4_15 n_26_4_15 378011.1486972212
R21155 n_25_4_15 n_25_5_15 264.5424621592225
R21156 n_25_5_0 n_26_5_0 5400.159267103118
R21157 n_25_5_0 n_25_6_0 3.7791780308461065
R21158 n_25_5_0 n_25_5_1 436.49656102390446
R21159 n_25_5_1 n_26_5_1 7560.222973944362
R21160 n_25_5_1 n_25_6_1 5.290849243184549
R21161 n_25_5_1 n_25_5_2 992.0376386906918
R21162 n_25_5_2 n_26_5_2 13500.39816775779
R21163 n_25_5_2 n_25_6_2 9.447945077115266
R21164 n_25_5_2 n_25_5_3 928.5472298144875
R21165 n_25_5_3 n_26_5_3 189005.5743486089
R21166 n_25_5_3 n_25_6_3 132.2712310796136
R21167 n_25_5_3 n_25_5_4 12.345357281484178
R21168 n_25_5_4 n_26_5_4 5727.441646927542
R21169 n_25_5_4 n_25_6_4 4.008219123624655
R21170 n_25_5_15 n_26_5_15 378011.14869721443
R21171 n_25_5_15 n_25_6_15 264.5424621592249
R21172 n_25_6_0 n_26_6_0 5400.159267103118
R21173 n_25_6_0 n_25_7_0 3.779178030846073
R21174 n_25_6_0 n_25_6_1 436.49656102390446
R21175 n_25_6_1 n_26_6_1 7560.222973944362
R21176 n_25_6_1 n_25_7_1 5.290849243184502
R21177 n_25_6_1 n_25_6_2 992.0376386906918
R21178 n_25_6_2 n_26_6_2 13500.39816775779
R21179 n_25_6_2 n_25_7_2 9.447945077115182
R21180 n_25_6_2 n_25_6_3 928.5472298144875
R21181 n_25_6_3 n_26_6_3 189005.5743486089
R21182 n_25_6_3 n_25_7_3 132.27123107961245
R21183 n_25_6_3 n_25_6_4 12.345357281484178
R21184 n_25_6_4 n_26_6_4 5727.441646927542
R21185 n_25_6_4 n_25_7_4 4.008219123624619
R21186 n_25_6_15 n_26_6_15 378011.14869721443
R21187 n_25_6_15 n_25_7_15 264.5424621592225
R21188 n_25_7_0 n_26_7_0 5400.159267103212
R21189 n_25_7_0 n_25_8_0 110.44365038628528
R21190 n_25_7_0 n_25_7_1 436.49656102391225
R21191 n_25_7_1 n_26_7_1 7560.2229739444965
R21192 n_25_7_1 n_25_8_1 154.62111054079944
R21193 n_25_7_1 n_25_7_2 992.0376386907095
R21194 n_25_7_2 n_26_7_2 13500.39816775803
R21195 n_25_7_2 n_25_8_2 276.10912596571325
R21196 n_25_7_2 n_25_7_3 928.547229814504
R21197 n_25_7_3 n_26_7_3 189005.57434861228
R21198 n_25_7_3 n_25_8_3 3865.5277635199823
R21199 n_25_7_3 n_25_7_4 12.345357281484397
R21200 n_25_7_4 n_26_7_4 5727.441646927644
R21201 n_25_7_4 n_25_8_4 117.13720495515096
R21202 n_25_7_15 n_26_7_15 378011.1486972212
R21203 n_25_7_15 n_25_8_15 7731.055527039895
R21204 n_25_8_0 n_26_8_0 93.99999874525193
R21205 n_25_8_0 n_25_9_0 217.10812274172463
R21206 n_25_8_0 n_25_8_1 7.598049272084611
R21207 n_25_8_1 n_26_8_1 131.59999824335267
R21208 n_25_8_1 n_25_9_1 303.9513718384145
R21209 n_25_8_1 n_25_8_2 17.268293800192296
R21210 n_25_8_2 n_26_8_2 234.9999968631298
R21211 n_25_8_2 n_25_9_2 542.7703068543115
R21212 n_25_8_2 n_25_8_3 16.16312299697999
R21213 n_25_8_3 n_26_8_3 3289.9999560838146
R21214 n_25_8_3 n_25_9_3 7598.784295960355
R21215 n_25_8_3 n_25_8_4 0.2148943228468377
R21216 n_25_8_4 n_26_8_4 99.69696836617621
R21217 n_25_8_4 n_25_9_4 230.26619078667744
R21218 n_25_8_4 n_25_8_5 0.2148943228468377
R21219 n_25_8_5 n_26_8_5 3289.9999560838146
R21220 n_25_8_5 n_25_9_5 7598.784295960355
R21221 n_25_8_5 n_25_8_6 0.4144390512046156
R21222 n_25_8_6 n_26_8_6 731.1111013519587
R21223 n_25_8_6 n_25_9_6 1688.6187324356342
R21224 n_25_8_6 n_25_8_7 0.5832845905842732
R21225 n_25_8_7 n_26_8_7 1253.333316603362
R21226 n_25_8_7 n_25_9_7 2894.774969889668
R21227 n_25_8_7 n_25_8_8 0.4297886456936741
R21228 n_25_8_8 n_26_8_8 1253.333316603362
R21229 n_25_8_8 n_25_9_8 2894.774969889668
R21230 n_25_8_8 n_25_8_9 0.4297886456936741
R21231 n_25_8_9 n_26_8_9 1253.333316603362
R21232 n_25_8_9 n_25_9_9 2894.774969889668
R21233 n_25_8_9 n_25_8_10 0.4297886456936741
R21234 n_25_8_10 n_26_8_10 1253.333316603362
R21235 n_25_8_10 n_25_9_10 2894.774969889668
R21236 n_25_8_10 n_25_8_11 0.42978864569367137
R21237 n_25_8_11 n_26_8_11 1253.3333166033776
R21238 n_25_8_11 n_25_9_11 2894.774969889705
R21239 n_25_8_11 n_25_8_12 0.4297886456936699
R21240 n_25_8_12 n_26_8_12 1253.33331660337
R21241 n_25_8_12 n_25_9_12 2894.7749698896864
R21242 n_25_8_12 n_25_8_13 0.42978864569367403
R21243 n_25_8_13 n_26_8_13 1253.333316603354
R21244 n_25_8_13 n_25_9_13 2894.77496988965
R21245 n_25_8_13 n_25_8_14 2.148943228468376
R21246 n_25_8_14 n_26_8_14 139.25925740037326
R21247 n_25_8_14 n_25_9_14 321.64166332107345
R21248 n_25_8_14 n_25_8_15 11.14380559905752
R21249 n_25_8_15 n_26_8_15 6579.999912167571
R21250 n_25_8_15 n_25_9_15 15197.568591920575
R21251 n_25_9_0 n_26_9_0 93.99999874525187
R21252 n_25_9_0 n_25_10_0 217.10812274172463
R21253 n_25_9_0 n_25_9_1 7.598049272084607
R21254 n_25_9_1 n_26_9_1 131.59999824335262
R21255 n_25_9_1 n_25_10_1 303.9513718384145
R21256 n_25_9_1 n_25_9_2 17.268293800192286
R21257 n_25_9_2 n_26_9_2 234.99999686312967
R21258 n_25_9_2 n_25_10_2 542.7703068543115
R21259 n_25_9_2 n_25_9_3 16.16312299697998
R21260 n_25_9_3 n_26_9_3 3289.999956083813
R21261 n_25_9_3 n_25_10_3 7598.784295960355
R21262 n_25_9_3 n_25_9_4 0.21489432284683754
R21263 n_25_9_4 n_26_9_4 99.69696836617614
R21264 n_25_9_4 n_25_10_4 230.26619078667744
R21265 n_25_9_4 n_25_9_5 0.21489432284683754
R21266 n_25_9_5 n_26_9_5 3289.999956083813
R21267 n_25_9_5 n_25_10_5 7598.784295960355
R21268 n_25_9_5 n_25_9_6 0.41443905120461527
R21269 n_25_9_6 n_26_9_6 731.1111013519583
R21270 n_25_9_6 n_25_10_6 1688.6187324356342
R21271 n_25_9_6 n_25_9_7 0.5832845905842726
R21272 n_25_9_7 n_26_9_7 1253.3333166033608
R21273 n_25_9_7 n_25_10_7 2894.774969889668
R21274 n_25_9_7 n_25_9_8 0.4297886456936737
R21275 n_25_9_8 n_26_9_8 1253.3333166033608
R21276 n_25_9_8 n_25_10_8 2894.774969889668
R21277 n_25_9_8 n_25_9_9 0.4297886456936737
R21278 n_25_9_9 n_26_9_9 1253.3333166033608
R21279 n_25_9_9 n_25_10_9 2894.774969889668
R21280 n_25_9_9 n_25_9_10 0.4297886456936737
R21281 n_25_9_10 n_26_9_10 1253.3333166033608
R21282 n_25_9_10 n_25_10_10 2894.774969889668
R21283 n_25_9_10 n_25_9_11 0.429788645693671
R21284 n_25_9_11 n_26_9_11 1253.3333166033772
R21285 n_25_9_11 n_25_10_11 2894.774969889705
R21286 n_25_9_11 n_25_9_12 0.4297886456936696
R21287 n_25_9_12 n_26_9_12 1253.333316603369
R21288 n_25_9_12 n_25_10_12 2894.7749698896864
R21289 n_25_9_12 n_25_9_13 0.4297886456936737
R21290 n_25_9_13 n_26_9_13 1253.333316603353
R21291 n_25_9_13 n_25_10_13 2894.77496988965
R21292 n_25_9_13 n_25_9_14 2.148943228468374
R21293 n_25_9_14 n_26_9_14 139.25925740037314
R21294 n_25_9_14 n_25_10_14 321.64166332107345
R21295 n_25_9_14 n_25_9_15 11.143805599057513
R21296 n_25_9_15 n_26_9_15 6579.999912167567
R21297 n_25_9_15 n_25_10_15 15197.568591920575
R21298 n_25_10_0 n_26_10_0 93.99999874525193
R21299 n_25_10_0 n_25_11_0 217.10812274172454
R21300 n_25_10_0 n_25_10_1 7.598049272084611
R21301 n_25_10_1 n_26_10_1 131.59999824335267
R21302 n_25_10_1 n_25_11_1 303.9513718384144
R21303 n_25_10_1 n_25_10_2 17.268293800192296
R21304 n_25_10_2 n_26_10_2 234.9999968631298
R21305 n_25_10_2 n_25_11_2 542.7703068543113
R21306 n_25_10_2 n_25_10_3 16.16312299697999
R21307 n_25_10_3 n_26_10_3 3289.9999560838146
R21308 n_25_10_3 n_25_11_3 7598.784295960353
R21309 n_25_10_3 n_25_10_4 0.2148943228468377
R21310 n_25_10_4 n_26_10_4 99.69696836617621
R21311 n_25_10_4 n_25_11_4 230.26619078667736
R21312 n_25_10_4 n_25_10_5 0.2148943228468377
R21313 n_25_10_5 n_26_10_5 3289.9999560838146
R21314 n_25_10_5 n_25_11_5 7598.784295960353
R21315 n_25_10_5 n_25_10_6 0.4144390512046156
R21316 n_25_10_6 n_26_10_6 731.1111013519587
R21317 n_25_10_6 n_25_11_6 1688.6187324356338
R21318 n_25_10_6 n_25_10_7 0.5832845905842732
R21319 n_25_10_7 n_26_10_7 1253.333316603362
R21320 n_25_10_7 n_25_11_7 2894.774969889667
R21321 n_25_10_7 n_25_10_8 0.4297886456936741
R21322 n_25_10_8 n_26_10_8 1253.333316603362
R21323 n_25_10_8 n_25_11_8 2894.774969889667
R21324 n_25_10_8 n_25_10_9 0.4297886456936741
R21325 n_25_10_9 n_26_10_9 1253.333316603362
R21326 n_25_10_9 n_25_11_9 2894.774969889667
R21327 n_25_10_9 n_25_10_10 0.4297886456936741
R21328 n_25_10_10 n_26_10_10 1253.333316603362
R21329 n_25_10_10 n_25_11_10 2894.774969889667
R21330 n_25_10_10 n_25_10_11 0.42978864569367137
R21331 n_25_10_11 n_26_10_11 1253.3333166033776
R21332 n_25_10_11 n_25_11_11 2894.774969889704
R21333 n_25_10_11 n_25_10_12 0.4297886456936699
R21334 n_25_10_12 n_26_10_12 1253.33331660337
R21335 n_25_10_12 n_25_11_12 2894.7749698896855
R21336 n_25_10_12 n_25_10_13 0.42978864569367403
R21337 n_25_10_13 n_26_10_13 1253.333316603354
R21338 n_25_10_13 n_25_11_13 2894.774969889649
R21339 n_25_10_13 n_25_10_14 2.148943228468376
R21340 n_25_10_14 n_26_10_14 139.25925740037326
R21341 n_25_10_14 n_25_11_14 321.6416633210734
R21342 n_25_10_14 n_25_10_15 11.14380559905752
R21343 n_25_10_15 n_26_10_15 6579.999912167571
R21344 n_25_10_15 n_25_11_15 15197.56859192057
R21345 n_25_11_0 n_26_11_0 93.99999874525193
R21346 n_25_11_0 n_25_12_0 110.44365362970504
R21347 n_25_11_0 n_25_11_1 7.598049272084611
R21348 n_25_11_1 n_26_11_1 131.59999824335267
R21349 n_25_11_1 n_25_12_1 154.62111508158705
R21350 n_25_11_1 n_25_11_2 17.268293800192296
R21351 n_25_11_2 n_26_11_2 234.9999968631298
R21352 n_25_11_2 n_25_12_2 276.10913407426256
R21353 n_25_11_2 n_25_11_3 16.16312299697999
R21354 n_25_11_3 n_26_11_3 3289.9999560838146
R21355 n_25_11_3 n_25_12_3 3865.527877039673
R21356 n_25_11_3 n_25_11_4 0.2148943228468377
R21357 n_25_11_4 n_26_11_4 99.69696836617621
R21358 n_25_11_4 n_25_12_4 117.13720839514161
R21359 n_25_11_4 n_25_11_5 0.2148943228468377
R21360 n_25_11_5 n_26_11_5 3289.9999560838146
R21361 n_25_11_5 n_25_11_6 0.4144390512046156
R21362 n_25_11_6 n_26_11_6 731.1111013519587
R21363 n_25_11_6 n_25_11_7 0.5832845905842732
R21364 n_25_11_7 n_26_11_7 1253.333316603362
R21365 n_25_11_7 n_25_11_8 0.4297886456936741
R21366 n_25_11_8 n_26_11_8 1253.333316603362
R21367 n_25_11_8 n_25_11_9 0.4297886456936741
R21368 n_25_11_9 n_26_11_9 1253.333316603362
R21369 n_25_11_9 n_25_11_10 0.4297886456936741
R21370 n_25_11_10 n_26_11_10 1253.333316603362
R21371 n_25_11_10 n_25_11_11 0.42978864569367137
R21372 n_25_11_11 n_26_11_11 1253.3333166033776
R21373 n_25_11_11 n_25_11_12 0.4297886456936699
R21374 n_25_11_12 n_26_11_12 1253.33331660337
R21375 n_25_11_12 n_25_11_13 0.42978864569367403
R21376 n_25_11_13 n_26_11_13 1253.333316603354
R21377 n_25_11_13 n_25_11_14 2.148943228468376
R21378 n_25_11_14 n_26_11_14 139.25925740037326
R21379 n_25_11_14 n_25_11_15 11.14380559905752
R21380 n_25_11_15 n_26_11_15 6579.999912167571
R21381 n_25_11_15 n_25_12_15 7731.055754079277
R21382 n_25_12_0 n_26_12_0 5400.1499979166465
R21383 n_25_12_0 n_25_13_0 3.7791845176855245
R21384 n_25_12_0 n_25_12_1 436.4958117926656
R21385 n_25_12_1 n_26_12_1 7560.209997083305
R21386 n_25_12_1 n_25_13_1 5.290858324759735
R21387 n_25_12_1 n_25_12_2 992.0359358924218
R21388 n_25_12_2 n_26_12_2 13500.374994791619
R21389 n_25_12_2 n_25_13_2 9.447961294213812
R21390 n_25_12_2 n_25_12_3 928.5456359953067
R21391 n_25_12_3 n_26_12_3 189005.24992708245
R21392 n_25_12_3 n_25_13_3 132.27145811899325
R21393 n_25_12_3 n_25_12_4 12.345336091105704
R21394 n_25_12_4 n_26_12_4 5727.431815972196
R21395 n_25_12_4 n_25_13_4 4.008226003605856
R21396 n_25_12_15 n_26_12_15 378010.4998541616
R21397 n_25_12_15 n_25_13_15 264.5429162379842
R21398 n_25_13_0 n_26_13_0 5400.1499979166465
R21399 n_25_13_0 n_25_14_0 3.7791845176855245
R21400 n_25_13_0 n_25_13_1 436.4958117926656
R21401 n_25_13_1 n_26_13_1 7560.209997083305
R21402 n_25_13_1 n_25_14_1 5.290858324759735
R21403 n_25_13_1 n_25_13_2 992.0359358924218
R21404 n_25_13_2 n_26_13_2 13500.374994791619
R21405 n_25_13_2 n_25_14_2 9.447961294213812
R21406 n_25_13_2 n_25_13_3 928.5456359953067
R21407 n_25_13_3 n_26_13_3 189005.24992708245
R21408 n_25_13_3 n_25_14_3 132.27145811899325
R21409 n_25_13_3 n_25_13_4 12.345336091105704
R21410 n_25_13_4 n_26_13_4 5727.431815972196
R21411 n_25_13_4 n_25_14_4 4.008226003605856
R21412 n_25_13_15 n_26_13_15 378010.4998541616
R21413 n_25_13_15 n_25_14_15 264.5429162379842
R21414 n_25_14_0 n_26_14_0 5400.1499979166465
R21415 n_25_14_0 n_25_15_0 3.7791845176855245
R21416 n_25_14_0 n_25_14_1 436.4958117926656
R21417 n_25_14_1 n_26_14_1 7560.209997083305
R21418 n_25_14_1 n_25_15_1 5.290858324759735
R21419 n_25_14_1 n_25_14_2 992.0359358924218
R21420 n_25_14_2 n_26_14_2 13500.374994791619
R21421 n_25_14_2 n_25_15_2 9.447961294213812
R21422 n_25_14_2 n_25_14_3 928.5456359953067
R21423 n_25_14_3 n_26_14_3 189005.24992708245
R21424 n_25_14_3 n_25_15_3 132.27145811899325
R21425 n_25_14_3 n_25_14_4 12.345336091105704
R21426 n_25_14_4 n_26_14_4 5727.431815972196
R21427 n_25_14_4 n_25_15_4 4.008226003605856
R21428 n_25_14_15 n_26_14_15 378010.4998541616
R21429 n_25_14_15 n_25_15_15 264.5429162379842
R21430 n_25_15_0 n_26_15_0 5400.1499979166465
R21431 n_25_15_0 n_25_16_0 110.44365362970498
R21432 n_25_15_0 n_25_15_1 436.4958117926656
R21433 n_25_15_1 n_26_15_1 7560.209997083305
R21434 n_25_15_1 n_25_16_1 154.62111508158694
R21435 n_25_15_1 n_25_15_2 992.0359358924218
R21436 n_25_15_2 n_26_15_2 13500.374994791619
R21437 n_25_15_2 n_25_16_2 276.1091340742624
R21438 n_25_15_2 n_25_15_3 928.5456359953067
R21439 n_25_15_3 n_26_15_3 189005.24992708245
R21440 n_25_15_3 n_25_16_3 3865.527877039671
R21441 n_25_15_3 n_25_15_4 12.345336091105704
R21442 n_25_15_4 n_26_15_4 5727.431815972196
R21443 n_25_15_4 n_25_16_4 117.13720839514153
R21444 n_25_15_15 n_26_15_15 378010.4998541616
R21445 n_25_15_15 n_25_16_15 7731.055754079272
R21446 n_25_16_0 n_26_16_0 93.99999874525201
R21447 n_25_16_0 n_25_17_0 217.10812274172457
R21448 n_25_16_0 n_25_16_1 7.598049272084617
R21449 n_25_16_1 n_26_16_1 131.5999982433528
R21450 n_25_16_1 n_25_17_1 303.9513718384144
R21451 n_25_16_1 n_25_16_2 17.26829380019231
R21452 n_25_16_2 n_26_16_2 234.99999686312998
R21453 n_25_16_2 n_25_17_2 542.7703068543113
R21454 n_25_16_2 n_25_16_3 16.16312299698
R21455 n_25_16_3 n_26_16_3 3289.9999560838164
R21456 n_25_16_3 n_25_17_3 7598.784295960353
R21457 n_25_16_3 n_25_16_4 0.21489432284683782
R21458 n_25_16_4 n_26_16_4 99.69696836617624
R21459 n_25_16_4 n_25_17_4 230.26619078667736
R21460 n_25_16_4 n_25_16_5 0.21489432284683782
R21461 n_25_16_5 n_26_16_5 3289.9999560838164
R21462 n_25_16_5 n_25_17_5 7598.784295960353
R21463 n_25_16_5 n_25_16_6 0.4144390512046158
R21464 n_25_16_6 n_26_16_6 731.1111013519592
R21465 n_25_16_6 n_25_17_6 1688.6187324356338
R21466 n_25_16_6 n_25_16_7 0.5832845905842734
R21467 n_25_16_7 n_26_16_7 1253.3333166033626
R21468 n_25_16_7 n_25_17_7 2894.774969889667
R21469 n_25_16_7 n_25_16_8 0.4297886456936743
R21470 n_25_16_8 n_26_16_8 1253.3333166033626
R21471 n_25_16_8 n_25_17_8 2894.774969889667
R21472 n_25_16_8 n_25_16_9 0.4297886456936743
R21473 n_25_16_9 n_26_16_9 1253.3333166033626
R21474 n_25_16_9 n_25_17_9 2894.774969889667
R21475 n_25_16_9 n_25_16_10 0.4297886456936743
R21476 n_25_16_10 n_26_16_10 1253.3333166033626
R21477 n_25_16_10 n_25_17_10 2894.774969889667
R21478 n_25_16_10 n_25_16_11 0.4297886456936716
R21479 n_25_16_11 n_26_16_11 1253.3333166033785
R21480 n_25_16_11 n_25_17_11 2894.774969889704
R21481 n_25_16_11 n_25_16_12 0.42978864569367015
R21482 n_25_16_12 n_26_16_12 1253.3333166033703
R21483 n_25_16_12 n_25_17_12 2894.7749698896855
R21484 n_25_16_12 n_25_16_13 0.42978864569367425
R21485 n_25_16_13 n_26_16_13 1253.333316603355
R21486 n_25_16_13 n_25_17_13 2894.774969889649
R21487 n_25_16_13 n_25_16_14 2.1489432284683767
R21488 n_25_16_14 n_26_16_14 139.25925740037331
R21489 n_25_16_14 n_25_17_14 321.6416633210734
R21490 n_25_16_14 n_25_16_15 11.143805599057526
R21491 n_25_16_15 n_26_16_15 6579.999912167575
R21492 n_25_16_15 n_25_17_15 15197.56859192057
R21493 n_25_17_0 n_26_17_0 93.99999874525187
R21494 n_25_17_0 n_25_18_0 217.10812274172469
R21495 n_25_17_0 n_25_17_1 7.598049272084607
R21496 n_25_17_1 n_26_17_1 131.59999824335262
R21497 n_25_17_1 n_25_18_1 303.95137183841456
R21498 n_25_17_1 n_25_17_2 17.268293800192286
R21499 n_25_17_2 n_26_17_2 234.99999686312967
R21500 n_25_17_2 n_25_18_2 542.7703068543117
R21501 n_25_17_2 n_25_17_3 16.16312299697998
R21502 n_25_17_3 n_26_17_3 3289.999956083813
R21503 n_25_17_3 n_25_18_3 7598.784295960358
R21504 n_25_17_3 n_25_17_4 0.21489432284683754
R21505 n_25_17_4 n_26_17_4 99.69696836617614
R21506 n_25_17_4 n_25_18_4 230.2661907866775
R21507 n_25_17_4 n_25_17_5 0.21489432284683754
R21508 n_25_17_5 n_26_17_5 3289.999956083813
R21509 n_25_17_5 n_25_18_5 7598.784295960358
R21510 n_25_17_5 n_25_17_6 0.41443905120461527
R21511 n_25_17_6 n_26_17_6 731.1111013519583
R21512 n_25_17_6 n_25_18_6 1688.6187324356347
R21513 n_25_17_6 n_25_17_7 0.5832845905842726
R21514 n_25_17_7 n_26_17_7 1253.3333166033608
R21515 n_25_17_7 n_25_18_7 2894.7749698896687
R21516 n_25_17_7 n_25_17_8 0.4297886456936737
R21517 n_25_17_8 n_26_17_8 1253.3333166033608
R21518 n_25_17_8 n_25_18_8 2894.7749698896687
R21519 n_25_17_8 n_25_17_9 0.4297886456936737
R21520 n_25_17_9 n_26_17_9 1253.3333166033608
R21521 n_25_17_9 n_25_18_9 2894.7749698896687
R21522 n_25_17_9 n_25_17_10 0.4297886456936737
R21523 n_25_17_10 n_26_17_10 1253.3333166033608
R21524 n_25_17_10 n_25_18_10 2894.7749698896687
R21525 n_25_17_10 n_25_17_11 0.429788645693671
R21526 n_25_17_11 n_26_17_11 1253.3333166033772
R21527 n_25_17_11 n_25_18_11 2894.774969889706
R21528 n_25_17_11 n_25_17_12 0.4297886456936696
R21529 n_25_17_12 n_26_17_12 1253.333316603369
R21530 n_25_17_12 n_25_18_12 2894.7749698896873
R21531 n_25_17_12 n_25_17_13 0.4297886456936737
R21532 n_25_17_13 n_26_17_13 1253.333316603353
R21533 n_25_17_13 n_25_18_13 2894.774969889651
R21534 n_25_17_13 n_25_17_14 2.148943228468374
R21535 n_25_17_14 n_26_17_14 139.25925740037314
R21536 n_25_17_14 n_25_18_14 321.64166332107357
R21537 n_25_17_14 n_25_17_15 11.143805599057513
R21538 n_25_17_15 n_26_17_15 6579.999912167567
R21539 n_25_17_15 n_25_18_15 15197.568591920579
R21540 n_25_18_0 n_26_18_0 93.99999874525187
R21541 n_25_18_0 n_25_19_0 217.10812274172457
R21542 n_25_18_0 n_25_18_1 7.598049272084607
R21543 n_25_18_1 n_26_18_1 131.59999824335262
R21544 n_25_18_1 n_25_19_1 303.9513718384144
R21545 n_25_18_1 n_25_18_2 17.268293800192286
R21546 n_25_18_2 n_26_18_2 234.99999686312967
R21547 n_25_18_2 n_25_19_2 542.7703068543113
R21548 n_25_18_2 n_25_18_3 16.16312299697998
R21549 n_25_18_3 n_26_18_3 3289.999956083813
R21550 n_25_18_3 n_25_19_3 7598.784295960353
R21551 n_25_18_3 n_25_18_4 0.21489432284683754
R21552 n_25_18_4 n_26_18_4 99.69696836617614
R21553 n_25_18_4 n_25_19_4 230.26619078667736
R21554 n_25_18_4 n_25_18_5 0.21489432284683754
R21555 n_25_18_5 n_26_18_5 3289.999956083813
R21556 n_25_18_5 n_25_19_5 7598.784295960353
R21557 n_25_18_5 n_25_18_6 0.41443905120461527
R21558 n_25_18_6 n_26_18_6 731.1111013519583
R21559 n_25_18_6 n_25_19_6 1688.6187324356338
R21560 n_25_18_6 n_25_18_7 0.5832845905842726
R21561 n_25_18_7 n_26_18_7 1253.3333166033608
R21562 n_25_18_7 n_25_19_7 2894.774969889667
R21563 n_25_18_7 n_25_18_8 0.4297886456936737
R21564 n_25_18_8 n_26_18_8 1253.3333166033608
R21565 n_25_18_8 n_25_19_8 2894.774969889667
R21566 n_25_18_8 n_25_18_9 0.4297886456936737
R21567 n_25_18_9 n_26_18_9 1253.3333166033608
R21568 n_25_18_9 n_25_19_9 2894.774969889667
R21569 n_25_18_9 n_25_18_10 0.4297886456936737
R21570 n_25_18_10 n_26_18_10 1253.3333166033608
R21571 n_25_18_10 n_25_19_10 2894.774969889667
R21572 n_25_18_10 n_25_18_11 0.429788645693671
R21573 n_25_18_11 n_26_18_11 1253.3333166033772
R21574 n_25_18_11 n_25_19_11 2894.774969889704
R21575 n_25_18_11 n_25_18_12 0.4297886456936696
R21576 n_25_18_12 n_26_18_12 1253.333316603369
R21577 n_25_18_12 n_25_19_12 2894.7749698896855
R21578 n_25_18_12 n_25_18_13 0.4297886456936737
R21579 n_25_18_13 n_26_18_13 1253.333316603353
R21580 n_25_18_13 n_25_19_13 2894.774969889649
R21581 n_25_18_13 n_25_18_14 2.148943228468374
R21582 n_25_18_14 n_26_18_14 139.25925740037314
R21583 n_25_18_14 n_25_19_14 321.6416633210734
R21584 n_25_18_14 n_25_18_15 11.143805599057513
R21585 n_25_18_15 n_26_18_15 6579.999912167567
R21586 n_25_18_15 n_25_19_15 15197.56859192057
R21587 n_25_19_0 n_26_19_0 93.99999874525201
R21588 n_25_19_0 n_25_20_0 110.44365397508213
R21589 n_25_19_0 n_25_19_1 7.598049272084617
R21590 n_25_19_1 n_26_19_1 131.5999982433528
R21591 n_25_19_1 n_25_20_1 154.62111556511496
R21592 n_25_19_1 n_25_19_2 17.26829380019231
R21593 n_25_19_2 n_26_19_2 234.99999686312998
R21594 n_25_19_2 n_25_20_2 276.1091349377053
R21595 n_25_19_2 n_25_19_3 16.16312299698
R21596 n_25_19_3 n_26_19_3 3289.9999560838164
R21597 n_25_19_3 n_25_20_3 3865.5278891278713
R21598 n_25_19_3 n_25_19_4 0.21489432284683782
R21599 n_25_19_4 n_26_19_4 99.69696836617624
R21600 n_25_19_4 n_25_20_4 117.13720876145064
R21601 n_25_19_4 n_25_19_5 0.21489432284683782
R21602 n_25_19_5 n_26_19_5 3289.9999560838164
R21603 n_25_19_5 n_25_19_6 0.4144390512046158
R21604 n_25_19_6 n_26_19_6 731.1111013519592
R21605 n_25_19_6 n_25_19_7 0.5832845905842734
R21606 n_25_19_7 n_26_19_7 1253.3333166033626
R21607 n_25_19_7 n_25_19_8 0.4297886456936743
R21608 n_25_19_8 n_26_19_8 1253.3333166033626
R21609 n_25_19_8 n_25_19_9 0.4297886456936743
R21610 n_25_19_9 n_26_19_9 1253.3333166033626
R21611 n_25_19_9 n_25_19_10 0.4297886456936743
R21612 n_25_19_10 n_26_19_10 1253.3333166033626
R21613 n_25_19_10 n_25_19_11 0.4297886456936716
R21614 n_25_19_11 n_26_19_11 1253.3333166033785
R21615 n_25_19_11 n_25_19_12 0.42978864569367015
R21616 n_25_19_12 n_26_19_12 1253.3333166033703
R21617 n_25_19_12 n_25_19_13 0.42978864569367425
R21618 n_25_19_13 n_26_19_13 1253.333316603355
R21619 n_25_19_13 n_25_19_14 2.1489432284683767
R21620 n_25_19_14 n_26_19_14 139.25925740037331
R21621 n_25_19_14 n_25_19_15 11.143805599057526
R21622 n_25_19_15 n_26_19_15 6579.999912167575
R21623 n_25_19_15 n_25_20_15 7731.0557782556725
R21624 n_25_20_0 n_26_20_0 5400.149010884629
R21625 n_25_20_0 n_25_21_0 3.7791852084398188
R21626 n_25_20_0 n_25_20_1 436.4957320105592
R21627 n_25_20_1 n_26_20_1 7560.208615238479
R21628 n_25_20_1 n_25_21_1 5.290859291815746
R21629 n_25_20_1 n_25_20_2 992.0357545694527
R21630 n_25_20_2 n_26_20_2 13500.372527211573
R21631 n_25_20_2 n_25_21_2 9.447963021099547
R21632 n_25_20_2 n_25_20_3 928.5454662770078
R21633 n_25_20_3 n_26_20_3 189005.21538096183
R21634 n_25_20_3 n_25_21_3 132.27148229539355
R21635 n_25_20_3 n_25_20_4 12.34533383464209
R21636 n_25_20_4 n_26_20_4 5727.430769120056
R21637 n_25_20_4 n_25_21_4 4.008226736224047
R21638 n_25_20_15 n_26_20_15 378010.4307619203
R21639 n_25_20_15 n_25_21_15 264.5429645907847
R21640 n_25_21_0 n_26_21_0 5400.149010884629
R21641 n_25_21_0 n_25_22_0 3.7791852084396846
R21642 n_25_21_0 n_25_21_1 436.4957320105592
R21643 n_25_21_1 n_26_21_1 7560.208615238479
R21644 n_25_21_1 n_25_22_1 5.290859291815558
R21645 n_25_21_1 n_25_21_2 992.0357545694527
R21646 n_25_21_2 n_26_21_2 13500.372527211573
R21647 n_25_21_2 n_25_22_2 9.447963021099211
R21648 n_25_21_2 n_25_21_3 928.5454662770078
R21649 n_25_21_3 n_26_21_3 189005.21538096183
R21650 n_25_21_3 n_25_22_3 132.27148229538886
R21651 n_25_21_3 n_25_21_4 12.34533383464209
R21652 n_25_21_4 n_26_21_4 5727.430769120056
R21653 n_25_21_4 n_25_22_4 4.008226736223905
R21654 n_25_21_15 n_26_21_15 378010.4307619203
R21655 n_25_21_15 n_25_22_15 264.54296459077534
R21656 n_25_22_0 n_26_22_0 5400.149010885012
R21657 n_25_22_0 n_25_23_0 3.7791852084396846
R21658 n_25_22_0 n_25_22_1 436.49573201059025
R21659 n_25_22_1 n_26_22_1 7560.208615239017
R21660 n_25_22_1 n_25_23_1 5.290859291815558
R21661 n_25_22_1 n_25_22_2 992.0357545695232
R21662 n_25_22_2 n_26_22_2 13500.37252721253
R21663 n_25_22_2 n_25_23_2 9.447963021099211
R21664 n_25_22_2 n_25_22_3 928.5454662770737
R21665 n_25_22_3 n_26_22_3 189005.21538097528
R21666 n_25_22_3 n_25_23_3 132.27148229538886
R21667 n_25_22_3 n_25_22_4 12.345333834642968
R21668 n_25_22_4 n_26_22_4 5727.430769120462
R21669 n_25_22_4 n_25_23_4 4.008226736223905
R21670 n_25_22_15 n_26_22_15 378010.4307619472
R21671 n_25_22_15 n_25_23_15 264.54296459077534
R21672 n_25_23_0 n_26_23_0 5400.149010884629
R21673 n_25_23_0 n_25_24_0 43.561715139231076
R21674 n_25_23_0 n_25_23_1 436.4957320105592
R21675 n_25_23_1 n_26_23_1 7560.208615238479
R21676 n_25_23_1 n_25_24_1 60.98640119492351
R21677 n_25_23_1 n_25_23_2 992.0357545694527
R21678 n_25_23_2 n_26_23_2 13500.372527211573
R21679 n_25_23_2 n_25_24_2 108.90428784807769
R21680 n_25_23_2 n_25_23_3 928.5454662770078
R21681 n_25_23_3 n_26_23_3 189005.21538096183
R21682 n_25_23_3 n_25_24_3 1524.6600298730866
R21683 n_25_23_3 n_25_23_4 12.34533383464209
R21684 n_25_23_4 n_26_23_4 5727.430769120056
R21685 n_25_23_4 n_25_24_4 46.20181908706322
R21686 n_25_23_15 n_26_23_15 378010.4307619203
R21687 n_25_23_15 n_25_24_15 3049.3200597461455
R21688 n_25_24_0 n_26_24_0 244.86589623746698
R21689 n_25_24_0 n_25_25_0 83.3442450700222
R21690 n_25_24_0 n_25_24_1 19.79258690957598
R21691 n_25_24_1 n_26_24_1 342.8122547324537
R21692 n_25_24_1 n_25_25_1 116.68194309803108
R21693 n_25_24_1 n_25_24_2 44.983152067218136
R21694 n_25_24_2 n_26_24_2 612.1647405936675
R21695 n_25_24_2 n_25_25_2 208.3606126750555
R21696 n_25_24_2 n_25_24_3 42.10423033491618
R21697 n_25_24_3 n_26_24_3 8570.306368311336
R21698 n_25_24_3 n_25_25_3 2917.048577450775
R21699 n_25_24_3 n_25_24_4 0.5597903368364929
R21700 n_25_24_4 n_26_24_4 259.70625358519203
R21701 n_25_24_4 n_25_25_4 88.39541143790225
R21702 n_25_24_4 n_25_24_5 0.46268384983424415
R21703 n_25_24_5 n_26_24_5 1632.4393082497784
R21704 n_25_24_5 n_25_25_5 555.6283004668143
R21705 n_25_24_5 n_25_24_6 0.15994009623899796
R21706 n_25_24_6 n_26_24_6 272.07321804162973
R21707 n_25_24_6 n_25_25_6 92.60471674446904
R21708 n_25_24_6 n_25_24_7 0.217061559181497
R21709 n_25_24_7 n_26_24_7 466.4112309285095
R21710 n_25_24_7 n_25_25_7 158.75094299051884
R21711 n_25_24_7 n_25_24_8 0.15994009623899746
R21712 n_25_24_8 n_26_24_8 466.4112309285095
R21713 n_25_24_8 n_25_25_8 158.75094299051884
R21714 n_25_24_8 n_25_24_9 0.15994009623899746
R21715 n_25_24_9 n_26_24_9 466.4112309285095
R21716 n_25_24_9 n_25_25_9 158.75094299051884
R21717 n_25_24_9 n_25_24_10 0.15994009623899746
R21718 n_25_24_10 n_26_24_10 466.4112309285095
R21719 n_25_24_10 n_25_25_10 158.75094299051884
R21720 n_25_24_10 n_25_24_11 0.15994009623899644
R21721 n_25_24_11 n_26_24_11 466.41123092851547
R21722 n_25_24_11 n_25_25_11 158.75094299052085
R21723 n_25_24_11 n_25_24_12 0.1599400962389959
R21724 n_25_24_12 n_26_24_12 466.4112309285125
R21725 n_25_24_12 n_25_25_12 158.75094299051983
R21726 n_25_24_12 n_25_24_13 0.15994009623899746
R21727 n_25_24_13 n_26_24_13 466.4112309285066
R21728 n_25_24_13 n_25_25_13 158.75094299051784
R21729 n_25_24_13 n_25_24_14 0.7997004811949894
R21730 n_25_24_14 n_26_24_14 51.82347010316761
R21731 n_25_24_14 n_25_25_14 17.638993665613164
R21732 n_25_24_14 n_25_24_15 24.7107448689254
R21733 n_25_24_15 n_26_24_15 17140.61273662252
R21734 n_25_24_15 n_25_25_15 5834.097154901498
R21735 n_25_25_0 n_26_25_0 244.86589623746778
R21736 n_25_25_0 n_25_26_0 83.3442450700222
R21737 n_25_25_0 n_25_25_1 19.792586909576038
R21738 n_25_25_1 n_26_25_1 342.81225473245485
R21739 n_25_25_1 n_25_26_1 116.68194309803108
R21740 n_25_25_1 n_25_25_2 44.983152067218285
R21741 n_25_25_2 n_26_25_2 612.1647405936694
R21742 n_25_25_2 n_25_26_2 208.3606126750555
R21743 n_25_25_2 n_25_25_3 42.104230334916316
R21744 n_25_25_3 n_26_25_3 8570.306368311365
R21745 n_25_25_3 n_25_26_3 2917.048577450775
R21746 n_25_25_3 n_25_25_4 0.5597903368364947
R21747 n_25_25_4 n_26_25_4 259.7062535851928
R21748 n_25_25_4 n_25_26_4 88.39541143790225
R21749 n_25_25_4 n_25_25_5 0.46268384983424565
R21750 n_25_25_5 n_26_25_5 1632.4393082497834
R21751 n_25_25_5 n_25_26_5 555.6283004668143
R21752 n_25_25_5 n_25_25_6 0.1599400962389985
R21753 n_25_25_6 n_26_25_6 272.07321804163064
R21754 n_25_25_6 n_25_26_6 92.60471674446904
R21755 n_25_25_6 n_25_25_7 0.21706155918149772
R21756 n_25_25_7 n_26_25_7 466.4112309285111
R21757 n_25_25_7 n_25_26_7 158.75094299051884
R21758 n_25_25_7 n_25_25_8 0.159940096238998
R21759 n_25_25_8 n_26_25_8 466.4112309285111
R21760 n_25_25_8 n_25_26_8 158.75094299051884
R21761 n_25_25_8 n_25_25_9 0.159940096238998
R21762 n_25_25_9 n_26_25_9 466.4112309285111
R21763 n_25_25_9 n_25_26_9 158.75094299051884
R21764 n_25_25_9 n_25_25_10 0.159940096238998
R21765 n_25_25_10 n_26_25_10 466.4112309285111
R21766 n_25_25_10 n_25_26_10 158.75094299051884
R21767 n_25_25_10 n_25_25_11 0.15994009623899696
R21768 n_25_25_11 n_26_25_11 466.411230928517
R21769 n_25_25_11 n_25_26_11 158.75094299052085
R21770 n_25_25_11 n_25_25_12 0.15994009623899647
R21771 n_25_25_12 n_26_25_12 466.4112309285139
R21772 n_25_25_12 n_25_26_12 158.75094299051983
R21773 n_25_25_12 n_25_25_13 0.15994009623899796
R21774 n_25_25_13 n_26_25_13 466.41123092850813
R21775 n_25_25_13 n_25_26_13 158.75094299051784
R21776 n_25_25_13 n_25_25_14 0.7997004811949919
R21777 n_25_25_14 n_26_25_14 51.82347010316778
R21778 n_25_25_14 n_25_26_14 17.638993665613164
R21779 n_25_25_14 n_25_25_15 24.71074486892548
R21780 n_25_25_15 n_26_25_15 17140.612736622574
R21781 n_25_25_15 n_25_26_15 5834.097154901498
R21782 n_25_26_0 n_26_26_0 244.86589623746698
R21783 n_25_26_0 n_25_27_0 83.34424507002234
R21784 n_25_26_0 n_25_26_1 19.79258690957598
R21785 n_25_26_1 n_26_26_1 342.8122547324537
R21786 n_25_26_1 n_25_27_1 116.68194309803127
R21787 n_25_26_1 n_25_26_2 44.983152067218136
R21788 n_25_26_2 n_26_26_2 612.1647405936675
R21789 n_25_26_2 n_25_27_2 208.36061267505582
R21790 n_25_26_2 n_25_26_3 42.10423033491618
R21791 n_25_26_3 n_26_26_3 8570.306368311336
R21792 n_25_26_3 n_25_27_3 2917.0485774507797
R21793 n_25_26_3 n_25_26_4 0.5597903368364929
R21794 n_25_26_4 n_26_26_4 259.70625358519203
R21795 n_25_26_4 n_25_27_4 88.3954114379024
R21796 n_25_26_4 n_25_26_5 0.46268384983424415
R21797 n_25_26_5 n_26_26_5 1632.4393082497784
R21798 n_25_26_5 n_25_27_5 555.6283004668152
R21799 n_25_26_5 n_25_26_6 0.15994009623899796
R21800 n_25_26_6 n_26_26_6 272.07321804162973
R21801 n_25_26_6 n_25_27_6 92.60471674446919
R21802 n_25_26_6 n_25_26_7 0.217061559181497
R21803 n_25_26_7 n_26_26_7 466.4112309285095
R21804 n_25_26_7 n_25_27_7 158.7509429905191
R21805 n_25_26_7 n_25_26_8 0.15994009623899746
R21806 n_25_26_8 n_26_26_8 466.4112309285095
R21807 n_25_26_8 n_25_27_8 158.7509429905191
R21808 n_25_26_8 n_25_26_9 0.15994009623899746
R21809 n_25_26_9 n_26_26_9 466.4112309285095
R21810 n_25_26_9 n_25_27_9 158.7509429905191
R21811 n_25_26_9 n_25_26_10 0.15994009623899746
R21812 n_25_26_10 n_26_26_10 466.4112309285095
R21813 n_25_26_10 n_25_27_10 158.7509429905191
R21814 n_25_26_10 n_25_26_11 0.15994009623899644
R21815 n_25_26_11 n_26_26_11 466.41123092851547
R21816 n_25_26_11 n_25_27_11 158.7509429905211
R21817 n_25_26_11 n_25_26_12 0.1599400962389959
R21818 n_25_26_12 n_26_26_12 466.4112309285125
R21819 n_25_26_12 n_25_27_12 158.7509429905201
R21820 n_25_26_12 n_25_26_13 0.15994009623899746
R21821 n_25_26_13 n_26_26_13 466.4112309285066
R21822 n_25_26_13 n_25_27_13 158.7509429905181
R21823 n_25_26_13 n_25_26_14 0.7997004811949894
R21824 n_25_26_14 n_26_26_14 51.82347010316761
R21825 n_25_26_14 n_25_27_14 17.638993665613192
R21826 n_25_26_14 n_25_26_15 24.7107448689254
R21827 n_25_26_15 n_26_26_15 17140.61273662252
R21828 n_25_26_15 n_25_27_15 5834.097154901507
R21829 n_25_27_0 n_26_27_0 244.86589623746698
R21830 n_25_27_0 n_25_27_1 19.79258690957598
R21831 n_25_27_1 n_26_27_1 342.8122547324537
R21832 n_25_27_1 n_25_27_2 44.983152067218136
R21833 n_25_27_2 n_26_27_2 612.1647405936675
R21834 n_25_27_2 n_25_27_3 42.10423033491618
R21835 n_25_27_3 n_26_27_3 8570.306368311336
R21836 n_25_27_3 n_25_27_4 0.5597903368364929
R21837 n_25_27_4 n_26_27_4 259.70625358519203
R21838 n_25_27_4 n_25_27_5 0.46268384983424415
R21839 n_25_27_5 n_26_27_5 1632.4393082497784
R21840 n_25_27_5 n_25_27_6 0.15994009623899796
R21841 n_25_27_6 n_26_27_6 272.07321804162973
R21842 n_25_27_6 n_25_27_7 0.217061559181497
R21843 n_25_27_7 n_26_27_7 466.4112309285095
R21844 n_25_27_7 n_25_27_8 0.15994009623899746
R21845 n_25_27_8 n_26_27_8 466.4112309285095
R21846 n_25_27_8 n_25_27_9 0.15994009623899746
R21847 n_25_27_9 n_26_27_9 466.4112309285095
R21848 n_25_27_9 n_25_27_10 0.15994009623899746
R21849 n_25_27_10 n_26_27_10 466.4112309285095
R21850 n_25_27_10 n_25_27_11 0.15994009623899644
R21851 n_25_27_11 n_26_27_11 466.41123092851547
R21852 n_25_27_11 n_25_27_12 0.1599400962389959
R21853 n_25_27_12 n_26_27_12 466.4112309285125
R21854 n_25_27_12 n_25_27_13 0.15994009623899746
R21855 n_25_27_13 n_26_27_13 466.4112309285066
R21856 n_25_27_13 n_25_27_14 0.7997004811949894
R21857 n_25_27_14 n_26_27_14 51.82347010316761
R21858 n_25_27_14 n_25_27_15 24.7107448689254
R21859 n_25_27_15 n_26_27_15 17140.61273662252
R21860 n_26_0_0 n_27_0_0 244.86587514965544
R21861 n_26_0_0 n_26_1_0 83.34425224761607
R21862 n_26_0_0 n_26_0_1 19.79258520504162
R21863 n_26_0_1 n_27_0_1 342.8122252095176
R21864 n_26_0_1 n_26_1_1 116.68195314666251
R21865 n_26_0_1 n_26_0_2 44.98314819327641
R21866 n_26_0_2 n_27_0_2 612.1646878741385
R21867 n_26_0_2 n_26_1_2 208.3606306190402
R21868 n_26_0_2 n_26_0_3 42.10422670890672
R21869 n_26_0_3 n_27_0_3 8570.30563023793
R21870 n_26_0_3 n_26_1_3 2917.04882866656
R21871 n_26_0_3 n_26_0_4 0.5597902886274403
R21872 n_26_0_4 n_27_0_4 259.70623121933124
R21873 n_26_0_4 n_26_1_4 88.39541905050183
R21874 n_26_0_4 n_26_0_5 0.46268380998798636
R21875 n_26_0_5 n_27_0_5 1632.4391676643677
R21876 n_26_0_5 n_26_1_5 555.62834831744
R21877 n_26_0_5 n_26_0_6 0.15994008246498298
R21878 n_26_0_6 n_27_0_6 272.073194610728
R21879 n_26_0_6 n_26_1_6 92.60472471957334
R21880 n_26_0_6 n_26_0_7 0.21706154048819093
R21881 n_26_0_7 n_27_0_7 466.41119076124943
R21882 n_26_0_7 n_26_1_7 158.7509566621262
R21883 n_26_0_7 n_26_0_8 0.15994008246498245
R21884 n_26_0_8 n_27_0_8 466.41119076124943
R21885 n_26_0_8 n_26_1_8 158.7509566621262
R21886 n_26_0_8 n_26_0_9 0.15994008246498245
R21887 n_26_0_9 n_27_0_9 466.41119076124943
R21888 n_26_0_9 n_26_1_9 158.7509566621262
R21889 n_26_0_9 n_26_0_10 0.15994008246498245
R21890 n_26_0_10 n_27_0_10 466.41119076124943
R21891 n_26_0_10 n_26_1_10 158.7509566621262
R21892 n_26_0_10 n_26_0_11 0.15994008246498143
R21893 n_26_0_11 n_27_0_11 466.4111907612554
R21894 n_26_0_11 n_26_1_11 158.75095666212826
R21895 n_26_0_11 n_26_0_12 0.15994008246498093
R21896 n_26_0_12 n_27_0_12 466.41119076125256
R21897 n_26_0_12 n_26_1_12 158.7509566621272
R21898 n_26_0_12 n_26_0_13 0.15994008246498245
R21899 n_26_0_13 n_27_0_13 466.41119076124653
R21900 n_26_0_13 n_26_1_13 158.7509566621252
R21901 n_26_0_13 n_26_0_14 0.7997004123249143
R21902 n_26_0_14 n_27_0_14 51.82346564013872
R21903 n_26_0_14 n_26_1_14 17.638995184680656
R21904 n_26_0_14 n_26_0_15 24.710742740840075
R21905 n_26_0_15 n_27_0_15 17140.611260475715
R21906 n_26_0_15 n_26_1_15 5834.097657333067
R21907 n_26_1_0 n_27_1_0 244.86587514965544
R21908 n_26_1_0 n_26_2_0 83.34425224761607
R21909 n_26_1_0 n_26_1_1 19.79258520504162
R21910 n_26_1_1 n_27_1_1 342.8122252095176
R21911 n_26_1_1 n_26_2_1 116.68195314666251
R21912 n_26_1_1 n_26_1_2 44.98314819327641
R21913 n_26_1_2 n_27_1_2 612.1646878741385
R21914 n_26_1_2 n_26_2_2 208.3606306190402
R21915 n_26_1_2 n_26_1_3 42.10422670890672
R21916 n_26_1_3 n_27_1_3 8570.30563023793
R21917 n_26_1_3 n_26_2_3 2917.04882866656
R21918 n_26_1_3 n_26_1_4 0.5597902886274403
R21919 n_26_1_4 n_27_1_4 259.70623121933124
R21920 n_26_1_4 n_26_2_4 88.39541905050183
R21921 n_26_1_4 n_26_1_5 0.46268380998798636
R21922 n_26_1_5 n_27_1_5 1632.4391676643677
R21923 n_26_1_5 n_26_2_5 555.62834831744
R21924 n_26_1_5 n_26_1_6 0.15994008246498298
R21925 n_26_1_6 n_27_1_6 272.073194610728
R21926 n_26_1_6 n_26_2_6 92.60472471957334
R21927 n_26_1_6 n_26_1_7 0.21706154048819093
R21928 n_26_1_7 n_27_1_7 466.41119076124943
R21929 n_26_1_7 n_26_2_7 158.7509566621262
R21930 n_26_1_7 n_26_1_8 0.15994008246498245
R21931 n_26_1_8 n_27_1_8 466.41119076124943
R21932 n_26_1_8 n_26_2_8 158.7509566621262
R21933 n_26_1_8 n_26_1_9 0.15994008246498245
R21934 n_26_1_9 n_27_1_9 466.41119076124943
R21935 n_26_1_9 n_26_2_9 158.7509566621262
R21936 n_26_1_9 n_26_1_10 0.15994008246498245
R21937 n_26_1_10 n_27_1_10 466.41119076124943
R21938 n_26_1_10 n_26_2_10 158.7509566621262
R21939 n_26_1_10 n_26_1_11 0.15994008246498143
R21940 n_26_1_11 n_27_1_11 466.4111907612554
R21941 n_26_1_11 n_26_2_11 158.75095666212826
R21942 n_26_1_11 n_26_1_12 0.15994008246498093
R21943 n_26_1_12 n_27_1_12 466.41119076125256
R21944 n_26_1_12 n_26_2_12 158.7509566621272
R21945 n_26_1_12 n_26_1_13 0.15994008246498245
R21946 n_26_1_13 n_27_1_13 466.41119076124653
R21947 n_26_1_13 n_26_2_13 158.7509566621252
R21948 n_26_1_13 n_26_1_14 0.7997004123249143
R21949 n_26_1_14 n_27_1_14 51.82346564013872
R21950 n_26_1_14 n_26_2_14 17.638995184680656
R21951 n_26_1_14 n_26_1_15 24.710742740840075
R21952 n_26_1_15 n_27_1_15 17140.611260475715
R21953 n_26_1_15 n_26_2_15 5834.097657333067
R21954 n_26_2_0 n_27_2_0 244.86587514965544
R21955 n_26_2_0 n_26_3_0 83.34425224761607
R21956 n_26_2_0 n_26_2_1 19.79258520504162
R21957 n_26_2_1 n_27_2_1 342.8122252095176
R21958 n_26_2_1 n_26_3_1 116.68195314666251
R21959 n_26_2_1 n_26_2_2 44.98314819327641
R21960 n_26_2_2 n_27_2_2 612.1646878741385
R21961 n_26_2_2 n_26_3_2 208.3606306190402
R21962 n_26_2_2 n_26_2_3 42.10422670890672
R21963 n_26_2_3 n_27_2_3 8570.30563023793
R21964 n_26_2_3 n_26_3_3 2917.04882866656
R21965 n_26_2_3 n_26_2_4 0.5597902886274403
R21966 n_26_2_4 n_27_2_4 259.70623121933124
R21967 n_26_2_4 n_26_3_4 88.39541905050183
R21968 n_26_2_4 n_26_2_5 0.46268380998798636
R21969 n_26_2_5 n_27_2_5 1632.4391676643677
R21970 n_26_2_5 n_26_3_5 555.62834831744
R21971 n_26_2_5 n_26_2_6 0.15994008246498298
R21972 n_26_2_6 n_27_2_6 272.073194610728
R21973 n_26_2_6 n_26_3_6 92.60472471957334
R21974 n_26_2_6 n_26_2_7 0.21706154048819093
R21975 n_26_2_7 n_27_2_7 466.41119076124943
R21976 n_26_2_7 n_26_3_7 158.7509566621262
R21977 n_26_2_7 n_26_2_8 0.15994008246498245
R21978 n_26_2_8 n_27_2_8 466.41119076124943
R21979 n_26_2_8 n_26_3_8 158.7509566621262
R21980 n_26_2_8 n_26_2_9 0.15994008246498245
R21981 n_26_2_9 n_27_2_9 466.41119076124943
R21982 n_26_2_9 n_26_3_9 158.7509566621262
R21983 n_26_2_9 n_26_2_10 0.15994008246498245
R21984 n_26_2_10 n_27_2_10 466.41119076124943
R21985 n_26_2_10 n_26_3_10 158.7509566621262
R21986 n_26_2_10 n_26_2_11 0.15994008246498143
R21987 n_26_2_11 n_27_2_11 466.4111907612554
R21988 n_26_2_11 n_26_3_11 158.75095666212826
R21989 n_26_2_11 n_26_2_12 0.15994008246498093
R21990 n_26_2_12 n_27_2_12 466.41119076125256
R21991 n_26_2_12 n_26_3_12 158.7509566621272
R21992 n_26_2_12 n_26_2_13 0.15994008246498245
R21993 n_26_2_13 n_27_2_13 466.41119076124653
R21994 n_26_2_13 n_26_3_13 158.7509566621252
R21995 n_26_2_13 n_26_2_14 0.7997004123249143
R21996 n_26_2_14 n_27_2_14 51.82346564013872
R21997 n_26_2_14 n_26_3_14 17.638995184680656
R21998 n_26_2_14 n_26_2_15 24.710742740840075
R21999 n_26_2_15 n_27_2_15 17140.611260475715
R22000 n_26_2_15 n_26_3_15 5834.097657333067
R22001 n_26_3_0 n_27_3_0 244.86587514965544
R22002 n_26_3_0 n_26_4_0 43.561715139231055
R22003 n_26_3_0 n_26_3_1 19.79258520504162
R22004 n_26_3_1 n_27_3_1 342.8122252095176
R22005 n_26_3_1 n_26_4_1 60.98640119492349
R22006 n_26_3_1 n_26_3_2 44.98314819327641
R22007 n_26_3_2 n_27_3_2 612.1646878741385
R22008 n_26_3_2 n_26_4_2 108.90428784807766
R22009 n_26_3_2 n_26_3_3 42.10422670890672
R22010 n_26_3_3 n_27_3_3 8570.30563023793
R22011 n_26_3_3 n_26_4_3 1524.6600298730857
R22012 n_26_3_3 n_26_3_4 0.5597902886274403
R22013 n_26_3_4 n_27_3_4 259.70623121933124
R22014 n_26_3_4 n_26_4_4 46.20181908706321
R22015 n_26_3_4 n_26_3_5 0.46268380998798636
R22016 n_26_3_5 n_27_3_5 1632.4391676643677
R22017 n_26_3_5 n_26_3_6 0.15994008246498298
R22018 n_26_3_6 n_27_3_6 272.073194610728
R22019 n_26_3_6 n_26_3_7 0.21706154048819093
R22020 n_26_3_7 n_27_3_7 466.41119076124943
R22021 n_26_3_7 n_26_3_8 0.15994008246498245
R22022 n_26_3_8 n_27_3_8 466.41119076124943
R22023 n_26_3_8 n_26_3_9 0.15994008246498245
R22024 n_26_3_9 n_27_3_9 466.41119076124943
R22025 n_26_3_9 n_26_3_10 0.15994008246498245
R22026 n_26_3_10 n_27_3_10 466.41119076124943
R22027 n_26_3_10 n_26_3_11 0.15994008246498143
R22028 n_26_3_11 n_27_3_11 466.4111907612554
R22029 n_26_3_11 n_26_3_12 0.15994008246498093
R22030 n_26_3_12 n_27_3_12 466.41119076125256
R22031 n_26_3_12 n_26_3_13 0.15994008246498245
R22032 n_26_3_13 n_27_3_13 466.41119076124653
R22033 n_26_3_13 n_26_3_14 0.7997004123249143
R22034 n_26_3_14 n_27_3_14 51.82346564013872
R22035 n_26_3_14 n_26_3_15 24.710742740840075
R22036 n_26_3_15 n_27_3_15 17140.611260475715
R22037 n_26_3_15 n_26_4_15 3049.320059746144
R22038 n_26_4_0 n_27_4_0 5400.159267103212
R22039 n_26_4_0 n_26_5_0 3.7791780308460794
R22040 n_26_4_0 n_26_4_1 436.4965610239131
R22041 n_26_4_1 n_27_4_1 7560.2229739444965
R22042 n_26_4_1 n_26_5_1 5.290849243184511
R22043 n_26_4_1 n_26_4_2 992.0376386907114
R22044 n_26_4_2 n_27_4_2 13500.39816775803
R22045 n_26_4_2 n_26_5_2 9.4479450771152
R22046 n_26_4_2 n_26_4_3 928.547229814506
R22047 n_26_4_3 n_27_4_3 189005.57434861228
R22048 n_26_4_3 n_26_5_3 132.27123107961268
R22049 n_26_4_3 n_26_4_4 12.345357281484421
R22050 n_26_4_4 n_27_4_4 5727.441646927644
R22051 n_26_4_4 n_26_5_4 4.008219123624627
R22052 n_26_4_15 n_27_4_15 378011.1486972212
R22053 n_26_4_15 n_26_5_15 264.54246215922296
R22054 n_26_5_0 n_27_5_0 5400.159267103118
R22055 n_26_5_0 n_26_6_0 3.779178030846113
R22056 n_26_5_0 n_26_5_1 436.49656102390526
R22057 n_26_5_1 n_27_5_1 7560.222973944362
R22058 n_26_5_1 n_26_6_1 5.290849243184558
R22059 n_26_5_1 n_26_5_2 992.0376386906937
R22060 n_26_5_2 n_27_5_2 13500.39816775779
R22061 n_26_5_2 n_26_6_2 9.447945077115284
R22062 n_26_5_2 n_26_5_3 928.5472298144894
R22063 n_26_5_3 n_27_5_3 189005.5743486089
R22064 n_26_5_3 n_26_6_3 132.27123107961384
R22065 n_26_5_3 n_26_5_4 12.345357281484201
R22066 n_26_5_4 n_27_5_4 5727.441646927542
R22067 n_26_5_4 n_26_6_4 4.008219123624663
R22068 n_26_5_15 n_27_5_15 378011.14869721443
R22069 n_26_5_15 n_26_6_15 264.5424621592253
R22070 n_26_6_0 n_27_6_0 5400.159267103118
R22071 n_26_6_0 n_26_7_0 3.7791780308460794
R22072 n_26_6_0 n_26_6_1 436.49656102390526
R22073 n_26_6_1 n_27_6_1 7560.222973944362
R22074 n_26_6_1 n_26_7_1 5.290849243184511
R22075 n_26_6_1 n_26_6_2 992.0376386906937
R22076 n_26_6_2 n_27_6_2 13500.39816775779
R22077 n_26_6_2 n_26_7_2 9.4479450771152
R22078 n_26_6_2 n_26_6_3 928.5472298144894
R22079 n_26_6_3 n_27_6_3 189005.5743486089
R22080 n_26_6_3 n_26_7_3 132.27123107961268
R22081 n_26_6_3 n_26_6_4 12.345357281484201
R22082 n_26_6_4 n_27_6_4 5727.441646927542
R22083 n_26_6_4 n_26_7_4 4.008219123624627
R22084 n_26_6_15 n_27_6_15 378011.14869721443
R22085 n_26_6_15 n_26_7_15 264.54246215922296
R22086 n_26_7_0 n_27_7_0 5400.159267103212
R22087 n_26_7_0 n_26_8_0 110.4436503862855
R22088 n_26_7_0 n_26_7_1 436.4965610239131
R22089 n_26_7_1 n_27_7_1 7560.2229739444965
R22090 n_26_7_1 n_26_8_1 154.6211105407997
R22091 n_26_7_1 n_26_7_2 992.0376386907114
R22092 n_26_7_2 n_27_7_2 13500.39816775803
R22093 n_26_7_2 n_26_8_2 276.10912596571376
R22094 n_26_7_2 n_26_7_3 928.547229814506
R22095 n_26_7_3 n_27_7_3 189005.57434861228
R22096 n_26_7_3 n_26_8_3 3865.5277635199886
R22097 n_26_7_3 n_26_7_4 12.345357281484421
R22098 n_26_7_4 n_27_7_4 5727.441646927644
R22099 n_26_7_4 n_26_8_4 117.13720495515119
R22100 n_26_7_15 n_27_7_15 378011.1486972212
R22101 n_26_7_15 n_26_8_15 7731.055527039908
R22102 n_26_8_0 n_27_8_0 93.99999874525193
R22103 n_26_8_0 n_26_9_0 217.108122741725
R22104 n_26_8_0 n_26_8_1 7.598049272084627
R22105 n_26_8_1 n_27_8_1 131.59999824335267
R22106 n_26_8_1 n_26_9_1 303.95137183841496
R22107 n_26_8_1 n_26_8_2 17.268293800192332
R22108 n_26_8_2 n_27_8_2 234.9999968631298
R22109 n_26_8_2 n_26_9_2 542.7703068543126
R22110 n_26_8_2 n_26_8_3 16.16312299698002
R22111 n_26_8_3 n_27_8_3 3289.9999560838146
R22112 n_26_8_3 n_26_9_3 7598.784295960368
R22113 n_26_8_3 n_26_8_4 0.21489432284683813
R22114 n_26_8_4 n_27_8_4 99.69696836617621
R22115 n_26_8_4 n_26_9_4 230.26619078667784
R22116 n_26_8_4 n_26_8_5 0.21489432284683813
R22117 n_26_8_5 n_27_8_5 3289.9999560838146
R22118 n_26_8_5 n_26_9_5 7598.784295960368
R22119 n_26_8_5 n_26_8_6 0.4144390512046164
R22120 n_26_8_6 n_27_8_6 731.1111013519587
R22121 n_26_8_6 n_26_9_6 1688.6187324356374
R22122 n_26_8_6 n_26_8_7 0.5832845905842742
R22123 n_26_8_7 n_27_8_7 1253.333316603362
R22124 n_26_8_7 n_26_9_7 2894.7749698896732
R22125 n_26_8_7 n_26_8_8 0.42978864569367486
R22126 n_26_8_8 n_27_8_8 1253.333316603362
R22127 n_26_8_8 n_26_9_8 2894.7749698896732
R22128 n_26_8_8 n_26_8_9 0.42978864569367486
R22129 n_26_8_9 n_27_8_9 1253.333316603362
R22130 n_26_8_9 n_26_9_9 2894.7749698896732
R22131 n_26_8_9 n_26_8_10 0.42978864569367486
R22132 n_26_8_10 n_27_8_10 1253.333316603362
R22133 n_26_8_10 n_26_9_10 2894.7749698896732
R22134 n_26_8_10 n_26_8_11 0.42978864569367214
R22135 n_26_8_11 n_27_8_11 1253.3333166033776
R22136 n_26_8_11 n_26_9_11 2894.7749698897105
R22137 n_26_8_11 n_26_8_12 0.42978864569367076
R22138 n_26_8_12 n_27_8_12 1253.33331660337
R22139 n_26_8_12 n_26_9_12 2894.7749698896914
R22140 n_26_8_12 n_26_8_13 0.4297886456936749
R22141 n_26_8_13 n_27_8_13 1253.333316603354
R22142 n_26_8_13 n_26_9_13 2894.774969889655
R22143 n_26_8_13 n_26_8_14 2.14894322846838
R22144 n_26_8_14 n_27_8_14 139.25925740037326
R22145 n_26_8_14 n_26_9_14 321.64166332107413
R22146 n_26_8_14 n_26_8_15 11.143805599057542
R22147 n_26_8_15 n_27_8_15 6579.999912167571
R22148 n_26_8_15 n_26_9_15 15197.5685919206
R22149 n_26_9_0 n_27_9_0 93.99999874525187
R22150 n_26_9_0 n_26_10_0 217.108122741725
R22151 n_26_9_0 n_26_9_1 7.598049272084621
R22152 n_26_9_1 n_27_9_1 131.59999824335262
R22153 n_26_9_1 n_26_10_1 303.95137183841496
R22154 n_26_9_1 n_26_9_2 17.26829380019232
R22155 n_26_9_2 n_27_9_2 234.99999686312967
R22156 n_26_9_2 n_26_10_2 542.7703068543126
R22157 n_26_9_2 n_26_9_3 16.16312299698001
R22158 n_26_9_3 n_27_9_3 3289.999956083813
R22159 n_26_9_3 n_26_10_3 7598.784295960368
R22160 n_26_9_3 n_26_9_4 0.21489432284683796
R22161 n_26_9_4 n_27_9_4 99.69696836617614
R22162 n_26_9_4 n_26_10_4 230.26619078667784
R22163 n_26_9_4 n_26_9_5 0.21489432284683796
R22164 n_26_9_5 n_27_9_5 3289.999956083813
R22165 n_26_9_5 n_26_10_5 7598.784295960368
R22166 n_26_9_5 n_26_9_6 0.41443905120461605
R22167 n_26_9_6 n_27_9_6 731.1111013519583
R22168 n_26_9_6 n_26_10_6 1688.6187324356374
R22169 n_26_9_6 n_26_9_7 0.5832845905842738
R22170 n_26_9_7 n_27_9_7 1253.3333166033608
R22171 n_26_9_7 n_26_10_7 2894.7749698896732
R22172 n_26_9_7 n_26_9_8 0.4297886456936746
R22173 n_26_9_8 n_27_9_8 1253.3333166033608
R22174 n_26_9_8 n_26_10_8 2894.7749698896732
R22175 n_26_9_8 n_26_9_9 0.4297886456936746
R22176 n_26_9_9 n_27_9_9 1253.3333166033608
R22177 n_26_9_9 n_26_10_9 2894.7749698896732
R22178 n_26_9_9 n_26_9_10 0.4297886456936746
R22179 n_26_9_10 n_27_9_10 1253.3333166033608
R22180 n_26_9_10 n_26_10_10 2894.7749698896732
R22181 n_26_9_10 n_26_9_11 0.4297886456936718
R22182 n_26_9_11 n_27_9_11 1253.3333166033772
R22183 n_26_9_11 n_26_10_11 2894.7749698897105
R22184 n_26_9_11 n_26_9_12 0.4297886456936705
R22185 n_26_9_12 n_27_9_12 1253.333316603369
R22186 n_26_9_12 n_26_10_12 2894.7749698896914
R22187 n_26_9_12 n_26_9_13 0.4297886456936746
R22188 n_26_9_13 n_27_9_13 1253.333316603353
R22189 n_26_9_13 n_26_10_13 2894.774969889655
R22190 n_26_9_13 n_26_9_14 2.1489432284683785
R22191 n_26_9_14 n_27_9_14 139.25925740037314
R22192 n_26_9_14 n_26_10_14 321.64166332107413
R22193 n_26_9_14 n_26_9_15 11.143805599057533
R22194 n_26_9_15 n_27_9_15 6579.999912167567
R22195 n_26_9_15 n_26_10_15 15197.5685919206
R22196 n_26_10_0 n_27_10_0 93.99999874525193
R22197 n_26_10_0 n_26_11_0 217.10812274172494
R22198 n_26_10_0 n_26_10_1 7.598049272084627
R22199 n_26_10_1 n_27_10_1 131.59999824335267
R22200 n_26_10_1 n_26_11_1 303.9513718384149
R22201 n_26_10_1 n_26_10_2 17.268293800192332
R22202 n_26_10_2 n_27_10_2 234.9999968631298
R22203 n_26_10_2 n_26_11_2 542.7703068543124
R22204 n_26_10_2 n_26_10_3 16.16312299698002
R22205 n_26_10_3 n_27_10_3 3289.9999560838146
R22206 n_26_10_3 n_26_11_3 7598.784295960366
R22207 n_26_10_3 n_26_10_4 0.21489432284683813
R22208 n_26_10_4 n_27_10_4 99.69696836617621
R22209 n_26_10_4 n_26_11_4 230.26619078667778
R22210 n_26_10_4 n_26_10_5 0.21489432284683813
R22211 n_26_10_5 n_27_10_5 3289.9999560838146
R22212 n_26_10_5 n_26_11_5 7598.784295960366
R22213 n_26_10_5 n_26_10_6 0.4144390512046164
R22214 n_26_10_6 n_27_10_6 731.1111013519587
R22215 n_26_10_6 n_26_11_6 1688.618732435637
R22216 n_26_10_6 n_26_10_7 0.5832845905842742
R22217 n_26_10_7 n_27_10_7 1253.333316603362
R22218 n_26_10_7 n_26_11_7 2894.7749698896723
R22219 n_26_10_7 n_26_10_8 0.42978864569367486
R22220 n_26_10_8 n_27_10_8 1253.333316603362
R22221 n_26_10_8 n_26_11_8 2894.7749698896723
R22222 n_26_10_8 n_26_10_9 0.42978864569367486
R22223 n_26_10_9 n_27_10_9 1253.333316603362
R22224 n_26_10_9 n_26_11_9 2894.7749698896723
R22225 n_26_10_9 n_26_10_10 0.42978864569367486
R22226 n_26_10_10 n_27_10_10 1253.333316603362
R22227 n_26_10_10 n_26_11_10 2894.7749698896723
R22228 n_26_10_10 n_26_10_11 0.42978864569367214
R22229 n_26_10_11 n_27_10_11 1253.3333166033776
R22230 n_26_10_11 n_26_11_11 2894.7749698897096
R22231 n_26_10_11 n_26_10_12 0.42978864569367076
R22232 n_26_10_12 n_27_10_12 1253.33331660337
R22233 n_26_10_12 n_26_11_12 2894.7749698896905
R22234 n_26_10_12 n_26_10_13 0.4297886456936749
R22235 n_26_10_13 n_27_10_13 1253.333316603354
R22236 n_26_10_13 n_26_11_13 2894.774969889654
R22237 n_26_10_13 n_26_10_14 2.14894322846838
R22238 n_26_10_14 n_27_10_14 139.25925740037326
R22239 n_26_10_14 n_26_11_14 321.6416633210741
R22240 n_26_10_14 n_26_10_15 11.143805599057542
R22241 n_26_10_15 n_27_10_15 6579.999912167571
R22242 n_26_10_15 n_26_11_15 15197.568591920595
R22243 n_26_11_0 n_27_11_0 93.99999874525193
R22244 n_26_11_0 n_26_12_0 110.44365362970524
R22245 n_26_11_0 n_26_11_1 7.598049272084627
R22246 n_26_11_1 n_27_11_1 131.59999824335267
R22247 n_26_11_1 n_26_12_1 154.62111508158733
R22248 n_26_11_1 n_26_11_2 17.268293800192332
R22249 n_26_11_2 n_27_11_2 234.9999968631298
R22250 n_26_11_2 n_26_12_2 276.1091340742631
R22251 n_26_11_2 n_26_11_3 16.16312299698002
R22252 n_26_11_3 n_27_11_3 3289.9999560838146
R22253 n_26_11_3 n_26_12_3 3865.52787703968
R22254 n_26_11_3 n_26_11_4 0.21489432284683813
R22255 n_26_11_4 n_27_11_4 99.69696836617621
R22256 n_26_11_4 n_26_12_4 117.13720839514183
R22257 n_26_11_4 n_26_11_5 0.21489432284683813
R22258 n_26_11_5 n_27_11_5 3289.9999560838146
R22259 n_26_11_5 n_26_11_6 0.4144390512046164
R22260 n_26_11_6 n_27_11_6 731.1111013519587
R22261 n_26_11_6 n_26_11_7 0.5832845905842742
R22262 n_26_11_7 n_27_11_7 1253.333316603362
R22263 n_26_11_7 n_26_11_8 0.42978864569367486
R22264 n_26_11_8 n_27_11_8 1253.333316603362
R22265 n_26_11_8 n_26_11_9 0.42978864569367486
R22266 n_26_11_9 n_27_11_9 1253.333316603362
R22267 n_26_11_9 n_26_11_10 0.42978864569367486
R22268 n_26_11_10 n_27_11_10 1253.333316603362
R22269 n_26_11_10 n_26_11_11 0.42978864569367214
R22270 n_26_11_11 n_27_11_11 1253.3333166033776
R22271 n_26_11_11 n_26_11_12 0.42978864569367076
R22272 n_26_11_12 n_27_11_12 1253.33331660337
R22273 n_26_11_12 n_26_11_13 0.4297886456936749
R22274 n_26_11_13 n_27_11_13 1253.333316603354
R22275 n_26_11_13 n_26_11_14 2.14894322846838
R22276 n_26_11_14 n_27_11_14 139.25925740037326
R22277 n_26_11_14 n_26_11_15 11.143805599057542
R22278 n_26_11_15 n_27_11_15 6579.999912167571
R22279 n_26_11_15 n_26_12_15 7731.05575407929
R22280 n_26_12_0 n_27_12_0 5400.1499979166465
R22281 n_26_12_0 n_26_13_0 3.7791845176855317
R22282 n_26_12_0 n_26_12_1 436.4958117926664
R22283 n_26_12_1 n_27_12_1 7560.209997083305
R22284 n_26_12_1 n_26_13_1 5.290858324759744
R22285 n_26_12_1 n_26_12_2 992.0359358924237
R22286 n_26_12_2 n_27_12_2 13500.374994791619
R22287 n_26_12_2 n_26_13_2 9.44796129421383
R22288 n_26_12_2 n_26_12_3 928.5456359953087
R22289 n_26_12_3 n_27_12_3 189005.24992708245
R22290 n_26_12_3 n_26_13_3 132.27145811899348
R22291 n_26_12_3 n_26_12_4 12.345336091105729
R22292 n_26_12_4 n_27_12_4 5727.431815972196
R22293 n_26_12_4 n_26_13_4 4.008226003605864
R22294 n_26_12_15 n_27_12_15 378010.4998541616
R22295 n_26_12_15 n_26_13_15 264.54291623798457
R22296 n_26_13_0 n_27_13_0 5400.1499979166465
R22297 n_26_13_0 n_26_14_0 3.7791845176855317
R22298 n_26_13_0 n_26_13_1 436.4958117926664
R22299 n_26_13_1 n_27_13_1 7560.209997083305
R22300 n_26_13_1 n_26_14_1 5.290858324759744
R22301 n_26_13_1 n_26_13_2 992.0359358924237
R22302 n_26_13_2 n_27_13_2 13500.374994791619
R22303 n_26_13_2 n_26_14_2 9.44796129421383
R22304 n_26_13_2 n_26_13_3 928.5456359953087
R22305 n_26_13_3 n_27_13_3 189005.24992708245
R22306 n_26_13_3 n_26_14_3 132.27145811899348
R22307 n_26_13_3 n_26_13_4 12.345336091105729
R22308 n_26_13_4 n_27_13_4 5727.431815972196
R22309 n_26_13_4 n_26_14_4 4.008226003605864
R22310 n_26_13_15 n_27_13_15 378010.4998541616
R22311 n_26_13_15 n_26_14_15 264.54291623798457
R22312 n_26_14_0 n_27_14_0 5400.1499979166465
R22313 n_26_14_0 n_26_15_0 3.7791845176855317
R22314 n_26_14_0 n_26_14_1 436.4958117926664
R22315 n_26_14_1 n_27_14_1 7560.209997083305
R22316 n_26_14_1 n_26_15_1 5.290858324759744
R22317 n_26_14_1 n_26_14_2 992.0359358924237
R22318 n_26_14_2 n_27_14_2 13500.374994791619
R22319 n_26_14_2 n_26_15_2 9.44796129421383
R22320 n_26_14_2 n_26_14_3 928.5456359953087
R22321 n_26_14_3 n_27_14_3 189005.24992708245
R22322 n_26_14_3 n_26_15_3 132.27145811899348
R22323 n_26_14_3 n_26_14_4 12.345336091105729
R22324 n_26_14_4 n_27_14_4 5727.431815972196
R22325 n_26_14_4 n_26_15_4 4.008226003605864
R22326 n_26_14_15 n_27_14_15 378010.4998541616
R22327 n_26_14_15 n_26_15_15 264.54291623798457
R22328 n_26_15_0 n_27_15_0 5400.1499979166465
R22329 n_26_15_0 n_26_16_0 110.44365362970517
R22330 n_26_15_0 n_26_15_1 436.4958117926664
R22331 n_26_15_1 n_27_15_1 7560.209997083305
R22332 n_26_15_1 n_26_16_1 154.62111508158725
R22333 n_26_15_1 n_26_15_2 992.0359358924237
R22334 n_26_15_2 n_27_15_2 13500.374994791619
R22335 n_26_15_2 n_26_16_2 276.10913407426295
R22336 n_26_15_2 n_26_15_3 928.5456359953087
R22337 n_26_15_3 n_27_15_3 189005.24992708245
R22338 n_26_15_3 n_26_16_3 3865.5278770396776
R22339 n_26_15_3 n_26_15_4 12.345336091105729
R22340 n_26_15_4 n_27_15_4 5727.431815972196
R22341 n_26_15_4 n_26_16_4 117.13720839514176
R22342 n_26_15_15 n_27_15_15 378010.4998541616
R22343 n_26_15_15 n_26_16_15 7731.055754079285
R22344 n_26_16_0 n_27_16_0 93.99999874525201
R22345 n_26_16_0 n_26_17_0 217.1081227417249
R22346 n_26_16_0 n_26_16_1 7.59804927208463
R22347 n_26_16_1 n_27_16_1 131.5999982433528
R22348 n_26_16_1 n_26_17_1 303.9513718384149
R22349 n_26_16_1 n_26_16_2 17.26829380019234
R22350 n_26_16_2 n_27_16_2 234.99999686312998
R22351 n_26_16_2 n_26_17_2 542.7703068543124
R22352 n_26_16_2 n_26_16_3 16.16312299698003
R22353 n_26_16_3 n_27_16_3 3289.9999560838164
R22354 n_26_16_3 n_26_17_3 7598.784295960366
R22355 n_26_16_3 n_26_16_4 0.21489432284683824
R22356 n_26_16_4 n_27_16_4 99.69696836617624
R22357 n_26_16_4 n_26_17_4 230.26619078667778
R22358 n_26_16_4 n_26_16_5 0.21489432284683824
R22359 n_26_16_5 n_27_16_5 3289.9999560838164
R22360 n_26_16_5 n_26_17_5 7598.784295960366
R22361 n_26_16_5 n_26_16_6 0.41443905120461655
R22362 n_26_16_6 n_27_16_6 731.1111013519592
R22363 n_26_16_6 n_26_17_6 1688.618732435637
R22364 n_26_16_6 n_26_16_7 0.5832845905842745
R22365 n_26_16_7 n_27_16_7 1253.3333166033626
R22366 n_26_16_7 n_26_17_7 2894.7749698896723
R22367 n_26_16_7 n_26_16_8 0.4297886456936751
R22368 n_26_16_8 n_27_16_8 1253.3333166033626
R22369 n_26_16_8 n_26_17_8 2894.7749698896723
R22370 n_26_16_8 n_26_16_9 0.4297886456936751
R22371 n_26_16_9 n_27_16_9 1253.3333166033626
R22372 n_26_16_9 n_26_17_9 2894.7749698896723
R22373 n_26_16_9 n_26_16_10 0.4297886456936751
R22374 n_26_16_10 n_27_16_10 1253.3333166033626
R22375 n_26_16_10 n_26_17_10 2894.7749698896723
R22376 n_26_16_10 n_26_16_11 0.42978864569367237
R22377 n_26_16_11 n_27_16_11 1253.3333166033785
R22378 n_26_16_11 n_26_17_11 2894.7749698897096
R22379 n_26_16_11 n_26_16_12 0.4297886456936709
R22380 n_26_16_12 n_27_16_12 1253.3333166033703
R22381 n_26_16_12 n_26_17_12 2894.7749698896905
R22382 n_26_16_12 n_26_16_13 0.42978864569367503
R22383 n_26_16_13 n_27_16_13 1253.333316603355
R22384 n_26_16_13 n_26_17_13 2894.774969889654
R22385 n_26_16_13 n_26_16_14 2.1489432284683807
R22386 n_26_16_14 n_27_16_14 139.25925740037331
R22387 n_26_16_14 n_26_17_14 321.641663321074
R22388 n_26_16_14 n_26_16_15 11.143805599057547
R22389 n_26_16_15 n_27_16_15 6579.999912167575
R22390 n_26_16_15 n_26_17_15 15197.568591920595
R22391 n_26_17_0 n_27_17_0 93.99999874525187
R22392 n_26_17_0 n_26_18_0 217.10812274172505
R22393 n_26_17_0 n_26_17_1 7.598049272084621
R22394 n_26_17_1 n_27_17_1 131.59999824335262
R22395 n_26_17_1 n_26_18_1 303.95137183841507
R22396 n_26_17_1 n_26_17_2 17.26829380019232
R22397 n_26_17_2 n_27_17_2 234.99999686312967
R22398 n_26_17_2 n_26_18_2 542.7703068543127
R22399 n_26_17_2 n_26_17_3 16.16312299698001
R22400 n_26_17_3 n_27_17_3 3289.999956083813
R22401 n_26_17_3 n_26_18_3 7598.78429596037
R22402 n_26_17_3 n_26_17_4 0.21489432284683796
R22403 n_26_17_4 n_27_17_4 99.69696836617614
R22404 n_26_17_4 n_26_18_4 230.26619078667792
R22405 n_26_17_4 n_26_17_5 0.21489432284683796
R22406 n_26_17_5 n_27_17_5 3289.999956083813
R22407 n_26_17_5 n_26_18_5 7598.78429596037
R22408 n_26_17_5 n_26_17_6 0.41443905120461605
R22409 n_26_17_6 n_27_17_6 731.1111013519583
R22410 n_26_17_6 n_26_18_6 1688.6187324356379
R22411 n_26_17_6 n_26_17_7 0.5832845905842738
R22412 n_26_17_7 n_27_17_7 1253.3333166033608
R22413 n_26_17_7 n_26_18_7 2894.774969889674
R22414 n_26_17_7 n_26_17_8 0.4297886456936746
R22415 n_26_17_8 n_27_17_8 1253.3333166033608
R22416 n_26_17_8 n_26_18_8 2894.774969889674
R22417 n_26_17_8 n_26_17_9 0.4297886456936746
R22418 n_26_17_9 n_27_17_9 1253.3333166033608
R22419 n_26_17_9 n_26_18_9 2894.774969889674
R22420 n_26_17_9 n_26_17_10 0.4297886456936746
R22421 n_26_17_10 n_27_17_10 1253.3333166033608
R22422 n_26_17_10 n_26_18_10 2894.774969889674
R22423 n_26_17_10 n_26_17_11 0.4297886456936718
R22424 n_26_17_11 n_27_17_11 1253.3333166033772
R22425 n_26_17_11 n_26_18_11 2894.7749698897114
R22426 n_26_17_11 n_26_17_12 0.4297886456936705
R22427 n_26_17_12 n_27_17_12 1253.333316603369
R22428 n_26_17_12 n_26_18_12 2894.7749698896923
R22429 n_26_17_12 n_26_17_13 0.4297886456936746
R22430 n_26_17_13 n_27_17_13 1253.333316603353
R22431 n_26_17_13 n_26_18_13 2894.7749698896555
R22432 n_26_17_13 n_26_17_14 2.1489432284683785
R22433 n_26_17_14 n_27_17_14 139.25925740037314
R22434 n_26_17_14 n_26_18_14 321.64166332107425
R22435 n_26_17_14 n_26_17_15 11.143805599057533
R22436 n_26_17_15 n_27_17_15 6579.999912167567
R22437 n_26_17_15 n_26_18_15 15197.568591920604
R22438 n_26_18_0 n_27_18_0 93.99999874525187
R22439 n_26_18_0 n_26_19_0 217.1081227417249
R22440 n_26_18_0 n_26_18_1 7.598049272084621
R22441 n_26_18_1 n_27_18_1 131.59999824335262
R22442 n_26_18_1 n_26_19_1 303.9513718384149
R22443 n_26_18_1 n_26_18_2 17.26829380019232
R22444 n_26_18_2 n_27_18_2 234.99999686312967
R22445 n_26_18_2 n_26_19_2 542.7703068543124
R22446 n_26_18_2 n_26_18_3 16.16312299698001
R22447 n_26_18_3 n_27_18_3 3289.999956083813
R22448 n_26_18_3 n_26_19_3 7598.784295960366
R22449 n_26_18_3 n_26_18_4 0.21489432284683796
R22450 n_26_18_4 n_27_18_4 99.69696836617614
R22451 n_26_18_4 n_26_19_4 230.26619078667778
R22452 n_26_18_4 n_26_18_5 0.21489432284683796
R22453 n_26_18_5 n_27_18_5 3289.999956083813
R22454 n_26_18_5 n_26_19_5 7598.784295960366
R22455 n_26_18_5 n_26_18_6 0.41443905120461605
R22456 n_26_18_6 n_27_18_6 731.1111013519583
R22457 n_26_18_6 n_26_19_6 1688.618732435637
R22458 n_26_18_6 n_26_18_7 0.5832845905842738
R22459 n_26_18_7 n_27_18_7 1253.3333166033608
R22460 n_26_18_7 n_26_19_7 2894.7749698896723
R22461 n_26_18_7 n_26_18_8 0.4297886456936746
R22462 n_26_18_8 n_27_18_8 1253.3333166033608
R22463 n_26_18_8 n_26_19_8 2894.7749698896723
R22464 n_26_18_8 n_26_18_9 0.4297886456936746
R22465 n_26_18_9 n_27_18_9 1253.3333166033608
R22466 n_26_18_9 n_26_19_9 2894.7749698896723
R22467 n_26_18_9 n_26_18_10 0.4297886456936746
R22468 n_26_18_10 n_27_18_10 1253.3333166033608
R22469 n_26_18_10 n_26_19_10 2894.7749698896723
R22470 n_26_18_10 n_26_18_11 0.4297886456936718
R22471 n_26_18_11 n_27_18_11 1253.3333166033772
R22472 n_26_18_11 n_26_19_11 2894.7749698897096
R22473 n_26_18_11 n_26_18_12 0.4297886456936705
R22474 n_26_18_12 n_27_18_12 1253.333316603369
R22475 n_26_18_12 n_26_19_12 2894.7749698896905
R22476 n_26_18_12 n_26_18_13 0.4297886456936746
R22477 n_26_18_13 n_27_18_13 1253.333316603353
R22478 n_26_18_13 n_26_19_13 2894.774969889654
R22479 n_26_18_13 n_26_18_14 2.1489432284683785
R22480 n_26_18_14 n_27_18_14 139.25925740037314
R22481 n_26_18_14 n_26_19_14 321.641663321074
R22482 n_26_18_14 n_26_18_15 11.143805599057533
R22483 n_26_18_15 n_27_18_15 6579.999912167567
R22484 n_26_18_15 n_26_19_15 15197.568591920595
R22485 n_26_19_0 n_27_19_0 93.99999874525201
R22486 n_26_19_0 n_26_20_0 110.44365397508231
R22487 n_26_19_0 n_26_19_1 7.59804927208463
R22488 n_26_19_1 n_27_19_1 131.5999982433528
R22489 n_26_19_1 n_26_20_1 154.62111556511525
R22490 n_26_19_1 n_26_19_2 17.26829380019234
R22491 n_26_19_2 n_27_19_2 234.99999686312998
R22492 n_26_19_2 n_26_20_2 276.1091349377058
R22493 n_26_19_2 n_26_19_3 16.16312299698003
R22494 n_26_19_3 n_27_19_3 3289.9999560838164
R22495 n_26_19_3 n_26_20_3 3865.5278891278776
R22496 n_26_19_3 n_26_19_4 0.21489432284683824
R22497 n_26_19_4 n_27_19_4 99.69696836617624
R22498 n_26_19_4 n_26_20_4 117.13720876145085
R22499 n_26_19_4 n_26_19_5 0.21489432284683824
R22500 n_26_19_5 n_27_19_5 3289.9999560838164
R22501 n_26_19_5 n_26_19_6 0.41443905120461655
R22502 n_26_19_6 n_27_19_6 731.1111013519592
R22503 n_26_19_6 n_26_19_7 0.5832845905842745
R22504 n_26_19_7 n_27_19_7 1253.3333166033626
R22505 n_26_19_7 n_26_19_8 0.4297886456936751
R22506 n_26_19_8 n_27_19_8 1253.3333166033626
R22507 n_26_19_8 n_26_19_9 0.4297886456936751
R22508 n_26_19_9 n_27_19_9 1253.3333166033626
R22509 n_26_19_9 n_26_19_10 0.4297886456936751
R22510 n_26_19_10 n_27_19_10 1253.3333166033626
R22511 n_26_19_10 n_26_19_11 0.42978864569367237
R22512 n_26_19_11 n_27_19_11 1253.3333166033785
R22513 n_26_19_11 n_26_19_12 0.4297886456936709
R22514 n_26_19_12 n_27_19_12 1253.3333166033703
R22515 n_26_19_12 n_26_19_13 0.42978864569367503
R22516 n_26_19_13 n_27_19_13 1253.333316603355
R22517 n_26_19_13 n_26_19_14 2.1489432284683807
R22518 n_26_19_14 n_27_19_14 139.25925740037331
R22519 n_26_19_14 n_26_19_15 11.143805599057547
R22520 n_26_19_15 n_27_19_15 6579.999912167575
R22521 n_26_19_15 n_26_20_15 7731.055778255685
R22522 n_26_20_0 n_27_20_0 5400.149010884629
R22523 n_26_20_0 n_26_21_0 3.7791852084398254
R22524 n_26_20_0 n_26_20_1 436.49573201056
R22525 n_26_20_1 n_27_20_1 7560.208615238479
R22526 n_26_20_1 n_26_21_1 5.290859291815756
R22527 n_26_20_1 n_26_20_2 992.0357545694546
R22528 n_26_20_2 n_27_20_2 13500.372527211573
R22529 n_26_20_2 n_26_21_2 9.447963021099564
R22530 n_26_20_2 n_26_20_3 928.5454662770095
R22531 n_26_20_3 n_27_20_3 189005.21538096183
R22532 n_26_20_3 n_26_21_3 132.27148229539378
R22533 n_26_20_3 n_26_20_4 12.345333834642112
R22534 n_26_20_4 n_27_20_4 5727.430769120056
R22535 n_26_20_4 n_26_21_4 4.008226736224055
R22536 n_26_20_15 n_27_20_15 378010.4307619203
R22537 n_26_20_15 n_26_21_15 264.5429645907852
R22538 n_26_21_0 n_27_21_0 5400.149010884629
R22539 n_26_21_0 n_26_22_0 3.7791852084396913
R22540 n_26_21_0 n_26_21_1 436.49573201056
R22541 n_26_21_1 n_27_21_1 7560.208615238479
R22542 n_26_21_1 n_26_22_1 5.290859291815568
R22543 n_26_21_1 n_26_21_2 992.0357545694546
R22544 n_26_21_2 n_27_21_2 13500.372527211573
R22545 n_26_21_2 n_26_22_2 9.447963021099229
R22546 n_26_21_2 n_26_21_3 928.5454662770095
R22547 n_26_21_3 n_27_21_3 189005.21538096183
R22548 n_26_21_3 n_26_22_3 132.2714822953891
R22549 n_26_21_3 n_26_21_4 12.345333834642112
R22550 n_26_21_4 n_27_21_4 5727.430769120056
R22551 n_26_21_4 n_26_22_4 4.008226736223913
R22552 n_26_21_15 n_27_21_15 378010.4307619203
R22553 n_26_21_15 n_26_22_15 264.5429645907758
R22554 n_26_22_0 n_27_22_0 5400.149010885012
R22555 n_26_22_0 n_26_23_0 3.7791852084396913
R22556 n_26_22_0 n_26_22_1 436.49573201059104
R22557 n_26_22_1 n_27_22_1 7560.208615239017
R22558 n_26_22_1 n_26_23_1 5.290859291815568
R22559 n_26_22_1 n_26_22_2 992.0357545695251
R22560 n_26_22_2 n_27_22_2 13500.37252721253
R22561 n_26_22_2 n_26_23_2 9.447963021099229
R22562 n_26_22_2 n_26_22_3 928.5454662770755
R22563 n_26_22_3 n_27_22_3 189005.21538097528
R22564 n_26_22_3 n_26_23_3 132.2714822953891
R22565 n_26_22_3 n_26_22_4 12.34533383464299
R22566 n_26_22_4 n_27_22_4 5727.430769120462
R22567 n_26_22_4 n_26_23_4 4.008226736223913
R22568 n_26_22_15 n_27_22_15 378010.4307619472
R22569 n_26_22_15 n_26_23_15 264.5429645907758
R22570 n_26_23_0 n_27_23_0 5400.149010884629
R22571 n_26_23_0 n_26_24_0 43.561715139231154
R22572 n_26_23_0 n_26_23_1 436.49573201056
R22573 n_26_23_1 n_27_23_1 7560.208615238479
R22574 n_26_23_1 n_26_24_1 60.986401194923616
R22575 n_26_23_1 n_26_23_2 992.0357545694546
R22576 n_26_23_2 n_27_23_2 13500.372527211573
R22577 n_26_23_2 n_26_24_2 108.90428784807789
R22578 n_26_23_2 n_26_23_3 928.5454662770095
R22579 n_26_23_3 n_27_23_3 189005.21538096183
R22580 n_26_23_3 n_26_24_3 1524.6600298730891
R22581 n_26_23_3 n_26_23_4 12.345333834642112
R22582 n_26_23_4 n_27_23_4 5727.430769120056
R22583 n_26_23_4 n_26_24_4 46.20181908706331
R22584 n_26_23_15 n_27_23_15 378010.4307619203
R22585 n_26_23_15 n_26_24_15 3049.320059746151
R22586 n_26_24_0 n_27_24_0 244.86589623746698
R22587 n_26_24_0 n_26_25_0 83.34424507002235
R22588 n_26_24_0 n_26_24_1 19.792586909576016
R22589 n_26_24_1 n_27_24_1 342.8122547324537
R22590 n_26_24_1 n_26_25_1 116.6819430980313
R22591 n_26_24_1 n_26_24_2 44.983152067218214
R22592 n_26_24_2 n_27_24_2 612.1647405936675
R22593 n_26_24_2 n_26_25_2 208.3606126750559
R22594 n_26_24_2 n_26_24_3 42.10423033491625
R22595 n_26_24_3 n_27_24_3 8570.306368311336
R22596 n_26_24_3 n_26_25_3 2917.0485774507797
R22597 n_26_24_3 n_26_24_4 0.5597903368364939
R22598 n_26_24_4 n_27_24_4 259.70625358519203
R22599 n_26_24_4 n_26_25_4 88.39541143790242
R22600 n_26_24_4 n_26_24_5 0.46268384983424504
R22601 n_26_24_5 n_27_24_5 1632.4393082497784
R22602 n_26_24_5 n_26_25_5 555.6283004668153
R22603 n_26_24_5 n_26_24_6 0.15994009623899827
R22604 n_26_24_6 n_27_24_6 272.07321804162973
R22605 n_26_24_6 n_26_25_6 92.60471674446921
R22606 n_26_24_6 n_26_24_7 0.2170615591814974
R22607 n_26_24_7 n_27_24_7 466.4112309285095
R22608 n_26_24_7 n_26_25_7 158.75094299051915
R22609 n_26_24_7 n_26_24_8 0.15994009623899777
R22610 n_26_24_8 n_27_24_8 466.4112309285095
R22611 n_26_24_8 n_26_25_8 158.75094299051915
R22612 n_26_24_8 n_26_24_9 0.15994009623899777
R22613 n_26_24_9 n_27_24_9 466.4112309285095
R22614 n_26_24_9 n_26_25_9 158.75094299051915
R22615 n_26_24_9 n_26_24_10 0.15994009623899777
R22616 n_26_24_10 n_27_24_10 466.4112309285095
R22617 n_26_24_10 n_26_25_10 158.75094299051915
R22618 n_26_24_10 n_26_24_11 0.15994009623899674
R22619 n_26_24_11 n_27_24_11 466.41123092851547
R22620 n_26_24_11 n_26_25_11 158.7509429905212
R22621 n_26_24_11 n_26_24_12 0.15994009623899624
R22622 n_26_24_12 n_27_24_12 466.4112309285125
R22623 n_26_24_12 n_26_25_12 158.75094299052012
R22624 n_26_24_12 n_26_24_13 0.1599400962389978
R22625 n_26_24_13 n_27_24_13 466.4112309285066
R22626 n_26_24_13 n_26_25_13 158.75094299051813
R22627 n_26_24_13 n_26_24_14 0.7997004811949909
R22628 n_26_24_14 n_27_24_14 51.82347010316761
R22629 n_26_24_14 n_26_25_14 17.638993665613203
R22630 n_26_24_14 n_26_24_15 24.710744868925442
R22631 n_26_24_15 n_27_24_15 17140.61273662252
R22632 n_26_24_15 n_26_25_15 5834.097154901508
R22633 n_26_25_0 n_27_25_0 244.86589623746778
R22634 n_26_25_0 n_26_26_0 83.34424507002235
R22635 n_26_25_0 n_26_25_1 19.79258690957608
R22636 n_26_25_1 n_27_25_1 342.81225473245485
R22637 n_26_25_1 n_26_26_1 116.6819430980313
R22638 n_26_25_1 n_26_25_2 44.98315206721837
R22639 n_26_25_2 n_27_25_2 612.1647405936694
R22640 n_26_25_2 n_26_26_2 208.3606126750559
R22641 n_26_25_2 n_26_25_3 42.104230334916394
R22642 n_26_25_3 n_27_25_3 8570.306368311365
R22643 n_26_25_3 n_26_26_3 2917.0485774507797
R22644 n_26_25_3 n_26_25_4 0.5597903368364958
R22645 n_26_25_4 n_27_25_4 259.7062535851928
R22646 n_26_25_4 n_26_26_4 88.39541143790242
R22647 n_26_25_4 n_26_25_5 0.46268384983424654
R22648 n_26_25_5 n_27_25_5 1632.4393082497834
R22649 n_26_25_5 n_26_26_5 555.6283004668153
R22650 n_26_25_5 n_26_25_6 0.1599400962389988
R22651 n_26_25_6 n_27_25_6 272.07321804163064
R22652 n_26_25_6 n_26_26_6 92.60471674446921
R22653 n_26_25_6 n_26_25_7 0.2170615591814981
R22654 n_26_25_7 n_27_25_7 466.4112309285111
R22655 n_26_25_7 n_26_26_7 158.75094299051915
R22656 n_26_25_7 n_26_25_8 0.15994009623899827
R22657 n_26_25_8 n_27_25_8 466.4112309285111
R22658 n_26_25_8 n_26_26_8 158.75094299051915
R22659 n_26_25_8 n_26_25_9 0.15994009623899827
R22660 n_26_25_9 n_27_25_9 466.4112309285111
R22661 n_26_25_9 n_26_26_9 158.75094299051915
R22662 n_26_25_9 n_26_25_10 0.15994009623899827
R22663 n_26_25_10 n_27_25_10 466.4112309285111
R22664 n_26_25_10 n_26_26_10 158.75094299051915
R22665 n_26_25_10 n_26_25_11 0.15994009623899724
R22666 n_26_25_11 n_27_25_11 466.411230928517
R22667 n_26_25_11 n_26_26_11 158.7509429905212
R22668 n_26_25_11 n_26_25_12 0.15994009623899674
R22669 n_26_25_12 n_27_25_12 466.4112309285139
R22670 n_26_25_12 n_26_26_12 158.75094299052012
R22671 n_26_25_12 n_26_25_13 0.15994009623899827
R22672 n_26_25_13 n_27_25_13 466.41123092850813
R22673 n_26_25_13 n_26_26_13 158.75094299051813
R22674 n_26_25_13 n_26_25_14 0.7997004811949935
R22675 n_26_25_14 n_27_25_14 51.82347010316778
R22676 n_26_25_14 n_26_26_14 17.638993665613203
R22677 n_26_25_14 n_26_25_15 24.710744868925524
R22678 n_26_25_15 n_27_25_15 17140.612736622574
R22679 n_26_25_15 n_26_26_15 5834.097154901508
R22680 n_26_26_0 n_27_26_0 244.86589623746698
R22681 n_26_26_0 n_26_27_0 83.34424507002248
R22682 n_26_26_0 n_26_26_1 19.792586909576016
R22683 n_26_26_1 n_27_26_1 342.8122547324537
R22684 n_26_26_1 n_26_27_1 116.68194309803148
R22685 n_26_26_1 n_26_26_2 44.983152067218214
R22686 n_26_26_2 n_27_26_2 612.1647405936675
R22687 n_26_26_2 n_26_27_2 208.36061267505622
R22688 n_26_26_2 n_26_26_3 42.10423033491625
R22689 n_26_26_3 n_27_26_3 8570.306368311336
R22690 n_26_26_3 n_26_27_3 2917.0485774507843
R22691 n_26_26_3 n_26_26_4 0.5597903368364939
R22692 n_26_26_4 n_27_26_4 259.70625358519203
R22693 n_26_26_4 n_26_27_4 88.39541143790257
R22694 n_26_26_4 n_26_26_5 0.46268384983424504
R22695 n_26_26_5 n_27_26_5 1632.4393082497784
R22696 n_26_26_5 n_26_27_5 555.6283004668161
R22697 n_26_26_5 n_26_26_6 0.15994009623899827
R22698 n_26_26_6 n_27_26_6 272.07321804162973
R22699 n_26_26_6 n_26_27_6 92.60471674446936
R22700 n_26_26_6 n_26_26_7 0.2170615591814974
R22701 n_26_26_7 n_27_26_7 466.4112309285095
R22702 n_26_26_7 n_26_27_7 158.7509429905194
R22703 n_26_26_7 n_26_26_8 0.15994009623899777
R22704 n_26_26_8 n_27_26_8 466.4112309285095
R22705 n_26_26_8 n_26_27_8 158.7509429905194
R22706 n_26_26_8 n_26_26_9 0.15994009623899777
R22707 n_26_26_9 n_27_26_9 466.4112309285095
R22708 n_26_26_9 n_26_27_9 158.7509429905194
R22709 n_26_26_9 n_26_26_10 0.15994009623899777
R22710 n_26_26_10 n_27_26_10 466.4112309285095
R22711 n_26_26_10 n_26_27_10 158.7509429905194
R22712 n_26_26_10 n_26_26_11 0.15994009623899674
R22713 n_26_26_11 n_27_26_11 466.41123092851547
R22714 n_26_26_11 n_26_27_11 158.75094299052142
R22715 n_26_26_11 n_26_26_12 0.15994009623899624
R22716 n_26_26_12 n_27_26_12 466.4112309285125
R22717 n_26_26_12 n_26_27_12 158.75094299052037
R22718 n_26_26_12 n_26_26_13 0.1599400962389978
R22719 n_26_26_13 n_27_26_13 466.4112309285066
R22720 n_26_26_13 n_26_27_13 158.75094299051838
R22721 n_26_26_13 n_26_26_14 0.7997004811949909
R22722 n_26_26_14 n_27_26_14 51.82347010316761
R22723 n_26_26_14 n_26_27_14 17.63899366561323
R22724 n_26_26_14 n_26_26_15 24.710744868925442
R22725 n_26_26_15 n_27_26_15 17140.61273662252
R22726 n_26_26_15 n_26_27_15 5834.097154901517
R22727 n_26_27_0 n_27_27_0 244.86589623746698
R22728 n_26_27_0 n_26_27_1 19.792586909576016
R22729 n_26_27_1 n_27_27_1 342.8122547324537
R22730 n_26_27_1 n_26_27_2 44.983152067218214
R22731 n_26_27_2 n_27_27_2 612.1647405936675
R22732 n_26_27_2 n_26_27_3 42.10423033491625
R22733 n_26_27_3 n_27_27_3 8570.306368311336
R22734 n_26_27_3 n_26_27_4 0.5597903368364939
R22735 n_26_27_4 n_27_27_4 259.70625358519203
R22736 n_26_27_4 n_26_27_5 0.46268384983424504
R22737 n_26_27_5 n_27_27_5 1632.4393082497784
R22738 n_26_27_5 n_26_27_6 0.15994009623899827
R22739 n_26_27_6 n_27_27_6 272.07321804162973
R22740 n_26_27_6 n_26_27_7 0.2170615591814974
R22741 n_26_27_7 n_27_27_7 466.4112309285095
R22742 n_26_27_7 n_26_27_8 0.15994009623899777
R22743 n_26_27_8 n_27_27_8 466.4112309285095
R22744 n_26_27_8 n_26_27_9 0.15994009623899777
R22745 n_26_27_9 n_27_27_9 466.4112309285095
R22746 n_26_27_9 n_26_27_10 0.15994009623899777
R22747 n_26_27_10 n_27_27_10 466.4112309285095
R22748 n_26_27_10 n_26_27_11 0.15994009623899674
R22749 n_26_27_11 n_27_27_11 466.41123092851547
R22750 n_26_27_11 n_26_27_12 0.15994009623899624
R22751 n_26_27_12 n_27_27_12 466.4112309285125
R22752 n_26_27_12 n_26_27_13 0.1599400962389978
R22753 n_26_27_13 n_27_27_13 466.4112309285066
R22754 n_26_27_13 n_26_27_14 0.7997004811949909
R22755 n_26_27_14 n_27_27_14 51.82347010316761
R22756 n_26_27_14 n_26_27_15 24.710744868925442
R22757 n_26_27_15 n_27_27_15 17140.61273662252
R22758 n_27_0_0 n_28_0_0 125.67181420979068
R22759 n_27_0_0 n_27_1_0 83.34425224761593
R22760 n_27_0_0 n_27_0_1 19.792585205041586
R22761 n_27_0_1 n_28_0_1 175.9405398937069
R22762 n_27_0_1 n_27_1_1 116.6819531466623
R22763 n_27_0_1 n_27_0_2 44.98314819327633
R22764 n_27_0_2 n_28_0_2 314.1795355244767
R22765 n_27_0_2 n_27_1_2 208.3606306190398
R22766 n_27_0_2 n_27_0_3 42.104226708906644
R22767 n_27_0_3 n_28_0_3 4398.513497342668
R22768 n_27_0_3 n_27_1_3 2917.048828666555
R22769 n_27_0_3 n_27_0_4 0.5597902886274392
R22770 n_27_0_4 n_28_0_4 133.2882877982627
R22771 n_27_0_4 n_27_1_4 88.39541905050166
R22772 n_27_0_4 n_27_0_5 0.4626838099879854
R22773 n_27_0_5 n_28_0_5 837.8120947319369
R22774 n_27_0_5 n_27_1_5 555.6283483174391
R22775 n_27_0_5 n_27_0_6 0.15994008246498265
R22776 n_27_0_6 n_28_0_6 139.6353491219895
R22777 n_27_0_6 n_27_1_6 92.60472471957317
R22778 n_27_0_6 n_27_0_7 0.21706154048819049
R22779 n_27_0_7 n_28_0_7 239.37488420912558
R22780 n_27_0_7 n_27_1_7 158.75095666212593
R22781 n_27_0_7 n_27_0_8 0.15994008246498215
R22782 n_27_0_8 n_28_0_8 239.37488420912558
R22783 n_27_0_8 n_27_1_8 158.75095666212593
R22784 n_27_0_8 n_27_0_9 0.15994008246498215
R22785 n_27_0_9 n_28_0_9 239.37488420912558
R22786 n_27_0_9 n_27_1_9 158.75095666212593
R22787 n_27_0_9 n_27_0_10 0.15994008246498215
R22788 n_27_0_10 n_28_0_10 239.37488420912558
R22789 n_27_0_10 n_27_1_10 158.75095666212593
R22790 n_27_0_10 n_27_0_11 0.15994008246498112
R22791 n_27_0_11 n_28_0_11 239.37488420912865
R22792 n_27_0_11 n_27_1_11 158.75095666212795
R22793 n_27_0_11 n_27_0_12 0.1599400824649806
R22794 n_27_0_12 n_28_0_12 239.3748842091272
R22795 n_27_0_12 n_27_1_12 158.7509566621269
R22796 n_27_0_12 n_27_0_13 0.15994008246498215
R22797 n_27_0_13 n_28_0_13 239.3748842091241
R22798 n_27_0_13 n_27_1_13 158.75095666212493
R22799 n_27_0_13 n_27_0_14 0.7997004123249127
R22800 n_27_0_14 n_28_0_14 26.597209356569458
R22801 n_27_0_14 n_27_1_14 17.638995184680617
R22802 n_27_0_14 n_27_0_15 24.710742740840033
R22803 n_27_0_15 n_28_0_15 8797.02699468526
R22804 n_27_0_15 n_27_1_15 5834.097657333058
R22805 n_27_1_0 n_28_1_0 125.67181420979068
R22806 n_27_1_0 n_27_2_0 83.34425224761593
R22807 n_27_1_0 n_27_1_1 19.792585205041586
R22808 n_27_1_1 n_28_1_1 175.9405398937069
R22809 n_27_1_1 n_27_2_1 116.6819531466623
R22810 n_27_1_1 n_27_1_2 44.98314819327633
R22811 n_27_1_2 n_28_1_2 314.1795355244767
R22812 n_27_1_2 n_27_2_2 208.3606306190398
R22813 n_27_1_2 n_27_1_3 42.104226708906644
R22814 n_27_1_3 n_28_1_3 4398.513497342668
R22815 n_27_1_3 n_27_2_3 2917.048828666555
R22816 n_27_1_3 n_27_1_4 0.5597902886274392
R22817 n_27_1_4 n_28_1_4 133.2882877982627
R22818 n_27_1_4 n_27_2_4 88.39541905050166
R22819 n_27_1_4 n_27_1_5 0.4626838099879854
R22820 n_27_1_5 n_28_1_5 837.8120947319369
R22821 n_27_1_5 n_27_2_5 555.6283483174391
R22822 n_27_1_5 n_27_1_6 0.15994008246498265
R22823 n_27_1_6 n_28_1_6 139.6353491219895
R22824 n_27_1_6 n_27_2_6 92.60472471957317
R22825 n_27_1_6 n_27_1_7 0.21706154048819049
R22826 n_27_1_7 n_28_1_7 239.37488420912558
R22827 n_27_1_7 n_27_2_7 158.75095666212593
R22828 n_27_1_7 n_27_1_8 0.15994008246498215
R22829 n_27_1_8 n_28_1_8 239.37488420912558
R22830 n_27_1_8 n_27_2_8 158.75095666212593
R22831 n_27_1_8 n_27_1_9 0.15994008246498215
R22832 n_27_1_9 n_28_1_9 239.37488420912558
R22833 n_27_1_9 n_27_2_9 158.75095666212593
R22834 n_27_1_9 n_27_1_10 0.15994008246498215
R22835 n_27_1_10 n_28_1_10 239.37488420912558
R22836 n_27_1_10 n_27_2_10 158.75095666212593
R22837 n_27_1_10 n_27_1_11 0.15994008246498112
R22838 n_27_1_11 n_28_1_11 239.37488420912865
R22839 n_27_1_11 n_27_2_11 158.75095666212795
R22840 n_27_1_11 n_27_1_12 0.1599400824649806
R22841 n_27_1_12 n_28_1_12 239.3748842091272
R22842 n_27_1_12 n_27_2_12 158.7509566621269
R22843 n_27_1_12 n_27_1_13 0.15994008246498215
R22844 n_27_1_13 n_28_1_13 239.3748842091241
R22845 n_27_1_13 n_27_2_13 158.75095666212493
R22846 n_27_1_13 n_27_1_14 0.7997004123249127
R22847 n_27_1_14 n_28_1_14 26.597209356569458
R22848 n_27_1_14 n_27_2_14 17.638995184680617
R22849 n_27_1_14 n_27_1_15 24.710742740840033
R22850 n_27_1_15 n_28_1_15 8797.02699468526
R22851 n_27_1_15 n_27_2_15 5834.097657333058
R22852 n_27_2_0 n_28_2_0 125.67181420979068
R22853 n_27_2_0 n_27_3_0 83.34425224761593
R22854 n_27_2_0 n_27_2_1 19.792585205041586
R22855 n_27_2_1 n_28_2_1 175.9405398937069
R22856 n_27_2_1 n_27_3_1 116.6819531466623
R22857 n_27_2_1 n_27_2_2 44.98314819327633
R22858 n_27_2_2 n_28_2_2 314.1795355244767
R22859 n_27_2_2 n_27_3_2 208.3606306190398
R22860 n_27_2_2 n_27_2_3 42.104226708906644
R22861 n_27_2_3 n_28_2_3 4398.513497342668
R22862 n_27_2_3 n_27_3_3 2917.048828666555
R22863 n_27_2_3 n_27_2_4 0.5597902886274392
R22864 n_27_2_4 n_28_2_4 133.2882877982627
R22865 n_27_2_4 n_27_3_4 88.39541905050166
R22866 n_27_2_4 n_27_2_5 0.4626838099879854
R22867 n_27_2_5 n_28_2_5 837.8120947319369
R22868 n_27_2_5 n_27_3_5 555.6283483174391
R22869 n_27_2_5 n_27_2_6 0.15994008246498265
R22870 n_27_2_6 n_28_2_6 139.6353491219895
R22871 n_27_2_6 n_27_3_6 92.60472471957317
R22872 n_27_2_6 n_27_2_7 0.21706154048819049
R22873 n_27_2_7 n_28_2_7 239.37488420912558
R22874 n_27_2_7 n_27_3_7 158.75095666212593
R22875 n_27_2_7 n_27_2_8 0.15994008246498215
R22876 n_27_2_8 n_28_2_8 239.37488420912558
R22877 n_27_2_8 n_27_3_8 158.75095666212593
R22878 n_27_2_8 n_27_2_9 0.15994008246498215
R22879 n_27_2_9 n_28_2_9 239.37488420912558
R22880 n_27_2_9 n_27_3_9 158.75095666212593
R22881 n_27_2_9 n_27_2_10 0.15994008246498215
R22882 n_27_2_10 n_28_2_10 239.37488420912558
R22883 n_27_2_10 n_27_3_10 158.75095666212593
R22884 n_27_2_10 n_27_2_11 0.15994008246498112
R22885 n_27_2_11 n_28_2_11 239.37488420912865
R22886 n_27_2_11 n_27_3_11 158.75095666212795
R22887 n_27_2_11 n_27_2_12 0.1599400824649806
R22888 n_27_2_12 n_28_2_12 239.3748842091272
R22889 n_27_2_12 n_27_3_12 158.7509566621269
R22890 n_27_2_12 n_27_2_13 0.15994008246498215
R22891 n_27_2_13 n_28_2_13 239.3748842091241
R22892 n_27_2_13 n_27_3_13 158.75095666212493
R22893 n_27_2_13 n_27_2_14 0.7997004123249127
R22894 n_27_2_14 n_28_2_14 26.597209356569458
R22895 n_27_2_14 n_27_3_14 17.638995184680617
R22896 n_27_2_14 n_27_2_15 24.710742740840033
R22897 n_27_2_15 n_28_2_15 8797.02699468526
R22898 n_27_2_15 n_27_3_15 5834.097657333058
R22899 n_27_3_0 n_28_3_0 125.67181420979068
R22900 n_27_3_0 n_27_4_0 43.561715139230984
R22901 n_27_3_0 n_27_3_1 19.792585205041586
R22902 n_27_3_1 n_28_3_1 175.9405398937069
R22903 n_27_3_1 n_27_4_1 60.986401194923374
R22904 n_27_3_1 n_27_3_2 44.98314819327633
R22905 n_27_3_2 n_28_3_2 314.1795355244767
R22906 n_27_3_2 n_27_4_2 108.90428784807744
R22907 n_27_3_2 n_27_3_3 42.104226708906644
R22908 n_27_3_3 n_28_3_3 4398.513497342668
R22909 n_27_3_3 n_27_4_3 1524.6600298730832
R22910 n_27_3_3 n_27_3_4 0.5597902886274392
R22911 n_27_3_4 n_28_3_4 133.2882877982627
R22912 n_27_3_4 n_27_4_4 46.20181908706312
R22913 n_27_3_4 n_27_3_5 0.4626838099879854
R22914 n_27_3_5 n_28_3_5 837.8120947319369
R22915 n_27_3_5 n_27_3_6 0.15994008246498265
R22916 n_27_3_6 n_28_3_6 139.6353491219895
R22917 n_27_3_6 n_27_3_7 0.21706154048819049
R22918 n_27_3_7 n_28_3_7 239.37488420912558
R22919 n_27_3_7 n_27_3_8 0.15994008246498215
R22920 n_27_3_8 n_28_3_8 239.37488420912558
R22921 n_27_3_8 n_27_3_9 0.15994008246498215
R22922 n_27_3_9 n_28_3_9 239.37488420912558
R22923 n_27_3_9 n_27_3_10 0.15994008246498215
R22924 n_27_3_10 n_28_3_10 239.37488420912558
R22925 n_27_3_10 n_27_3_11 0.15994008246498112
R22926 n_27_3_11 n_28_3_11 239.37488420912865
R22927 n_27_3_11 n_27_3_12 0.1599400824649806
R22928 n_27_3_12 n_28_3_12 239.3748842091272
R22929 n_27_3_12 n_27_3_13 0.15994008246498215
R22930 n_27_3_13 n_28_3_13 239.3748842091241
R22931 n_27_3_13 n_27_3_14 0.7997004123249127
R22932 n_27_3_14 n_28_3_14 26.597209356569458
R22933 n_27_3_14 n_27_3_15 24.710742740840033
R22934 n_27_3_15 n_28_3_15 8797.02699468526
R22935 n_27_3_15 n_27_4_15 3049.320059746139
R22936 n_27_4_0 n_28_4_0 2771.508327585062
R22937 n_27_4_0 n_27_5_0 3.779178030846073
R22938 n_27_4_0 n_27_4_1 436.49656102391225
R22939 n_27_4_1 n_28_4_1 3880.111658619087
R22940 n_27_4_1 n_27_5_1 5.290849243184502
R22941 n_27_4_1 n_27_4_2 992.0376386907095
R22942 n_27_4_2 n_28_4_2 6928.7708189626555
R22943 n_27_4_2 n_27_5_2 9.447945077115182
R22944 n_27_4_2 n_27_4_3 928.547229814504
R22945 n_27_4_3 n_28_4_3 97002.7914654771
R22946 n_27_4_3 n_27_5_3 132.27123107961245
R22947 n_27_4_3 n_27_4_4 12.345357281484397
R22948 n_27_4_4 n_28_4_4 2939.4785292568818
R22949 n_27_4_4 n_27_5_4 4.008219123624619
R22950 n_27_4_15 n_28_4_15 194005.58293095249
R22951 n_27_4_15 n_27_5_15 264.5424621592225
R22952 n_27_5_0 n_28_5_0 2771.5083275850134
R22953 n_27_5_0 n_27_6_0 3.7791780308461065
R22954 n_27_5_0 n_27_5_1 436.49656102390446
R22955 n_27_5_1 n_28_5_1 3880.111658619018
R22956 n_27_5_1 n_27_6_1 5.290849243184549
R22957 n_27_5_1 n_27_5_2 992.0376386906918
R22958 n_27_5_2 n_28_5_2 6928.770818962533
R22959 n_27_5_2 n_27_6_2 9.447945077115266
R22960 n_27_5_2 n_27_5_3 928.5472298144875
R22961 n_27_5_3 n_28_5_3 97002.79146547537
R22962 n_27_5_3 n_27_6_3 132.2712310796136
R22963 n_27_5_3 n_27_5_4 12.345357281484178
R22964 n_27_5_4 n_28_5_4 2939.4785292568295
R22965 n_27_5_4 n_27_6_4 4.008219123624655
R22966 n_27_5_15 n_28_5_15 194005.58293094902
R22967 n_27_5_15 n_27_6_15 264.5424621592249
R22968 n_27_6_0 n_28_6_0 2771.5083275850134
R22969 n_27_6_0 n_27_7_0 3.779178030846073
R22970 n_27_6_0 n_27_6_1 436.49656102390446
R22971 n_27_6_1 n_28_6_1 3880.111658619018
R22972 n_27_6_1 n_27_7_1 5.290849243184502
R22973 n_27_6_1 n_27_6_2 992.0376386906918
R22974 n_27_6_2 n_28_6_2 6928.770818962533
R22975 n_27_6_2 n_27_7_2 9.447945077115182
R22976 n_27_6_2 n_27_6_3 928.5472298144875
R22977 n_27_6_3 n_28_6_3 97002.79146547537
R22978 n_27_6_3 n_27_7_3 132.27123107961245
R22979 n_27_6_3 n_27_6_4 12.345357281484178
R22980 n_27_6_4 n_28_6_4 2939.4785292568295
R22981 n_27_6_4 n_27_7_4 4.008219123624619
R22982 n_27_6_15 n_28_6_15 194005.58293094902
R22983 n_27_6_15 n_27_7_15 264.5424621592225
R22984 n_27_7_0 n_28_7_0 2771.508327585062
R22985 n_27_7_0 n_27_8_0 110.44365038628528
R22986 n_27_7_0 n_27_7_1 436.49656102391225
R22987 n_27_7_1 n_28_7_1 3880.111658619087
R22988 n_27_7_1 n_27_8_1 154.62111054079944
R22989 n_27_7_1 n_27_7_2 992.0376386907095
R22990 n_27_7_2 n_28_7_2 6928.7708189626555
R22991 n_27_7_2 n_27_8_2 276.10912596571325
R22992 n_27_7_2 n_27_7_3 928.547229814504
R22993 n_27_7_3 n_28_7_3 97002.7914654771
R22994 n_27_7_3 n_27_8_3 3865.5277635199823
R22995 n_27_7_3 n_27_7_4 12.345357281484397
R22996 n_27_7_4 n_28_7_4 2939.4785292568818
R22997 n_27_7_4 n_27_8_4 117.13720495515096
R22998 n_27_7_15 n_28_7_15 194005.58293095249
R22999 n_27_7_15 n_27_8_15 7731.055527039895
R23000 n_27_8_0 n_28_8_0 48.24335106234782
R23001 n_27_8_0 n_27_9_0 217.10812274172463
R23002 n_27_8_0 n_27_8_1 7.598049272084611
R23003 n_27_8_1 n_28_8_1 67.54069148728694
R23004 n_27_8_1 n_27_9_1 303.9513718384145
R23005 n_27_8_1 n_27_8_2 17.268293800192296
R23006 n_27_8_2 n_28_8_2 120.60837765586953
R23007 n_27_8_2 n_27_9_2 542.7703068543115
R23008 n_27_8_2 n_27_8_3 16.16312299697999
R23009 n_27_8_3 n_28_8_3 1688.517287182172
R23010 n_27_8_3 n_27_9_3 7598.784295960355
R23011 n_27_8_3 n_27_8_4 0.2148943228468377
R23012 n_27_8_4 n_28_8_4 51.16719052067188
R23013 n_27_8_4 n_27_9_4 230.26619078667744
R23014 n_27_8_4 n_27_8_5 0.2148943228468377
R23015 n_27_8_5 n_27_9_5 7598.784295960355
R23016 n_27_8_5 n_27_8_6 0.4144390512046156
R23017 n_27_8_6 n_27_9_6 1688.6187324356342
R23018 n_27_8_6 n_27_8_7 0.5832845905842732
R23019 n_27_8_7 n_27_9_7 2894.774969889668
R23020 n_27_8_7 n_27_8_8 0.4297886456936741
R23021 n_27_8_8 n_27_9_8 2894.774969889668
R23022 n_27_8_8 n_27_8_9 0.4297886456936741
R23023 n_27_8_9 n_27_9_9 2894.774969889668
R23024 n_27_8_9 n_27_8_10 0.4297886456936741
R23025 n_27_8_10 n_27_9_10 2894.774969889668
R23026 n_27_8_10 n_27_8_11 0.42978864569367137
R23027 n_27_8_11 n_27_9_11 2894.774969889705
R23028 n_27_8_11 n_27_8_12 0.4297886456936699
R23029 n_27_8_12 n_27_9_12 2894.7749698896864
R23030 n_27_8_12 n_27_8_13 0.42978864569367403
R23031 n_27_8_13 n_27_9_13 2894.77496988965
R23032 n_27_8_13 n_27_8_14 2.148943228468376
R23033 n_27_8_14 n_27_9_14 321.64166332107345
R23034 n_27_8_14 n_27_8_15 11.14380559905752
R23035 n_27_8_15 n_28_8_15 3377.034574364314
R23036 n_27_8_15 n_27_9_15 15197.568591920575
R23037 n_27_9_0 n_28_9_0 48.243351062347784
R23038 n_27_9_0 n_27_10_0 217.10812274172463
R23039 n_27_9_0 n_27_9_1 7.598049272084607
R23040 n_27_9_1 n_28_9_1 67.5406914872869
R23041 n_27_9_1 n_27_10_1 303.9513718384145
R23042 n_27_9_1 n_27_9_2 17.268293800192286
R23043 n_27_9_2 n_28_9_2 120.60837765586945
R23044 n_27_9_2 n_27_10_2 542.7703068543115
R23045 n_27_9_2 n_27_9_3 16.16312299697998
R23046 n_27_9_3 n_28_9_3 1688.517287182171
R23047 n_27_9_3 n_27_10_3 7598.784295960355
R23048 n_27_9_3 n_27_9_4 0.21489432284683754
R23049 n_27_9_4 n_28_9_4 51.167190520671845
R23050 n_27_9_4 n_27_10_4 230.26619078667744
R23051 n_27_9_4 n_27_9_5 0.21489432284683754
R23052 n_27_9_5 n_27_10_5 7598.784295960355
R23053 n_27_9_5 n_27_9_6 0.41443905120461527
R23054 n_27_9_6 n_27_10_6 1688.6187324356342
R23055 n_27_9_6 n_27_9_7 0.5832845905842726
R23056 n_27_9_7 n_27_10_7 2894.774969889668
R23057 n_27_9_7 n_27_9_8 0.4297886456936737
R23058 n_27_9_8 n_27_10_8 2894.774969889668
R23059 n_27_9_8 n_27_9_9 0.4297886456936737
R23060 n_27_9_9 n_27_10_9 2894.774969889668
R23061 n_27_9_9 n_27_9_10 0.4297886456936737
R23062 n_27_9_10 n_27_10_10 2894.774969889668
R23063 n_27_9_10 n_27_9_11 0.429788645693671
R23064 n_27_9_11 n_27_10_11 2894.774969889705
R23065 n_27_9_11 n_27_9_12 0.4297886456936696
R23066 n_27_9_12 n_27_10_12 2894.7749698896864
R23067 n_27_9_12 n_27_9_13 0.4297886456936737
R23068 n_27_9_13 n_27_10_13 2894.77496988965
R23069 n_27_9_13 n_27_9_14 2.148943228468374
R23070 n_27_9_14 n_27_10_14 321.64166332107345
R23071 n_27_9_14 n_27_9_15 11.143805599057513
R23072 n_27_9_15 n_28_9_15 3377.034574364312
R23073 n_27_9_15 n_27_10_15 15197.568591920575
R23074 n_27_10_0 n_28_10_0 48.24335106234782
R23075 n_27_10_0 n_27_11_0 217.10812274172454
R23076 n_27_10_0 n_27_10_1 7.598049272084611
R23077 n_27_10_1 n_28_10_1 67.54069148728694
R23078 n_27_10_1 n_27_11_1 303.9513718384144
R23079 n_27_10_1 n_27_10_2 17.268293800192296
R23080 n_27_10_2 n_28_10_2 120.60837765586953
R23081 n_27_10_2 n_27_11_2 542.7703068543113
R23082 n_27_10_2 n_27_10_3 16.16312299697999
R23083 n_27_10_3 n_28_10_3 1688.517287182172
R23084 n_27_10_3 n_27_11_3 7598.784295960353
R23085 n_27_10_3 n_27_10_4 0.2148943228468377
R23086 n_27_10_4 n_28_10_4 51.16719052067188
R23087 n_27_10_4 n_27_11_4 230.26619078667736
R23088 n_27_10_4 n_27_10_5 0.2148943228468377
R23089 n_27_10_5 n_27_11_5 7598.784295960353
R23090 n_27_10_5 n_27_10_6 0.4144390512046156
R23091 n_27_10_6 n_27_11_6 1688.6187324356338
R23092 n_27_10_6 n_27_10_7 0.5832845905842732
R23093 n_27_10_7 n_27_11_7 2894.774969889667
R23094 n_27_10_7 n_27_10_8 0.4297886456936741
R23095 n_27_10_8 n_27_11_8 2894.774969889667
R23096 n_27_10_8 n_27_10_9 0.4297886456936741
R23097 n_27_10_9 n_27_11_9 2894.774969889667
R23098 n_27_10_9 n_27_10_10 0.4297886456936741
R23099 n_27_10_10 n_27_11_10 2894.774969889667
R23100 n_27_10_10 n_27_10_11 0.42978864569367137
R23101 n_27_10_11 n_27_11_11 2894.774969889704
R23102 n_27_10_11 n_27_10_12 0.4297886456936699
R23103 n_27_10_12 n_27_11_12 2894.7749698896855
R23104 n_27_10_12 n_27_10_13 0.42978864569367403
R23105 n_27_10_13 n_27_11_13 2894.774969889649
R23106 n_27_10_13 n_27_10_14 2.148943228468376
R23107 n_27_10_14 n_27_11_14 321.6416633210734
R23108 n_27_10_14 n_27_10_15 11.14380559905752
R23109 n_27_10_15 n_28_10_15 3377.034574364314
R23110 n_27_10_15 n_27_11_15 15197.56859192057
R23111 n_27_11_0 n_28_11_0 48.24335106234782
R23112 n_27_11_0 n_27_12_0 110.44365362970504
R23113 n_27_11_0 n_27_11_1 7.598049272084611
R23114 n_27_11_1 n_28_11_1 67.54069148728694
R23115 n_27_11_1 n_27_12_1 154.62111508158705
R23116 n_27_11_1 n_27_11_2 17.268293800192296
R23117 n_27_11_2 n_28_11_2 120.60837765586953
R23118 n_27_11_2 n_27_12_2 276.10913407426256
R23119 n_27_11_2 n_27_11_3 16.16312299697999
R23120 n_27_11_3 n_28_11_3 1688.517287182172
R23121 n_27_11_3 n_27_12_3 3865.527877039673
R23122 n_27_11_3 n_27_11_4 0.2148943228468377
R23123 n_27_11_4 n_28_11_4 51.16719052067188
R23124 n_27_11_4 n_27_12_4 117.13720839514161
R23125 n_27_11_4 n_27_11_5 0.2148943228468377
R23126 n_27_11_5 n_27_11_6 0.4144390512046156
R23127 n_27_11_6 n_27_11_7 0.5832845905842732
R23128 n_27_11_7 n_27_11_8 0.4297886456936741
R23129 n_27_11_8 n_27_11_9 0.4297886456936741
R23130 n_27_11_9 n_27_11_10 0.4297886456936741
R23131 n_27_11_10 n_27_11_11 0.42978864569367137
R23132 n_27_11_11 n_27_11_12 0.4297886456936699
R23133 n_27_11_12 n_27_11_13 0.42978864569367403
R23134 n_27_11_13 n_27_11_14 2.148943228468376
R23135 n_27_11_14 n_27_11_15 11.14380559905752
R23136 n_27_11_15 n_28_11_15 3377.034574364314
R23137 n_27_11_15 n_27_12_15 7731.055754079277
R23138 n_27_12_0 n_28_12_0 2771.5035703868975
R23139 n_27_12_0 n_27_13_0 3.7791845176855245
R23140 n_27_12_0 n_27_12_1 436.4958117926656
R23141 n_27_12_1 n_28_12_1 3880.104998541656
R23142 n_27_12_1 n_27_13_1 5.290858324759735
R23143 n_27_12_1 n_27_12_2 992.0359358924218
R23144 n_27_12_2 n_28_12_2 6928.758925967244
R23145 n_27_12_2 n_27_13_2 9.447961294213812
R23146 n_27_12_2 n_27_12_3 928.5456359953067
R23147 n_27_12_3 n_28_12_3 97002.62496354131
R23148 n_27_12_3 n_27_13_3 132.27145811899325
R23149 n_27_12_3 n_27_12_4 12.345336091105704
R23150 n_27_12_4 n_28_12_4 2939.4734837436763
R23151 n_27_12_4 n_27_13_4 4.008226003605856
R23152 n_27_12_15 n_28_12_15 194005.2499270809
R23153 n_27_12_15 n_27_13_15 264.5429162379842
R23154 n_27_13_0 n_28_13_0 2771.5035703868975
R23155 n_27_13_0 n_27_14_0 3.7791845176855245
R23156 n_27_13_0 n_27_13_1 436.4958117926656
R23157 n_27_13_1 n_28_13_1 3880.104998541656
R23158 n_27_13_1 n_27_14_1 5.290858324759735
R23159 n_27_13_1 n_27_13_2 992.0359358924218
R23160 n_27_13_2 n_28_13_2 6928.758925967244
R23161 n_27_13_2 n_27_14_2 9.447961294213812
R23162 n_27_13_2 n_27_13_3 928.5456359953067
R23163 n_27_13_3 n_28_13_3 97002.62496354131
R23164 n_27_13_3 n_27_14_3 132.27145811899325
R23165 n_27_13_3 n_27_13_4 12.345336091105704
R23166 n_27_13_4 n_28_13_4 2939.4734837436763
R23167 n_27_13_4 n_27_14_4 4.008226003605856
R23168 n_27_13_15 n_28_13_15 194005.2499270809
R23169 n_27_13_15 n_27_14_15 264.5429162379842
R23170 n_27_14_0 n_28_14_0 2771.5035703868975
R23171 n_27_14_0 n_27_15_0 3.7791845176855245
R23172 n_27_14_0 n_27_14_1 436.4958117926656
R23173 n_27_14_1 n_28_14_1 3880.104998541656
R23174 n_27_14_1 n_27_15_1 5.290858324759735
R23175 n_27_14_1 n_27_14_2 992.0359358924218
R23176 n_27_14_2 n_28_14_2 6928.758925967244
R23177 n_27_14_2 n_27_15_2 9.447961294213812
R23178 n_27_14_2 n_27_14_3 928.5456359953067
R23179 n_27_14_3 n_28_14_3 97002.62496354131
R23180 n_27_14_3 n_27_15_3 132.27145811899325
R23181 n_27_14_3 n_27_14_4 12.345336091105704
R23182 n_27_14_4 n_28_14_4 2939.4734837436763
R23183 n_27_14_4 n_27_15_4 4.008226003605856
R23184 n_27_14_15 n_28_14_15 194005.2499270809
R23185 n_27_14_15 n_27_15_15 264.5429162379842
R23186 n_27_15_0 n_28_15_0 2771.5035703868975
R23187 n_27_15_0 n_27_16_0 110.44365362970498
R23188 n_27_15_0 n_27_15_1 436.4958117926656
R23189 n_27_15_1 n_28_15_1 3880.104998541656
R23190 n_27_15_1 n_27_16_1 154.62111508158694
R23191 n_27_15_1 n_27_15_2 992.0359358924218
R23192 n_27_15_2 n_28_15_2 6928.758925967244
R23193 n_27_15_2 n_27_16_2 276.1091340742624
R23194 n_27_15_2 n_27_15_3 928.5456359953067
R23195 n_27_15_3 n_28_15_3 97002.62496354131
R23196 n_27_15_3 n_27_16_3 3865.527877039671
R23197 n_27_15_3 n_27_15_4 12.345336091105704
R23198 n_27_15_4 n_28_15_4 2939.4734837436763
R23199 n_27_15_4 n_27_16_4 117.13720839514153
R23200 n_27_15_15 n_28_15_15 194005.2499270809
R23201 n_27_15_15 n_27_16_15 7731.055754079272
R23202 n_27_16_0 n_28_16_0 48.243351062347855
R23203 n_27_16_0 n_27_17_0 217.10812274172457
R23204 n_27_16_0 n_27_16_1 7.598049272084617
R23205 n_27_16_1 n_28_16_1 67.54069148728698
R23206 n_27_16_1 n_27_17_1 303.9513718384144
R23207 n_27_16_1 n_27_16_2 17.26829380019231
R23208 n_27_16_2 n_28_16_2 120.60837765586962
R23209 n_27_16_2 n_27_17_2 542.7703068543113
R23210 n_27_16_2 n_27_16_3 16.16312299698
R23211 n_27_16_3 n_28_16_3 1688.5172871821728
R23212 n_27_16_3 n_27_17_3 7598.784295960353
R23213 n_27_16_3 n_27_16_4 0.21489432284683782
R23214 n_27_16_4 n_28_16_4 51.167190520671895
R23215 n_27_16_4 n_27_17_4 230.26619078667736
R23216 n_27_16_4 n_27_16_5 0.21489432284683782
R23217 n_27_16_5 n_27_17_5 7598.784295960353
R23218 n_27_16_5 n_27_16_6 0.4144390512046158
R23219 n_27_16_6 n_27_17_6 1688.6187324356338
R23220 n_27_16_6 n_27_16_7 0.5832845905842734
R23221 n_27_16_7 n_27_17_7 2894.774969889667
R23222 n_27_16_7 n_27_16_8 0.4297886456936743
R23223 n_27_16_8 n_27_17_8 2894.774969889667
R23224 n_27_16_8 n_27_16_9 0.4297886456936743
R23225 n_27_16_9 n_27_17_9 2894.774969889667
R23226 n_27_16_9 n_27_16_10 0.4297886456936743
R23227 n_27_16_10 n_27_17_10 2894.774969889667
R23228 n_27_16_10 n_27_16_11 0.4297886456936716
R23229 n_27_16_11 n_27_17_11 2894.774969889704
R23230 n_27_16_11 n_27_16_12 0.42978864569367015
R23231 n_27_16_12 n_27_17_12 2894.7749698896855
R23232 n_27_16_12 n_27_16_13 0.42978864569367425
R23233 n_27_16_13 n_27_17_13 2894.774969889649
R23234 n_27_16_13 n_27_16_14 2.1489432284683767
R23235 n_27_16_14 n_27_17_14 321.6416633210734
R23236 n_27_16_14 n_27_16_15 11.143805599057526
R23237 n_27_16_15 n_28_16_15 3377.034574364316
R23238 n_27_16_15 n_27_17_15 15197.56859192057
R23239 n_27_17_0 n_28_17_0 48.243351062347784
R23240 n_27_17_0 n_27_18_0 217.10812274172469
R23241 n_27_17_0 n_27_17_1 7.598049272084607
R23242 n_27_17_1 n_28_17_1 67.5406914872869
R23243 n_27_17_1 n_27_18_1 303.95137183841456
R23244 n_27_17_1 n_27_17_2 17.268293800192286
R23245 n_27_17_2 n_28_17_2 120.60837765586945
R23246 n_27_17_2 n_27_18_2 542.7703068543117
R23247 n_27_17_2 n_27_17_3 16.16312299697998
R23248 n_27_17_3 n_28_17_3 1688.517287182171
R23249 n_27_17_3 n_27_18_3 7598.784295960358
R23250 n_27_17_3 n_27_17_4 0.21489432284683754
R23251 n_27_17_4 n_28_17_4 51.167190520671845
R23252 n_27_17_4 n_27_18_4 230.2661907866775
R23253 n_27_17_4 n_27_17_5 0.21489432284683754
R23254 n_27_17_5 n_27_18_5 7598.784295960358
R23255 n_27_17_5 n_27_17_6 0.41443905120461527
R23256 n_27_17_6 n_27_18_6 1688.6187324356347
R23257 n_27_17_6 n_27_17_7 0.5832845905842726
R23258 n_27_17_7 n_27_18_7 2894.7749698896687
R23259 n_27_17_7 n_27_17_8 0.4297886456936737
R23260 n_27_17_8 n_27_18_8 2894.7749698896687
R23261 n_27_17_8 n_27_17_9 0.4297886456936737
R23262 n_27_17_9 n_27_18_9 2894.7749698896687
R23263 n_27_17_9 n_27_17_10 0.4297886456936737
R23264 n_27_17_10 n_27_18_10 2894.7749698896687
R23265 n_27_17_10 n_27_17_11 0.429788645693671
R23266 n_27_17_11 n_27_18_11 2894.774969889706
R23267 n_27_17_11 n_27_17_12 0.4297886456936696
R23268 n_27_17_12 n_27_18_12 2894.7749698896873
R23269 n_27_17_12 n_27_17_13 0.4297886456936737
R23270 n_27_17_13 n_27_18_13 2894.774969889651
R23271 n_27_17_13 n_27_17_14 2.148943228468374
R23272 n_27_17_14 n_27_18_14 321.64166332107357
R23273 n_27_17_14 n_27_17_15 11.143805599057513
R23274 n_27_17_15 n_28_17_15 3377.034574364312
R23275 n_27_17_15 n_27_18_15 15197.568591920579
R23276 n_27_18_0 n_28_18_0 48.243351062347784
R23277 n_27_18_0 n_27_19_0 217.10812274172457
R23278 n_27_18_0 n_27_18_1 7.598049272084607
R23279 n_27_18_1 n_28_18_1 67.5406914872869
R23280 n_27_18_1 n_27_19_1 303.9513718384144
R23281 n_27_18_1 n_27_18_2 17.268293800192286
R23282 n_27_18_2 n_28_18_2 120.60837765586945
R23283 n_27_18_2 n_27_19_2 542.7703068543113
R23284 n_27_18_2 n_27_18_3 16.16312299697998
R23285 n_27_18_3 n_28_18_3 1688.517287182171
R23286 n_27_18_3 n_27_19_3 7598.784295960353
R23287 n_27_18_3 n_27_18_4 0.21489432284683754
R23288 n_27_18_4 n_28_18_4 51.167190520671845
R23289 n_27_18_4 n_27_19_4 230.26619078667736
R23290 n_27_18_4 n_27_18_5 0.21489432284683754
R23291 n_27_18_5 n_27_19_5 7598.784295960353
R23292 n_27_18_5 n_27_18_6 0.41443905120461527
R23293 n_27_18_6 n_27_19_6 1688.6187324356338
R23294 n_27_18_6 n_27_18_7 0.5832845905842726
R23295 n_27_18_7 n_27_19_7 2894.774969889667
R23296 n_27_18_7 n_27_18_8 0.4297886456936737
R23297 n_27_18_8 n_27_19_8 2894.774969889667
R23298 n_27_18_8 n_27_18_9 0.4297886456936737
R23299 n_27_18_9 n_27_19_9 2894.774969889667
R23300 n_27_18_9 n_27_18_10 0.4297886456936737
R23301 n_27_18_10 n_27_19_10 2894.774969889667
R23302 n_27_18_10 n_27_18_11 0.429788645693671
R23303 n_27_18_11 n_27_19_11 2894.774969889704
R23304 n_27_18_11 n_27_18_12 0.4297886456936696
R23305 n_27_18_12 n_27_19_12 2894.7749698896855
R23306 n_27_18_12 n_27_18_13 0.4297886456936737
R23307 n_27_18_13 n_27_19_13 2894.774969889649
R23308 n_27_18_13 n_27_18_14 2.148943228468374
R23309 n_27_18_14 n_27_19_14 321.6416633210734
R23310 n_27_18_14 n_27_18_15 11.143805599057513
R23311 n_27_18_15 n_28_18_15 3377.034574364312
R23312 n_27_18_15 n_27_19_15 15197.56859192057
R23313 n_27_19_0 n_28_19_0 48.243351062347855
R23314 n_27_19_0 n_27_20_0 110.44365397508213
R23315 n_27_19_0 n_27_19_1 7.598049272084617
R23316 n_27_19_1 n_28_19_1 67.54069148728698
R23317 n_27_19_1 n_27_20_1 154.62111556511496
R23318 n_27_19_1 n_27_19_2 17.26829380019231
R23319 n_27_19_2 n_28_19_2 120.60837765586962
R23320 n_27_19_2 n_27_20_2 276.1091349377053
R23321 n_27_19_2 n_27_19_3 16.16312299698
R23322 n_27_19_3 n_28_19_3 1688.5172871821728
R23323 n_27_19_3 n_27_20_3 3865.5278891278713
R23324 n_27_19_3 n_27_19_4 0.21489432284683782
R23325 n_27_19_4 n_28_19_4 51.167190520671895
R23326 n_27_19_4 n_27_20_4 117.13720876145064
R23327 n_27_19_4 n_27_19_5 0.21489432284683782
R23328 n_27_19_5 n_27_19_6 0.4144390512046158
R23329 n_27_19_6 n_27_19_7 0.5832845905842734
R23330 n_27_19_7 n_27_19_8 0.4297886456936743
R23331 n_27_19_8 n_27_19_9 0.4297886456936743
R23332 n_27_19_9 n_27_19_10 0.4297886456936743
R23333 n_27_19_10 n_27_19_11 0.4297886456936716
R23334 n_27_19_11 n_27_19_12 0.42978864569367015
R23335 n_27_19_12 n_27_19_13 0.42978864569367425
R23336 n_27_19_13 n_27_19_14 2.1489432284683767
R23337 n_27_19_14 n_27_19_15 11.143805599057526
R23338 n_27_19_15 n_28_19_15 3377.034574364316
R23339 n_27_19_15 n_27_20_15 7731.0557782556725
R23340 n_27_20_0 n_28_20_0 2771.5030638152725
R23341 n_27_20_0 n_27_21_0 3.7791852084398188
R23342 n_27_20_0 n_27_20_1 436.4957320105592
R23343 n_27_20_1 n_28_20_1 3880.10428934138
R23344 n_27_20_1 n_27_21_1 5.290859291815746
R23345 n_27_20_1 n_27_20_2 992.0357545694527
R23346 n_27_20_2 n_28_20_2 6928.757659538181
R23347 n_27_20_2 n_27_21_2 9.447963021099547
R23348 n_27_20_2 n_27_20_3 928.5454662770078
R23349 n_27_20_3 n_28_20_3 97002.60723353442
R23350 n_27_20_3 n_27_21_3 132.27148229539355
R23351 n_27_20_3 n_27_20_4 12.34533383464209
R23352 n_27_20_4 n_28_20_4 2939.47294647074
R23353 n_27_20_4 n_27_21_4 4.008226736224047
R23354 n_27_20_15 n_28_20_15 194005.21446706713
R23355 n_27_20_15 n_27_21_15 264.5429645907847
R23356 n_27_21_0 n_28_21_0 2771.5030638152725
R23357 n_27_21_0 n_27_22_0 3.7791852084396846
R23358 n_27_21_0 n_27_21_1 436.4957320105592
R23359 n_27_21_1 n_28_21_1 3880.10428934138
R23360 n_27_21_1 n_27_22_1 5.290859291815558
R23361 n_27_21_1 n_27_21_2 992.0357545694527
R23362 n_27_21_2 n_28_21_2 6928.757659538181
R23363 n_27_21_2 n_27_22_2 9.447963021099211
R23364 n_27_21_2 n_27_21_3 928.5454662770078
R23365 n_27_21_3 n_28_21_3 97002.60723353442
R23366 n_27_21_3 n_27_22_3 132.27148229538886
R23367 n_27_21_3 n_27_21_4 12.34533383464209
R23368 n_27_21_4 n_28_21_4 2939.47294647074
R23369 n_27_21_4 n_27_22_4 4.008226736223905
R23370 n_27_21_15 n_28_21_15 194005.21446706713
R23371 n_27_21_15 n_27_22_15 264.54296459077534
R23372 n_27_22_0 n_28_22_0 2771.503063815469
R23373 n_27_22_0 n_27_23_0 3.7791852084396846
R23374 n_27_22_0 n_27_22_1 436.49573201059025
R23375 n_27_22_1 n_28_22_1 3880.1042893416566
R23376 n_27_22_1 n_27_23_1 5.290859291815558
R23377 n_27_22_1 n_27_22_2 992.0357545695232
R23378 n_27_22_2 n_28_22_2 6928.757659538673
R23379 n_27_22_2 n_27_23_2 9.447963021099211
R23380 n_27_22_2 n_27_22_3 928.5454662770737
R23381 n_27_22_3 n_28_22_3 97002.60723354133
R23382 n_27_22_3 n_27_23_3 132.27148229538886
R23383 n_27_22_3 n_27_22_4 12.345333834642968
R23384 n_27_22_4 n_28_22_4 2939.472946470949
R23385 n_27_22_4 n_27_23_4 4.008226736223905
R23386 n_27_22_15 n_28_22_15 194005.21446708092
R23387 n_27_22_15 n_27_23_15 264.54296459077534
R23388 n_27_23_0 n_28_23_0 2771.5030638152725
R23389 n_27_23_0 n_27_24_0 43.561715139231076
R23390 n_27_23_0 n_27_23_1 436.4957320105592
R23391 n_27_23_1 n_28_23_1 3880.10428934138
R23392 n_27_23_1 n_27_24_1 60.98640119492351
R23393 n_27_23_1 n_27_23_2 992.0357545694527
R23394 n_27_23_2 n_28_23_2 6928.757659538181
R23395 n_27_23_2 n_27_24_2 108.90428784807769
R23396 n_27_23_2 n_27_23_3 928.5454662770078
R23397 n_27_23_3 n_28_23_3 97002.60723353442
R23398 n_27_23_3 n_27_24_3 1524.6600298730866
R23399 n_27_23_3 n_27_23_4 12.34533383464209
R23400 n_27_23_4 n_28_23_4 2939.47294647074
R23401 n_27_23_4 n_27_24_4 46.20181908706322
R23402 n_27_23_15 n_28_23_15 194005.21446706713
R23403 n_27_23_15 n_27_24_15 3049.3200597461455
R23404 n_27_24_0 n_28_24_0 125.67182503262799
R23405 n_27_24_0 n_27_25_0 83.3442450700222
R23406 n_27_24_0 n_27_24_1 19.79258690957598
R23407 n_27_24_1 n_28_24_1 175.94055504567916
R23408 n_27_24_1 n_27_25_1 116.68194309803108
R23409 n_27_24_1 n_27_24_2 44.983152067218136
R23410 n_27_24_2 n_28_24_2 314.17956258157
R23411 n_27_24_2 n_27_25_2 208.3606126750555
R23412 n_27_24_2 n_27_24_3 42.10423033491618
R23413 n_27_24_3 n_28_24_3 4398.513876141976
R23414 n_27_24_3 n_27_25_3 2917.048577450775
R23415 n_27_24_3 n_27_24_4 0.5597903368364929
R23416 n_27_24_4 n_28_24_4 133.28829927702958
R23417 n_27_24_4 n_27_25_4 88.39541143790225
R23418 n_27_24_4 n_27_24_5 0.46268384983424415
R23419 n_27_24_5 n_28_24_5 837.8121668841859
R23420 n_27_24_5 n_27_25_5 555.6283004668143
R23421 n_27_24_5 n_27_24_6 0.15994009623899796
R23422 n_27_24_6 n_28_24_6 139.6353611473643
R23423 n_27_24_6 n_27_25_6 92.60471674446904
R23424 n_27_24_6 n_27_24_7 0.217061559181497
R23425 n_27_24_7 n_28_24_7 239.37490482405383
R23426 n_27_24_7 n_27_25_7 158.75094299051884
R23427 n_27_24_7 n_27_24_8 0.15994009623899746
R23428 n_27_24_8 n_28_24_8 239.37490482405383
R23429 n_27_24_8 n_27_25_8 158.75094299051884
R23430 n_27_24_8 n_27_24_9 0.15994009623899746
R23431 n_27_24_9 n_28_24_9 239.37490482405383
R23432 n_27_24_9 n_27_25_9 158.75094299051884
R23433 n_27_24_9 n_27_24_10 0.15994009623899746
R23434 n_27_24_10 n_28_24_10 239.37490482405383
R23435 n_27_24_10 n_27_25_10 158.75094299051884
R23436 n_27_24_10 n_27_24_11 0.15994009623899644
R23437 n_27_24_11 n_28_24_11 239.3749048240569
R23438 n_27_24_11 n_27_25_11 158.75094299052085
R23439 n_27_24_11 n_27_24_12 0.1599400962389959
R23440 n_27_24_12 n_28_24_12 239.37490482405536
R23441 n_27_24_12 n_27_25_12 158.75094299051983
R23442 n_27_24_12 n_27_24_13 0.15994009623899746
R23443 n_27_24_13 n_28_24_13 239.37490482405235
R23444 n_27_24_13 n_27_25_13 158.75094299051784
R23445 n_27_24_13 n_27_24_14 0.7997004811949894
R23446 n_27_24_14 n_28_24_14 26.597211647117035
R23447 n_27_24_14 n_27_25_14 17.638993665613164
R23448 n_27_24_14 n_27_24_15 24.7107448689254
R23449 n_27_24_15 n_28_24_15 8797.027752283871
R23450 n_27_24_15 n_27_25_15 5834.097154901498
R23451 n_27_25_0 n_28_25_0 125.6718250326284
R23452 n_27_25_0 n_27_26_0 83.3442450700222
R23453 n_27_25_0 n_27_25_1 19.792586909576038
R23454 n_27_25_1 n_28_25_1 175.94055504567976
R23455 n_27_25_1 n_27_26_1 116.68194309803108
R23456 n_27_25_1 n_27_25_2 44.983152067218285
R23457 n_27_25_2 n_28_25_2 314.179562581571
R23458 n_27_25_2 n_27_26_2 208.3606126750555
R23459 n_27_25_2 n_27_25_3 42.104230334916316
R23460 n_27_25_3 n_28_25_3 4398.51387614199
R23461 n_27_25_3 n_27_26_3 2917.048577450775
R23462 n_27_25_3 n_27_25_4 0.5597903368364947
R23463 n_27_25_4 n_28_25_4 133.28829927703
R23464 n_27_25_4 n_27_26_4 88.39541143790225
R23465 n_27_25_4 n_27_25_5 0.46268384983424565
R23466 n_27_25_5 n_28_25_5 837.8121668841885
R23467 n_27_25_5 n_27_26_5 555.6283004668143
R23468 n_27_25_5 n_27_25_6 0.1599400962389985
R23469 n_27_25_6 n_28_25_6 139.63536114736476
R23470 n_27_25_6 n_27_26_6 92.60471674446904
R23471 n_27_25_6 n_27_25_7 0.21706155918149772
R23472 n_27_25_7 n_28_25_7 239.37490482405465
R23473 n_27_25_7 n_27_26_7 158.75094299051884
R23474 n_27_25_7 n_27_25_8 0.159940096238998
R23475 n_27_25_8 n_28_25_8 239.37490482405465
R23476 n_27_25_8 n_27_26_8 158.75094299051884
R23477 n_27_25_8 n_27_25_9 0.159940096238998
R23478 n_27_25_9 n_28_25_9 239.37490482405465
R23479 n_27_25_9 n_27_26_9 158.75094299051884
R23480 n_27_25_9 n_27_25_10 0.159940096238998
R23481 n_27_25_10 n_28_25_10 239.37490482405465
R23482 n_27_25_10 n_27_26_10 158.75094299051884
R23483 n_27_25_10 n_27_25_11 0.15994009623899696
R23484 n_27_25_11 n_28_25_11 239.3749048240577
R23485 n_27_25_11 n_27_26_11 158.75094299052085
R23486 n_27_25_11 n_27_25_12 0.15994009623899647
R23487 n_27_25_12 n_28_25_12 239.37490482405607
R23488 n_27_25_12 n_27_26_12 158.75094299051983
R23489 n_27_25_12 n_27_25_13 0.15994009623899796
R23490 n_27_25_13 n_28_25_13 239.37490482405312
R23491 n_27_25_13 n_27_26_13 158.75094299051784
R23492 n_27_25_13 n_27_25_14 0.7997004811949919
R23493 n_27_25_14 n_28_25_14 26.59721164711712
R23494 n_27_25_14 n_27_26_14 17.638993665613164
R23495 n_27_25_14 n_27_25_15 24.71074486892548
R23496 n_27_25_15 n_28_25_15 8797.027752283902
R23497 n_27_25_15 n_27_26_15 5834.097154901498
R23498 n_27_26_0 n_28_26_0 125.67182503262799
R23499 n_27_26_0 n_27_27_0 83.34424507002234
R23500 n_27_26_0 n_27_26_1 19.79258690957598
R23501 n_27_26_1 n_28_26_1 175.94055504567916
R23502 n_27_26_1 n_27_27_1 116.68194309803127
R23503 n_27_26_1 n_27_26_2 44.983152067218136
R23504 n_27_26_2 n_28_26_2 314.17956258157
R23505 n_27_26_2 n_27_27_2 208.36061267505582
R23506 n_27_26_2 n_27_26_3 42.10423033491618
R23507 n_27_26_3 n_28_26_3 4398.513876141976
R23508 n_27_26_3 n_27_27_3 2917.0485774507797
R23509 n_27_26_3 n_27_26_4 0.5597903368364929
R23510 n_27_26_4 n_28_26_4 133.28829927702958
R23511 n_27_26_4 n_27_27_4 88.3954114379024
R23512 n_27_26_4 n_27_26_5 0.46268384983424415
R23513 n_27_26_5 n_28_26_5 837.8121668841859
R23514 n_27_26_5 n_27_27_5 555.6283004668152
R23515 n_27_26_5 n_27_26_6 0.15994009623899796
R23516 n_27_26_6 n_28_26_6 139.6353611473643
R23517 n_27_26_6 n_27_27_6 92.60471674446919
R23518 n_27_26_6 n_27_26_7 0.217061559181497
R23519 n_27_26_7 n_28_26_7 239.37490482405383
R23520 n_27_26_7 n_27_27_7 158.7509429905191
R23521 n_27_26_7 n_27_26_8 0.15994009623899746
R23522 n_27_26_8 n_28_26_8 239.37490482405383
R23523 n_27_26_8 n_27_27_8 158.7509429905191
R23524 n_27_26_8 n_27_26_9 0.15994009623899746
R23525 n_27_26_9 n_28_26_9 239.37490482405383
R23526 n_27_26_9 n_27_27_9 158.7509429905191
R23527 n_27_26_9 n_27_26_10 0.15994009623899746
R23528 n_27_26_10 n_28_26_10 239.37490482405383
R23529 n_27_26_10 n_27_27_10 158.7509429905191
R23530 n_27_26_10 n_27_26_11 0.15994009623899644
R23531 n_27_26_11 n_28_26_11 239.3749048240569
R23532 n_27_26_11 n_27_27_11 158.7509429905211
R23533 n_27_26_11 n_27_26_12 0.1599400962389959
R23534 n_27_26_12 n_28_26_12 239.37490482405536
R23535 n_27_26_12 n_27_27_12 158.7509429905201
R23536 n_27_26_12 n_27_26_13 0.15994009623899746
R23537 n_27_26_13 n_28_26_13 239.37490482405235
R23538 n_27_26_13 n_27_27_13 158.7509429905181
R23539 n_27_26_13 n_27_26_14 0.7997004811949894
R23540 n_27_26_14 n_28_26_14 26.597211647117035
R23541 n_27_26_14 n_27_27_14 17.638993665613192
R23542 n_27_26_14 n_27_26_15 24.7107448689254
R23543 n_27_26_15 n_28_26_15 8797.027752283871
R23544 n_27_26_15 n_27_27_15 5834.097154901507
R23545 n_27_27_0 n_28_27_0 125.67182503262799
R23546 n_27_27_0 n_27_27_1 19.79258690957598
R23547 n_27_27_1 n_28_27_1 175.94055504567916
R23548 n_27_27_1 n_27_27_2 44.983152067218136
R23549 n_27_27_2 n_28_27_2 314.17956258157
R23550 n_27_27_2 n_27_27_3 42.10423033491618
R23551 n_27_27_3 n_28_27_3 4398.513876141976
R23552 n_27_27_3 n_27_27_4 0.5597903368364929
R23553 n_27_27_4 n_28_27_4 133.28829927702958
R23554 n_27_27_4 n_27_27_5 0.46268384983424415
R23555 n_27_27_5 n_28_27_5 837.8121668841859
R23556 n_27_27_5 n_27_27_6 0.15994009623899796
R23557 n_27_27_6 n_28_27_6 139.6353611473643
R23558 n_27_27_6 n_27_27_7 0.217061559181497
R23559 n_27_27_7 n_28_27_7 239.37490482405383
R23560 n_27_27_7 n_27_27_8 0.15994009623899746
R23561 n_27_27_8 n_28_27_8 239.37490482405383
R23562 n_27_27_8 n_27_27_9 0.15994009623899746
R23563 n_27_27_9 n_28_27_9 239.37490482405383
R23564 n_27_27_9 n_27_27_10 0.15994009623899746
R23565 n_27_27_10 n_28_27_10 239.37490482405383
R23566 n_27_27_10 n_27_27_11 0.15994009623899644
R23567 n_27_27_11 n_28_27_11 239.3749048240569
R23568 n_27_27_11 n_27_27_12 0.1599400962389959
R23569 n_27_27_12 n_28_27_12 239.37490482405536
R23570 n_27_27_12 n_27_27_13 0.15994009623899746
R23571 n_27_27_13 n_28_27_13 239.37490482405235
R23572 n_27_27_13 n_27_27_14 0.7997004811949894
R23573 n_27_27_14 n_28_27_14 26.597211647117035
R23574 n_27_27_14 n_27_27_15 24.7107448689254
R23575 n_27_27_15 n_28_27_15 8797.027752283871
R23576 n_28_0_0 n_29_0_0 6.4777532699254365
R23577 n_28_0_0 n_28_1_0 3150.5002452092954
R23578 n_28_0_0 n_28_0_1 748.1805026763932
R23579 n_28_0_1 n_29_0_1 9.06885457789561
R23580 n_28_0_1 n_28_1_1 4410.700343293014
R23581 n_28_0_1 n_28_0_2 1700.4102333554388
R23582 n_28_0_2 n_29_0_2 16.19438317481359
R23583 n_28_0_2 n_28_1_2 7876.25061302324
R23584 n_28_0_2 n_28_0_3 1591.5839784206908
R23585 n_28_0_3 n_29_0_3 226.72136444739002
R23586 n_28_0_3 n_28_1_3 110267.50858232524
R23587 n_28_0_3 n_28_0_4 21.160660681756593
R23588 n_28_0_4 n_29_0_4 6.870344377193637
R23589 n_28_0_4 n_28_1_4 3341.4396540098564
R23590 n_28_0_4 n_28_0_5 17.489933828798815
R23591 n_28_0_5 n_29_0_5 43.18502179950286
R23592 n_28_0_5 n_28_1_5 21003.33496806195
R23593 n_28_0_5 n_28_0_6 6.045903051930455
R23594 n_28_0_6 n_29_0_6 7.197503633250478
R23595 n_28_0_6 n_28_1_6 3500.5558280103255
R23596 n_28_0_6 n_28_0_7 8.205154141905608
R23597 n_28_0_7 n_29_0_7 12.338577657000856
R23598 n_28_0_7 n_28_1_7 6000.95284801772
R23599 n_28_0_7 n_28_0_8 6.045903051930436
R23600 n_28_0_8 n_29_0_8 12.338577657000856
R23601 n_28_0_8 n_28_1_8 6000.95284801772
R23602 n_28_0_8 n_28_0_9 6.045903051930436
R23603 n_28_0_9 n_29_0_9 12.338577657000856
R23604 n_28_0_9 n_28_1_9 6000.95284801772
R23605 n_28_0_9 n_28_0_10 6.045903051930436
R23606 n_28_0_10 n_29_0_10 12.338577657000856
R23607 n_28_0_10 n_28_1_10 6000.95284801772
R23608 n_28_0_10 n_28_0_11 6.045903051930397
R23609 n_28_0_11 n_29_0_11 12.338577657001014
R23610 n_28_0_11 n_28_1_11 6000.952848017796
R23611 n_28_0_11 n_28_0_12 6.045903051930377
R23612 n_28_0_12 n_29_0_12 12.33857765700094
R23613 n_28_0_12 n_28_1_12 6000.952848017758
R23614 n_28_0_12 n_28_0_13 6.045903051930436
R23615 n_28_0_13 n_29_0_13 12.33857765700078
R23616 n_28_0_13 n_28_1_13 6000.952848017681
R23617 n_28_0_13 n_28_0_14 30.229515259652253
R23618 n_28_0_14 n_29_0_14 1.3709530730000923
R23619 n_28_0_14 n_28_1_14 666.7725386686341
R23620 n_28_0_14 n_28_0_15 934.0920215232634
R23621 n_28_0_15 n_29_0_15 453.44272889477605
R23622 n_28_0_15 n_28_1_15 220535.01716464857
R23623 n_28_1_0 n_29_1_0 6.4777532699254365
R23624 n_28_1_0 n_28_2_0 3150.5002452092954
R23625 n_28_1_0 n_28_1_1 748.1805026763932
R23626 n_28_1_1 n_29_1_1 9.06885457789561
R23627 n_28_1_1 n_28_2_1 4410.700343293014
R23628 n_28_1_1 n_28_1_2 1700.4102333554388
R23629 n_28_1_2 n_29_1_2 16.19438317481359
R23630 n_28_1_2 n_28_2_2 7876.25061302324
R23631 n_28_1_2 n_28_1_3 1591.5839784206908
R23632 n_28_1_3 n_29_1_3 226.72136444739002
R23633 n_28_1_3 n_28_2_3 110267.50858232524
R23634 n_28_1_3 n_28_1_4 21.160660681756593
R23635 n_28_1_4 n_29_1_4 6.870344377193637
R23636 n_28_1_4 n_28_2_4 3341.4396540098564
R23637 n_28_1_4 n_28_1_5 17.489933828798815
R23638 n_28_1_5 n_29_1_5 43.18502179950286
R23639 n_28_1_5 n_28_2_5 21003.33496806195
R23640 n_28_1_5 n_28_1_6 6.045903051930455
R23641 n_28_1_6 n_29_1_6 7.197503633250478
R23642 n_28_1_6 n_28_2_6 3500.5558280103255
R23643 n_28_1_6 n_28_1_7 8.205154141905608
R23644 n_28_1_7 n_29_1_7 12.338577657000856
R23645 n_28_1_7 n_28_2_7 6000.95284801772
R23646 n_28_1_7 n_28_1_8 6.045903051930436
R23647 n_28_1_8 n_29_1_8 12.338577657000856
R23648 n_28_1_8 n_28_2_8 6000.95284801772
R23649 n_28_1_8 n_28_1_9 6.045903051930436
R23650 n_28_1_9 n_29_1_9 12.338577657000856
R23651 n_28_1_9 n_28_2_9 6000.95284801772
R23652 n_28_1_9 n_28_1_10 6.045903051930436
R23653 n_28_1_10 n_29_1_10 12.338577657000856
R23654 n_28_1_10 n_28_2_10 6000.95284801772
R23655 n_28_1_10 n_28_1_11 6.045903051930397
R23656 n_28_1_11 n_29_1_11 12.338577657001014
R23657 n_28_1_11 n_28_2_11 6000.952848017796
R23658 n_28_1_11 n_28_1_12 6.045903051930377
R23659 n_28_1_12 n_29_1_12 12.33857765700094
R23660 n_28_1_12 n_28_2_12 6000.952848017758
R23661 n_28_1_12 n_28_1_13 6.045903051930436
R23662 n_28_1_13 n_29_1_13 12.33857765700078
R23663 n_28_1_13 n_28_2_13 6000.952848017681
R23664 n_28_1_13 n_28_1_14 30.229515259652253
R23665 n_28_1_14 n_29_1_14 1.3709530730000923
R23666 n_28_1_14 n_28_2_14 666.7725386686341
R23667 n_28_1_14 n_28_1_15 934.0920215232634
R23668 n_28_1_15 n_29_1_15 453.44272889477605
R23669 n_28_1_15 n_28_2_15 220535.01716464857
R23670 n_28_2_0 n_29_2_0 6.4777532699254365
R23671 n_28_2_0 n_28_3_0 3150.5002452092954
R23672 n_28_2_0 n_28_2_1 748.1805026763932
R23673 n_28_2_1 n_29_2_1 9.06885457789561
R23674 n_28_2_1 n_28_3_1 4410.700343293014
R23675 n_28_2_1 n_28_2_2 1700.4102333554388
R23676 n_28_2_2 n_29_2_2 16.19438317481359
R23677 n_28_2_2 n_28_3_2 7876.25061302324
R23678 n_28_2_2 n_28_2_3 1591.5839784206908
R23679 n_28_2_3 n_29_2_3 226.72136444739002
R23680 n_28_2_3 n_28_3_3 110267.50858232524
R23681 n_28_2_3 n_28_2_4 21.160660681756593
R23682 n_28_2_4 n_29_2_4 6.870344377193637
R23683 n_28_2_4 n_28_3_4 3341.4396540098564
R23684 n_28_2_4 n_28_2_5 17.489933828798815
R23685 n_28_2_5 n_29_2_5 43.18502179950286
R23686 n_28_2_5 n_28_3_5 21003.33496806195
R23687 n_28_2_5 n_28_2_6 6.045903051930455
R23688 n_28_2_6 n_29_2_6 7.197503633250478
R23689 n_28_2_6 n_28_3_6 3500.5558280103255
R23690 n_28_2_6 n_28_2_7 8.205154141905608
R23691 n_28_2_7 n_29_2_7 12.338577657000856
R23692 n_28_2_7 n_28_3_7 6000.95284801772
R23693 n_28_2_7 n_28_2_8 6.045903051930436
R23694 n_28_2_8 n_29_2_8 12.338577657000856
R23695 n_28_2_8 n_28_3_8 6000.95284801772
R23696 n_28_2_8 n_28_2_9 6.045903051930436
R23697 n_28_2_9 n_29_2_9 12.338577657000856
R23698 n_28_2_9 n_28_3_9 6000.95284801772
R23699 n_28_2_9 n_28_2_10 6.045903051930436
R23700 n_28_2_10 n_29_2_10 12.338577657000856
R23701 n_28_2_10 n_28_3_10 6000.95284801772
R23702 n_28_2_10 n_28_2_11 6.045903051930397
R23703 n_28_2_11 n_29_2_11 12.338577657001014
R23704 n_28_2_11 n_28_3_11 6000.952848017796
R23705 n_28_2_11 n_28_2_12 6.045903051930377
R23706 n_28_2_12 n_29_2_12 12.33857765700094
R23707 n_28_2_12 n_28_3_12 6000.952848017758
R23708 n_28_2_12 n_28_2_13 6.045903051930436
R23709 n_28_2_13 n_29_2_13 12.33857765700078
R23710 n_28_2_13 n_28_3_13 6000.952848017681
R23711 n_28_2_13 n_28_2_14 30.229515259652253
R23712 n_28_2_14 n_29_2_14 1.3709530730000923
R23713 n_28_2_14 n_28_3_14 666.7725386686341
R23714 n_28_2_14 n_28_2_15 934.0920215232634
R23715 n_28_2_15 n_29_2_15 453.44272889477605
R23716 n_28_2_15 n_28_3_15 220535.01716464857
R23717 n_28_3_0 n_29_3_0 6.4777532699254365
R23718 n_28_3_0 n_28_4_0 1646.6785714285472
R23719 n_28_3_0 n_28_3_1 748.1805026763932
R23720 n_28_3_1 n_29_3_1 9.06885457789561
R23721 n_28_3_1 n_28_4_1 2305.3499999999667
R23722 n_28_3_1 n_28_3_2 1700.4102333554388
R23723 n_28_3_2 n_29_3_2 16.19438317481359
R23724 n_28_3_2 n_28_4_2 4116.696428571369
R23725 n_28_3_2 n_28_3_3 1591.5839784206908
R23726 n_28_3_3 n_29_3_3 226.72136444739002
R23727 n_28_3_3 n_28_4_3 57633.749999999105
R23728 n_28_3_3 n_28_3_4 21.160660681756593
R23729 n_28_3_4 n_29_3_4 6.870344377193637
R23730 n_28_3_4 n_28_4_4 1746.477272727246
R23731 n_28_3_4 n_28_3_5 17.489933828798815
R23732 n_28_3_5 n_29_3_5 43.18502179950286
R23733 n_28_3_5 n_28_3_6 6.045903051930455
R23734 n_28_3_6 n_29_3_6 7.197503633250478
R23735 n_28_3_6 n_28_3_7 8.205154141905608
R23736 n_28_3_7 n_29_3_7 12.338577657000856
R23737 n_28_3_7 n_28_3_8 6.045903051930436
R23738 n_28_3_8 n_29_3_8 12.338577657000856
R23739 n_28_3_8 n_28_3_9 6.045903051930436
R23740 n_28_3_9 n_29_3_9 12.338577657000856
R23741 n_28_3_9 n_28_3_10 6.045903051930436
R23742 n_28_3_10 n_29_3_10 12.338577657000856
R23743 n_28_3_10 n_28_3_11 6.045903051930397
R23744 n_28_3_11 n_29_3_11 12.338577657001014
R23745 n_28_3_11 n_28_3_12 6.045903051930377
R23746 n_28_3_12 n_29_3_12 12.33857765700094
R23747 n_28_3_12 n_28_3_13 6.045903051930436
R23748 n_28_3_13 n_29_3_13 12.33857765700078
R23749 n_28_3_13 n_28_3_14 30.229515259652253
R23750 n_28_3_14 n_29_3_14 1.3709530730000923
R23751 n_28_3_14 n_28_3_15 934.0920215232634
R23752 n_28_3_15 n_29_3_15 453.44272889477605
R23753 n_28_3_15 n_28_4_15 115267.4999999972
R23754 n_28_4_0 n_29_4_0 142.8573880669023
R23755 n_28_4_0 n_28_5_0 142.8568976478005
R23756 n_28_4_0 n_28_4_1 16500.028321727335
R23757 n_28_4_1 n_29_4_1 200.0003432936632
R23758 n_28_4_1 n_28_5_1 199.99965670692075
R23759 n_28_4_1 n_28_4_2 37500.064367562125
R23760 n_28_4_2 n_29_4_2 357.1434701672558
R23761 n_28_4_2 n_28_5_2 357.14224411950136
R23762 n_28_4_2 n_28_4_3 35100.06024803815
R23763 n_28_4_3 n_29_4_3 5000.0085823415775
R23764 n_28_4_3 n_28_5_3 4999.9914176730135
R23765 n_28_4_3 n_28_4_4 466.66746768521796
R23766 n_28_4_4 n_29_4_4 151.51541158610837
R23767 n_28_4_4 n_28_5_4 151.5148914446368
R23768 n_28_4_15 n_29_4_15 10000.017164683064
R23769 n_28_4_15 n_28_5_15 9999.982835345938
R23770 n_28_5_0 n_29_5_0 142.8573880668998
R23771 n_28_5_0 n_28_6_0 142.8568976478018
R23772 n_28_5_0 n_28_5_1 16500.02832172704
R23773 n_28_5_1 n_29_5_1 200.00034329365968
R23774 n_28_5_1 n_28_6_1 199.9996567069225
R23775 n_28_5_1 n_28_5_2 37500.06436756146
R23776 n_28_5_2 n_29_5_2 357.14347016724946
R23777 n_28_5_2 n_28_6_2 357.1422441195045
R23778 n_28_5_2 n_28_5_3 35100.06024803753
R23779 n_28_5_3 n_29_5_3 5000.008582341488
R23780 n_28_5_3 n_28_6_3 4999.991417673058
R23781 n_28_5_3 n_28_5_4 466.66746768520966
R23782 n_28_5_4 n_29_5_4 151.5154115861057
R23783 n_28_5_4 n_28_6_4 151.51489144463812
R23784 n_28_5_15 n_29_5_15 10000.017164682886
R23785 n_28_5_15 n_28_6_15 9999.982835346027
R23786 n_28_6_0 n_29_6_0 142.8573880668998
R23787 n_28_6_0 n_28_7_0 142.8568976478005
R23788 n_28_6_0 n_28_6_1 16500.02832172704
R23789 n_28_6_1 n_29_6_1 200.00034329365968
R23790 n_28_6_1 n_28_7_1 199.99965670692075
R23791 n_28_6_1 n_28_6_2 37500.06436756146
R23792 n_28_6_2 n_29_6_2 357.14347016724946
R23793 n_28_6_2 n_28_7_2 357.14224411950136
R23794 n_28_6_2 n_28_6_3 35100.06024803753
R23795 n_28_6_3 n_29_6_3 5000.008582341488
R23796 n_28_6_3 n_28_7_3 4999.9914176730135
R23797 n_28_6_3 n_28_6_4 466.66746768520966
R23798 n_28_6_4 n_29_6_4 151.5154115861057
R23799 n_28_6_4 n_28_7_4 151.5148914446368
R23800 n_28_6_15 n_29_6_15 10000.017164682886
R23801 n_28_6_15 n_28_7_15 9999.982835345938
R23802 n_28_7_0 n_29_7_0 142.8573880669023
R23803 n_28_7_0 n_28_8_0 4174.885948823841
R23804 n_28_7_0 n_28_7_1 16500.028321727335
R23805 n_28_7_1 n_29_7_1 200.0003432936632
R23806 n_28_7_1 n_28_8_1 5844.840328353377
R23807 n_28_7_1 n_28_7_2 37500.064367562125
R23808 n_28_7_2 n_29_7_2 357.1434701672558
R23809 n_28_7_2 n_28_8_2 10437.214872059603
R23810 n_28_7_2 n_28_7_3 35100.06024803815
R23811 n_28_7_3 n_29_7_3 5000.0085823415775
R23812 n_28_7_3 n_28_8_3 146121.00820883428
R23813 n_28_7_3 n_28_7_4 466.66746768521796
R23814 n_28_7_4 n_29_7_4 151.51541158610837
R23815 n_28_7_4 n_28_8_4 4427.909339661646
R23816 n_28_7_15 n_29_7_15 10000.017164683064
R23817 n_28_7_15 n_28_8_15 292242.01641766605
R23818 n_28_8_0 n_29_8_0 2.486703379443518
R23819 n_28_8_0 n_28_9_0 8206.914999999884
R23820 n_28_8_0 n_28_8_1 287.21424032572827
R23821 n_28_8_1 n_29_8_1 3.481384731220924
R23822 n_28_8_1 n_28_9_1 11489.680999999839
R23823 n_28_8_1 n_28_8_2 652.759637103928
R23824 n_28_8_2 n_29_8_2 6.216758448608793
R23825 n_28_8_2 n_28_9_2 20517.287499999715
R23826 n_28_8_2 n_28_8_3 610.9830203292765
R23827 n_28_8_3 n_29_8_3 87.03461828052303
R23828 n_28_8_3 n_28_9_3 287242.0249999957
R23829 n_28_8_3 n_28_8_4 8.123231039515554
R23830 n_28_8_4 n_29_8_4 2.637412675167365
R23831 n_28_8_4 n_28_9_4 8704.30378787866
R23832 n_28_8_15 n_29_8_15 174.06923656104453
R23833 n_28_8_15 n_28_9_15 574484.0499999863
R23834 n_28_9_0 n_29_9_0 2.4867033794435156
R23835 n_28_9_0 n_28_10_0 8206.914999999884
R23836 n_28_9_0 n_28_9_1 287.2142403257281
R23837 n_28_9_1 n_29_9_1 3.4813847312209223
R23838 n_28_9_1 n_28_10_1 11489.680999999839
R23839 n_28_9_1 n_28_9_2 652.7596371039276
R23840 n_28_9_2 n_29_9_2 6.21675844860879
R23841 n_28_9_2 n_28_10_2 20517.287499999715
R23842 n_28_9_2 n_28_9_3 610.9830203292762
R23843 n_28_9_3 n_29_9_3 87.03461828052298
R23844 n_28_9_3 n_28_10_3 287242.0249999957
R23845 n_28_9_3 n_28_9_4 8.123231039515549
R23846 n_28_9_4 n_29_9_4 2.637412675167363
R23847 n_28_9_4 n_28_10_4 8704.30378787866
R23848 n_28_9_15 n_29_9_15 174.06923656104442
R23849 n_28_9_15 n_28_10_15 574484.0499999863
R23850 n_28_10_0 n_29_10_0 2.486703379443518
R23851 n_28_10_0 n_28_11_0 8206.914999999883
R23852 n_28_10_0 n_28_10_1 287.21424032572827
R23853 n_28_10_1 n_29_10_1 3.481384731220924
R23854 n_28_10_1 n_28_11_1 11489.680999999835
R23855 n_28_10_1 n_28_10_2 652.759637103928
R23856 n_28_10_2 n_29_10_2 6.216758448608793
R23857 n_28_10_2 n_28_11_2 20517.287499999708
R23858 n_28_10_2 n_28_10_3 610.9830203292765
R23859 n_28_10_3 n_29_10_3 87.03461828052303
R23860 n_28_10_3 n_28_11_3 287242.0249999956
R23861 n_28_10_3 n_28_10_4 8.123231039515554
R23862 n_28_10_4 n_29_10_4 2.637412675167365
R23863 n_28_10_4 n_28_11_4 8704.303787878656
R23864 n_28_10_15 n_29_10_15 174.06923656104453
R23865 n_28_10_15 n_28_11_15 574484.0499999862
R23866 n_28_11_0 n_29_11_0 2.486703379443518
R23867 n_28_11_0 n_28_12_0 4174.886071428513
R23868 n_28_11_0 n_28_11_1 287.21424032572827
R23869 n_28_11_1 n_29_11_1 3.481384731220924
R23870 n_28_11_1 n_28_12_1 5844.8404999999175
R23871 n_28_11_1 n_28_11_2 652.759637103928
R23872 n_28_11_2 n_29_11_2 6.216758448608793
R23873 n_28_11_2 n_28_12_2 10437.215178571283
R23874 n_28_11_2 n_28_11_3 610.9830203292765
R23875 n_28_11_3 n_29_11_3 87.03461828052303
R23876 n_28_11_3 n_28_12_3 146121.0124999978
R23877 n_28_11_3 n_28_11_4 8.123231039515554
R23878 n_28_11_4 n_29_11_4 2.637412675167365
R23879 n_28_11_4 n_28_12_4 4427.909469696904
R23880 n_28_11_15 n_29_11_15 174.06923656104453
R23881 n_28_11_15 n_28_12_15 292242.02499999304
R23882 n_28_12_0 n_29_12_0 142.85714285713777
R23883 n_28_12_0 n_28_13_0 142.85714285714286
R23884 n_28_12_0 n_28_12_1 16499.99999999953
R23885 n_28_12_1 n_29_12_1 199.9999999999929
R23886 n_28_12_1 n_28_13_1 200.00000000000003
R23887 n_28_12_1 n_28_12_2 37499.99999999893
R23888 n_28_12_2 n_29_12_2 357.1428571428445
R23889 n_28_12_2 n_28_13_2 357.1428571428572
R23890 n_28_12_2 n_28_12_3 35099.999999999
R23891 n_28_12_3 n_29_12_3 4999.999999999818
R23892 n_28_12_3 n_28_13_3 4999.999999999996
R23893 n_28_12_3 n_28_12_4 466.66666666665384
R23894 n_28_12_4 n_29_12_4 151.51515151514602
R23895 n_28_12_4 n_28_13_4 151.51515151515142
R23896 n_28_12_15 n_29_12_15 9999.999999999549
R23897 n_28_12_15 n_28_13_15 9999.999999999904
R23898 n_28_13_0 n_29_13_0 142.85714285713777
R23899 n_28_13_0 n_28_14_0 142.85714285714286
R23900 n_28_13_0 n_28_13_1 16499.99999999953
R23901 n_28_13_1 n_29_13_1 199.9999999999929
R23902 n_28_13_1 n_28_14_1 200.00000000000003
R23903 n_28_13_1 n_28_13_2 37499.99999999893
R23904 n_28_13_2 n_29_13_2 357.1428571428445
R23905 n_28_13_2 n_28_14_2 357.1428571428572
R23906 n_28_13_2 n_28_13_3 35099.999999999
R23907 n_28_13_3 n_29_13_3 4999.999999999818
R23908 n_28_13_3 n_28_14_3 4999.999999999996
R23909 n_28_13_3 n_28_13_4 466.66666666665384
R23910 n_28_13_4 n_29_13_4 151.51515151514602
R23911 n_28_13_4 n_28_14_4 151.51515151515142
R23912 n_28_13_15 n_29_13_15 9999.999999999549
R23913 n_28_13_15 n_28_14_15 9999.999999999904
R23914 n_28_14_0 n_29_14_0 142.85714285713777
R23915 n_28_14_0 n_28_15_0 142.85714285714286
R23916 n_28_14_0 n_28_14_1 16499.99999999953
R23917 n_28_14_1 n_29_14_1 199.9999999999929
R23918 n_28_14_1 n_28_15_1 200.00000000000003
R23919 n_28_14_1 n_28_14_2 37499.99999999893
R23920 n_28_14_2 n_29_14_2 357.1428571428445
R23921 n_28_14_2 n_28_15_2 357.1428571428572
R23922 n_28_14_2 n_28_14_3 35099.999999999
R23923 n_28_14_3 n_29_14_3 4999.999999999818
R23924 n_28_14_3 n_28_15_3 4999.999999999996
R23925 n_28_14_3 n_28_14_4 466.66666666665384
R23926 n_28_14_4 n_29_14_4 151.51515151514602
R23927 n_28_14_4 n_28_15_4 151.51515151515142
R23928 n_28_14_15 n_29_14_15 9999.999999999549
R23929 n_28_14_15 n_28_15_15 9999.999999999904
R23930 n_28_15_0 n_29_15_0 142.85714285713777
R23931 n_28_15_0 n_28_16_0 4174.88607142851
R23932 n_28_15_0 n_28_15_1 16499.99999999953
R23933 n_28_15_1 n_29_15_1 199.9999999999929
R23934 n_28_15_1 n_28_16_1 5844.840499999915
R23935 n_28_15_1 n_28_15_2 37499.99999999893
R23936 n_28_15_2 n_29_15_2 357.1428571428445
R23937 n_28_15_2 n_28_16_2 10437.215178571278
R23938 n_28_15_2 n_28_15_3 35099.999999999
R23939 n_28_15_3 n_29_15_3 4999.999999999818
R23940 n_28_15_3 n_28_16_3 146121.0124999977
R23941 n_28_15_3 n_28_15_4 466.66666666665384
R23942 n_28_15_4 n_29_15_4 151.51515151514602
R23943 n_28_15_4 n_28_16_4 4427.909469696901
R23944 n_28_15_15 n_29_15_15 9999.999999999549
R23945 n_28_15_15 n_28_16_15 292242.02499999286
R23946 n_28_16_0 n_29_16_0 2.4867033794435196
R23947 n_28_16_0 n_28_17_0 8206.914999999883
R23948 n_28_16_0 n_28_16_1 287.21424032572844
R23949 n_28_16_1 n_29_16_1 3.4813847312209263
R23950 n_28_16_1 n_28_17_1 11489.680999999837
R23951 n_28_16_1 n_28_16_2 652.7596371039283
R23952 n_28_16_2 n_29_16_2 6.216758448608798
R23953 n_28_16_2 n_28_17_2 20517.287499999708
R23954 n_28_16_2 n_28_16_3 610.9830203292769
R23955 n_28_16_3 n_29_16_3 87.03461828052308
R23956 n_28_16_3 n_28_17_3 287242.0249999956
R23957 n_28_16_3 n_28_16_4 8.12323103951556
R23958 n_28_16_4 n_29_16_4 2.637412675167366
R23959 n_28_16_4 n_28_17_4 8704.303787878656
R23960 n_28_16_15 n_29_16_15 174.06923656104462
R23961 n_28_16_15 n_28_17_15 574484.0499999862
R23962 n_28_17_0 n_29_17_0 2.4867033794435156
R23963 n_28_17_0 n_28_18_0 8206.914999999888
R23964 n_28_17_0 n_28_17_1 287.2142403257281
R23965 n_28_17_1 n_29_17_1 3.4813847312209223
R23966 n_28_17_1 n_28_18_1 11489.680999999842
R23967 n_28_17_1 n_28_17_2 652.7596371039276
R23968 n_28_17_2 n_29_17_2 6.21675844860879
R23969 n_28_17_2 n_28_18_2 20517.287499999722
R23970 n_28_17_2 n_28_17_3 610.9830203292762
R23971 n_28_17_3 n_29_17_3 87.03461828052298
R23972 n_28_17_3 n_28_18_3 287242.0249999958
R23973 n_28_17_3 n_28_17_4 8.123231039515549
R23974 n_28_17_4 n_29_17_4 2.637412675167363
R23975 n_28_17_4 n_28_18_4 8704.303787878662
R23976 n_28_17_15 n_29_17_15 174.06923656104442
R23977 n_28_17_15 n_28_18_15 574484.0499999865
R23978 n_28_18_0 n_29_18_0 2.4867033794435156
R23979 n_28_18_0 n_28_19_0 8206.914999999883
R23980 n_28_18_0 n_28_18_1 287.2142403257281
R23981 n_28_18_1 n_29_18_1 3.4813847312209223
R23982 n_28_18_1 n_28_19_1 11489.680999999837
R23983 n_28_18_1 n_28_18_2 652.7596371039276
R23984 n_28_18_2 n_29_18_2 6.21675844860879
R23985 n_28_18_2 n_28_19_2 20517.287499999708
R23986 n_28_18_2 n_28_18_3 610.9830203292762
R23987 n_28_18_3 n_29_18_3 87.03461828052298
R23988 n_28_18_3 n_28_19_3 287242.0249999956
R23989 n_28_18_3 n_28_18_4 8.123231039515549
R23990 n_28_18_4 n_29_18_4 2.637412675167363
R23991 n_28_18_4 n_28_19_4 8704.303787878656
R23992 n_28_18_15 n_29_18_15 174.06923656104442
R23993 n_28_18_15 n_28_19_15 574484.0499999862
R23994 n_28_19_0 n_29_19_0 2.4867033794435196
R23995 n_28_19_0 n_28_20_0 4174.886084484129
R23996 n_28_19_0 n_28_19_1 287.21424032572844
R23997 n_28_19_1 n_29_19_1 3.4813847312209263
R23998 n_28_19_1 n_28_20_1 5844.8405182777815
R23999 n_28_19_1 n_28_19_2 652.7596371039283
R24000 n_28_19_2 n_29_19_2 6.216758448608798
R24001 n_28_19_2 n_28_20_2 10437.215211210323
R24002 n_28_19_2 n_28_19_3 610.9830203292769
R24003 n_28_19_3 n_29_19_3 87.03461828052308
R24004 n_28_19_3 n_28_20_3 146121.01295694438
R24005 n_28_19_3 n_28_19_4 8.12323103951556
R24006 n_28_19_4 n_29_19_4 2.637412675167366
R24007 n_28_19_4 n_28_20_4 4427.90948354377
R24008 n_28_19_15 n_29_19_15 174.06923656104462
R24009 n_28_19_15 n_28_20_15 292242.0259138862
R24010 n_28_20_0 n_29_20_0 142.85711674590496
R24011 n_28_20_0 n_28_21_0 142.85716896838048
R24012 n_28_20_0 n_28_20_1 16499.996984152138
R24013 n_28_20_1 n_29_20_1 199.9999634442669
R24014 n_28_20_1 n_28_21_1 200.00003655573266
R24015 n_28_20_1 n_28_20_2 37499.99314580031
R24016 n_28_20_2 n_29_20_2 357.14279186476244
R24017 n_28_20_2 n_28_21_2 357.1429224209512
R24018 n_28_20_2 n_28_20_3 35099.99358446909
R24019 n_28_20_3 n_29_20_3 4999.999086106669
R24020 n_28_20_3 n_28_21_3 5000.000913893312
R24021 n_28_20_3 n_28_20_4 466.66658136996
R24022 n_28_20_4 n_29_20_4 151.51512382141422
R24023 n_28_20_4 n_28_21_4 151.51517920888827
R24024 n_28_20_15 n_29_20_15 9999.998172213247
R24025 n_28_20_15 n_28_21_15 10000.001827786537
R24026 n_28_21_0 n_29_21_0 142.85711674590496
R24027 n_28_21_0 n_28_22_0 142.8571689683754
R24028 n_28_21_0 n_28_21_1 16499.996984152138
R24029 n_28_21_1 n_29_21_1 199.9999634442669
R24030 n_28_21_1 n_28_22_1 200.00003655572556
R24031 n_28_21_1 n_28_21_2 37499.99314580031
R24032 n_28_21_2 n_29_21_2 357.14279186476244
R24033 n_28_21_2 n_28_22_2 357.14292242093853
R24034 n_28_21_2 n_28_21_3 35099.99358446909
R24035 n_28_21_3 n_29_21_3 4999.999086106669
R24036 n_28_21_3 n_28_22_3 5000.000913893135
R24037 n_28_21_3 n_28_21_4 466.66658136996
R24038 n_28_21_4 n_29_21_4 151.51512382141422
R24039 n_28_21_4 n_28_22_4 151.5151792088829
R24040 n_28_21_15 n_29_21_15 9999.998172213247
R24041 n_28_21_15 n_28_22_15 10000.001827786182
R24042 n_28_22_0 n_29_22_0 142.8571167459151
R24043 n_28_22_0 n_28_23_0 142.8571689683754
R24044 n_28_22_0 n_28_22_1 16499.99698415331
R24045 n_28_22_1 n_29_22_1 199.99996344428115
R24046 n_28_22_1 n_28_23_1 200.00003655572556
R24047 n_28_22_1 n_28_22_2 37499.99314580298
R24048 n_28_22_2 n_29_22_2 357.1427918647878
R24049 n_28_22_2 n_28_23_2 357.14292242093853
R24050 n_28_22_2 n_28_22_3 35099.99358447159
R24051 n_28_22_3 n_29_22_3 4999.999086107024
R24052 n_28_22_3 n_28_23_3 5000.000913893135
R24053 n_28_22_3 n_28_22_4 466.66658136999297
R24054 n_28_22_4 n_29_22_4 151.51512382142496
R24055 n_28_22_4 n_28_23_4 151.5151792088829
R24056 n_28_22_15 n_29_22_15 9999.99817221396
R24057 n_28_22_15 n_28_23_15 10000.001827786182
R24058 n_28_23_0 n_29_23_0 142.85711674590496
R24059 n_28_23_0 n_28_24_0 1646.678571428551
R24060 n_28_23_0 n_28_23_1 16499.996984152138
R24061 n_28_23_1 n_29_23_1 199.9999634442669
R24062 n_28_23_1 n_28_24_1 2305.3499999999717
R24063 n_28_23_1 n_28_23_2 37499.99314580031
R24064 n_28_23_2 n_29_23_2 357.14279186476244
R24065 n_28_23_2 n_28_24_2 4116.696428571378
R24066 n_28_23_2 n_28_23_3 35099.99358446909
R24067 n_28_23_3 n_29_23_3 4999.999086106669
R24068 n_28_23_3 n_28_24_3 57633.749999999236
R24069 n_28_23_3 n_28_23_4 466.66658136996
R24070 n_28_23_4 n_29_23_4 151.51512382141422
R24071 n_28_23_4 n_28_24_4 1746.4772727272498
R24072 n_28_23_15 n_29_23_15 9999.998172213247
R24073 n_28_23_15 n_28_24_15 115267.49999999745
R24074 n_28_24_0 n_29_24_0 6.477753827788552
R24075 n_28_24_0 n_28_25_0 3150.499973888717
R24076 n_28_24_0 n_28_24_1 748.1805671095831
R24077 n_28_24_1 n_29_24_1 9.068855358903972
R24078 n_28_24_1 n_28_25_1 4410.699963444204
R24079 n_28_24_1 n_28_24_2 1700.410379794507
R24080 n_28_24_2 n_29_24_2 16.19438456947138
R24081 n_28_24_2 n_28_25_2 7876.249934721793
R24082 n_28_24_2 n_28_24_3 1591.5841154876584
R24083 n_28_24_3 n_29_24_3 226.72138397259914
R24084 n_28_24_3 n_28_25_3 110267.49908610499
R24085 n_28_24_3 n_28_24_4 21.16066250410944
R24086 n_28_24_4 n_29_24_4 6.87034496886664
R24087 n_28_24_4 n_28_25_4 3341.439366245606
R24088 n_28_24_4 n_28_24_5 17.48993533502923
R24089 n_28_24_5 n_29_24_5 43.18502551859031
R24090 n_28_24_5 n_28_25_5 21003.33315925809
R24091 n_28_24_5 n_28_24_6 6.045903572602696
R24092 n_28_24_6 n_29_24_6 7.197504253098384
R24093 n_28_24_6 n_28_25_6 3500.5555265430157
R24094 n_28_24_6 n_28_24_7 8.20515484853222
R24095 n_28_24_7 n_29_24_7 12.338578719597269
R24096 n_28_24_7 n_28_25_7 6000.952331216617
R24097 n_28_24_7 n_28_24_8 6.045903572602677
R24098 n_28_24_8 n_29_24_8 12.338578719597269
R24099 n_28_24_8 n_28_25_8 6000.952331216617
R24100 n_28_24_8 n_28_24_9 6.045903572602677
R24101 n_28_24_9 n_29_24_9 12.338578719597269
R24102 n_28_24_9 n_28_25_9 6000.952331216617
R24103 n_28_24_9 n_28_24_10 6.045903572602677
R24104 n_28_24_10 n_29_24_10 12.338578719597269
R24105 n_28_24_10 n_28_25_10 6000.952331216617
R24106 n_28_24_10 n_28_24_11 6.045903572602638
R24107 n_28_24_11 n_29_24_11 12.338578719597425
R24108 n_28_24_11 n_28_25_11 6000.952331216693
R24109 n_28_24_11 n_28_24_12 6.045903572602619
R24110 n_28_24_12 n_29_24_12 12.338578719597349
R24111 n_28_24_12 n_28_25_12 6000.952331216655
R24112 n_28_24_12 n_28_24_13 6.045903572602677
R24113 n_28_24_13 n_29_24_13 12.33857871959719
R24114 n_28_24_13 n_28_25_13 6000.952331216578
R24115 n_28_24_13 n_28_24_14 30.229517863013463
R24116 n_28_24_14 n_29_24_14 1.3709531910663602
R24117 n_28_24_14 n_28_25_14 666.7724812462893
R24118 n_28_24_14 n_28_24_15 934.0921019671247
R24119 n_28_24_15 n_29_24_15 453.4427679451942
R24120 n_28_24_15 n_28_25_15 220534.99817220803
R24121 n_28_25_0 n_29_25_0 6.477753827788574
R24122 n_28_25_0 n_28_26_0 3150.499973888717
R24123 n_28_25_0 n_28_25_1 748.1805671095855
R24124 n_28_25_1 n_29_25_1 9.068855358904003
R24125 n_28_25_1 n_28_26_1 4410.699963444204
R24126 n_28_25_1 n_28_25_2 1700.4103797945122
R24127 n_28_25_2 n_29_25_2 16.19438456947143
R24128 n_28_25_2 n_28_26_2 7876.249934721793
R24129 n_28_25_2 n_28_25_3 1591.5841154876634
R24130 n_28_25_3 n_29_25_3 226.72138397259985
R24131 n_28_25_3 n_28_26_3 110267.49908610499
R24132 n_28_25_3 n_28_25_4 21.160662504109506
R24133 n_28_25_4 n_29_25_4 6.870344968866663
R24134 n_28_25_4 n_28_26_4 3341.439366245606
R24135 n_28_25_4 n_28_25_5 17.489935335029287
R24136 n_28_25_5 n_29_25_5 43.18502551859045
R24137 n_28_25_5 n_28_26_5 21003.33315925809
R24138 n_28_25_5 n_28_25_6 6.0459035726027155
R24139 n_28_25_6 n_29_25_6 7.197504253098408
R24140 n_28_25_6 n_28_26_6 3500.5555265430157
R24141 n_28_25_6 n_28_25_7 8.205154848532247
R24142 n_28_25_7 n_29_25_7 12.33857871959731
R24143 n_28_25_7 n_28_26_7 6000.952331216617
R24144 n_28_25_7 n_28_25_8 6.045903572602697
R24145 n_28_25_8 n_29_25_8 12.33857871959731
R24146 n_28_25_8 n_28_26_8 6000.952331216617
R24147 n_28_25_8 n_28_25_9 6.045903572602697
R24148 n_28_25_9 n_29_25_9 12.33857871959731
R24149 n_28_25_9 n_28_26_9 6000.952331216617
R24150 n_28_25_9 n_28_25_10 6.045903572602697
R24151 n_28_25_10 n_29_25_10 12.33857871959731
R24152 n_28_25_10 n_28_26_10 6000.952331216617
R24153 n_28_25_10 n_28_25_11 6.045903572602658
R24154 n_28_25_11 n_29_25_11 12.338578719597468
R24155 n_28_25_11 n_28_26_11 6000.952331216693
R24156 n_28_25_11 n_28_25_12 6.045903572602638
R24157 n_28_25_12 n_29_25_12 12.338578719597384
R24158 n_28_25_12 n_28_26_12 6000.952331216655
R24159 n_28_25_12 n_28_25_13 6.045903572602697
R24160 n_28_25_13 n_29_25_13 12.338578719597233
R24161 n_28_25_13 n_28_26_13 6000.952331216578
R24162 n_28_25_13 n_28_25_14 30.22951786301356
R24163 n_28_25_14 n_29_25_14 1.3709531910663646
R24164 n_28_25_14 n_28_26_14 666.7724812462893
R24165 n_28_25_14 n_28_25_15 934.0921019671276
R24166 n_28_25_15 n_29_25_15 453.44276794519567
R24167 n_28_25_15 n_28_26_15 220534.99817220803
R24168 n_28_26_0 n_29_26_0 6.477753827788552
R24169 n_28_26_0 n_28_27_0 3150.499973888722
R24170 n_28_26_0 n_28_26_1 748.1805671095831
R24171 n_28_26_1 n_29_26_1 9.068855358903972
R24172 n_28_26_1 n_28_27_1 4410.699963444211
R24173 n_28_26_1 n_28_26_2 1700.410379794507
R24174 n_28_26_2 n_29_26_2 16.19438456947138
R24175 n_28_26_2 n_28_27_2 7876.249934721805
R24176 n_28_26_2 n_28_26_3 1591.5841154876584
R24177 n_28_26_3 n_29_26_3 226.72138397259914
R24178 n_28_26_3 n_28_27_3 110267.49908610516
R24179 n_28_26_3 n_28_26_4 21.16066250410944
R24180 n_28_26_4 n_29_26_4 6.87034496886664
R24181 n_28_26_4 n_28_27_4 3341.4393662456114
R24182 n_28_26_4 n_28_26_5 17.48993533502923
R24183 n_28_26_5 n_29_26_5 43.18502551859031
R24184 n_28_26_5 n_28_27_5 21003.333159258123
R24185 n_28_26_5 n_28_26_6 6.045903572602696
R24186 n_28_26_6 n_29_26_6 7.197504253098384
R24187 n_28_26_6 n_28_27_6 3500.555526543021
R24188 n_28_26_6 n_28_26_7 8.20515484853222
R24189 n_28_26_7 n_29_26_7 12.338578719597269
R24190 n_28_26_7 n_28_27_7 6000.952331216627
R24191 n_28_26_7 n_28_26_8 6.045903572602677
R24192 n_28_26_8 n_29_26_8 12.338578719597269
R24193 n_28_26_8 n_28_27_8 6000.952331216627
R24194 n_28_26_8 n_28_26_9 6.045903572602677
R24195 n_28_26_9 n_29_26_9 12.338578719597269
R24196 n_28_26_9 n_28_27_9 6000.952331216627
R24197 n_28_26_9 n_28_26_10 6.045903572602677
R24198 n_28_26_10 n_29_26_10 12.338578719597269
R24199 n_28_26_10 n_28_27_10 6000.952331216627
R24200 n_28_26_10 n_28_26_11 6.045903572602638
R24201 n_28_26_11 n_29_26_11 12.338578719597425
R24202 n_28_26_11 n_28_27_11 6000.952331216702
R24203 n_28_26_11 n_28_26_12 6.045903572602619
R24204 n_28_26_12 n_29_26_12 12.338578719597349
R24205 n_28_26_12 n_28_27_12 6000.952331216665
R24206 n_28_26_12 n_28_26_13 6.045903572602677
R24207 n_28_26_13 n_29_26_13 12.33857871959719
R24208 n_28_26_13 n_28_27_13 6000.952331216588
R24209 n_28_26_13 n_28_26_14 30.229517863013463
R24210 n_28_26_14 n_29_26_14 1.3709531910663602
R24211 n_28_26_14 n_28_27_14 666.7724812462903
R24212 n_28_26_14 n_28_26_15 934.0921019671247
R24213 n_28_26_15 n_29_26_15 453.4427679451942
R24214 n_28_26_15 n_28_27_15 220534.99817220838
R24215 n_28_27_0 n_29_27_0 6.477753827788552
R24216 n_28_27_0 n_28_27_1 748.1805671095831
R24217 n_28_27_1 n_29_27_1 9.068855358903972
R24218 n_28_27_1 n_28_27_2 1700.410379794507
R24219 n_28_27_2 n_29_27_2 16.19438456947138
R24220 n_28_27_2 n_28_27_3 1591.5841154876584
R24221 n_28_27_3 n_29_27_3 226.72138397259914
R24222 n_28_27_3 n_28_27_4 21.16066250410944
R24223 n_28_27_4 n_29_27_4 6.87034496886664
R24224 n_28_27_4 n_28_27_5 17.48993533502923
R24225 n_28_27_5 n_29_27_5 43.18502551859031
R24226 n_28_27_5 n_28_27_6 6.045903572602696
R24227 n_28_27_6 n_29_27_6 7.197504253098384
R24228 n_28_27_6 n_28_27_7 8.20515484853222
R24229 n_28_27_7 n_29_27_7 12.338578719597269
R24230 n_28_27_7 n_28_27_8 6.045903572602677
R24231 n_28_27_8 n_29_27_8 12.338578719597269
R24232 n_28_27_8 n_28_27_9 6.045903572602677
R24233 n_28_27_9 n_29_27_9 12.338578719597269
R24234 n_28_27_9 n_28_27_10 6.045903572602677
R24235 n_28_27_10 n_29_27_10 12.338578719597269
R24236 n_28_27_10 n_28_27_11 6.045903572602638
R24237 n_28_27_11 n_29_27_11 12.338578719597425
R24238 n_28_27_11 n_28_27_12 6.045903572602619
R24239 n_28_27_12 n_29_27_12 12.338578719597349
R24240 n_28_27_12 n_28_27_13 6.045903572602677
R24241 n_28_27_13 n_29_27_13 12.33857871959719
R24242 n_28_27_13 n_28_27_14 30.229517863013463
R24243 n_28_27_14 n_29_27_14 1.3709531910663602
R24244 n_28_27_14 n_28_27_15 934.0921019671247
R24245 n_28_27_15 n_29_27_15 453.4427679451942
R24246 n_29_0_0 n_30_0_0 6.4777532699254365
R24247 n_29_0_0 n_29_1_0 3150.50024520952
R24248 n_29_0_0 n_29_0_1 748.1805026764463
R24249 n_29_0_1 n_30_0_1 9.06885457789561
R24250 n_29_0_1 n_29_1_1 4410.700343293327
R24251 n_29_0_1 n_29_0_2 1700.4102333555597
R24252 n_29_0_2 n_30_0_2 16.19438317481359
R24253 n_29_0_2 n_29_1_2 7876.2506130238
R24254 n_29_0_2 n_29_0_3 1591.5839784208038
R24255 n_29_0_3 n_30_0_3 226.72136444739002
R24256 n_29_0_3 n_29_1_3 110267.50858233309
R24257 n_29_0_3 n_29_0_4 21.160660681758092
R24258 n_29_0_4 n_30_0_4 6.870344377193637
R24259 n_29_0_4 n_29_1_4 3341.4396540100934
R24260 n_29_0_4 n_29_0_5 17.489933828800055
R24261 n_29_0_5 n_30_0_5 43.18502179950286
R24262 n_29_0_5 n_29_1_5 21003.334968063442
R24263 n_29_0_5 n_29_0_6 6.0459030519308845
R24264 n_29_0_6 n_30_0_6 7.197503633250478
R24265 n_29_0_6 n_29_1_6 3500.555828010574
R24266 n_29_0_6 n_29_0_7 8.205154141906192
R24267 n_29_0_7 n_30_0_7 12.338577657000856
R24268 n_29_0_7 n_29_1_7 6000.952848018146
R24269 n_29_0_7 n_29_0_8 6.045903051930866
R24270 n_29_0_8 n_30_0_8 12.338577657000856
R24271 n_29_0_8 n_29_1_8 6000.952848018146
R24272 n_29_0_8 n_29_0_9 6.045903051930866
R24273 n_29_0_9 n_30_0_9 12.338577657000856
R24274 n_29_0_9 n_29_1_9 6000.952848018146
R24275 n_29_0_9 n_29_0_10 6.045903051930866
R24276 n_29_0_10 n_30_0_10 12.338577657000856
R24277 n_29_0_10 n_29_1_10 6000.952848018146
R24278 n_29_0_10 n_29_0_11 6.045903051930827
R24279 n_29_0_11 n_30_0_11 12.338577657001014
R24280 n_29_0_11 n_29_1_11 6000.9528480182225
R24281 n_29_0_11 n_29_0_12 6.045903051930807
R24282 n_29_0_12 n_30_0_12 12.33857765700094
R24283 n_29_0_12 n_29_1_12 6000.952848018184
R24284 n_29_0_12 n_29_0_13 6.045903051930866
R24285 n_29_0_13 n_30_0_13 12.33857765700078
R24286 n_29_0_13 n_29_1_13 6000.952848018108
R24287 n_29_0_13 n_29_0_14 30.229515259654406
R24288 n_29_0_14 n_30_0_14 1.3709530730000923
R24289 n_29_0_14 n_29_1_14 666.7725386686815
R24290 n_29_0_14 n_29_0_15 934.0920215233298
R24291 n_29_0_15 n_30_0_15 453.44272889477605
R24292 n_29_0_15 n_29_1_15 220535.01716466417
R24293 n_29_1_0 n_30_1_0 6.4777532699254365
R24294 n_29_1_0 n_29_2_0 3150.50024520952
R24295 n_29_1_0 n_29_1_1 748.1805026764463
R24296 n_29_1_1 n_30_1_1 9.06885457789561
R24297 n_29_1_1 n_29_2_1 4410.700343293327
R24298 n_29_1_1 n_29_1_2 1700.4102333555597
R24299 n_29_1_2 n_30_1_2 16.19438317481359
R24300 n_29_1_2 n_29_2_2 7876.2506130238
R24301 n_29_1_2 n_29_1_3 1591.5839784208038
R24302 n_29_1_3 n_30_1_3 226.72136444739002
R24303 n_29_1_3 n_29_2_3 110267.50858233309
R24304 n_29_1_3 n_29_1_4 21.160660681758092
R24305 n_29_1_4 n_30_1_4 6.870344377193637
R24306 n_29_1_4 n_29_2_4 3341.4396540100934
R24307 n_29_1_4 n_29_1_5 17.489933828800055
R24308 n_29_1_5 n_30_1_5 43.18502179950286
R24309 n_29_1_5 n_29_2_5 21003.334968063442
R24310 n_29_1_5 n_29_1_6 6.0459030519308845
R24311 n_29_1_6 n_30_1_6 7.197503633250478
R24312 n_29_1_6 n_29_2_6 3500.555828010574
R24313 n_29_1_6 n_29_1_7 8.205154141906192
R24314 n_29_1_7 n_30_1_7 12.338577657000856
R24315 n_29_1_7 n_29_2_7 6000.952848018146
R24316 n_29_1_7 n_29_1_8 6.045903051930866
R24317 n_29_1_8 n_30_1_8 12.338577657000856
R24318 n_29_1_8 n_29_2_8 6000.952848018146
R24319 n_29_1_8 n_29_1_9 6.045903051930866
R24320 n_29_1_9 n_30_1_9 12.338577657000856
R24321 n_29_1_9 n_29_2_9 6000.952848018146
R24322 n_29_1_9 n_29_1_10 6.045903051930866
R24323 n_29_1_10 n_30_1_10 12.338577657000856
R24324 n_29_1_10 n_29_2_10 6000.952848018146
R24325 n_29_1_10 n_29_1_11 6.045903051930827
R24326 n_29_1_11 n_30_1_11 12.338577657001014
R24327 n_29_1_11 n_29_2_11 6000.9528480182225
R24328 n_29_1_11 n_29_1_12 6.045903051930807
R24329 n_29_1_12 n_30_1_12 12.33857765700094
R24330 n_29_1_12 n_29_2_12 6000.952848018184
R24331 n_29_1_12 n_29_1_13 6.045903051930866
R24332 n_29_1_13 n_30_1_13 12.33857765700078
R24333 n_29_1_13 n_29_2_13 6000.952848018108
R24334 n_29_1_13 n_29_1_14 30.229515259654406
R24335 n_29_1_14 n_30_1_14 1.3709530730000923
R24336 n_29_1_14 n_29_2_14 666.7725386686815
R24337 n_29_1_14 n_29_1_15 934.0920215233298
R24338 n_29_1_15 n_30_1_15 453.44272889477605
R24339 n_29_1_15 n_29_2_15 220535.01716466417
R24340 n_29_2_0 n_30_2_0 6.4777532699254365
R24341 n_29_2_0 n_29_3_0 3150.50024520952
R24342 n_29_2_0 n_29_2_1 748.1805026764463
R24343 n_29_2_1 n_30_2_1 9.06885457789561
R24344 n_29_2_1 n_29_3_1 4410.700343293327
R24345 n_29_2_1 n_29_2_2 1700.4102333555597
R24346 n_29_2_2 n_30_2_2 16.19438317481359
R24347 n_29_2_2 n_29_3_2 7876.2506130238
R24348 n_29_2_2 n_29_2_3 1591.5839784208038
R24349 n_29_2_3 n_30_2_3 226.72136444739002
R24350 n_29_2_3 n_29_3_3 110267.50858233309
R24351 n_29_2_3 n_29_2_4 21.160660681758092
R24352 n_29_2_4 n_30_2_4 6.870344377193637
R24353 n_29_2_4 n_29_3_4 3341.4396540100934
R24354 n_29_2_4 n_29_2_5 17.489933828800055
R24355 n_29_2_5 n_30_2_5 43.18502179950286
R24356 n_29_2_5 n_29_3_5 21003.334968063442
R24357 n_29_2_5 n_29_2_6 6.0459030519308845
R24358 n_29_2_6 n_30_2_6 7.197503633250478
R24359 n_29_2_6 n_29_3_6 3500.555828010574
R24360 n_29_2_6 n_29_2_7 8.205154141906192
R24361 n_29_2_7 n_30_2_7 12.338577657000856
R24362 n_29_2_7 n_29_3_7 6000.952848018146
R24363 n_29_2_7 n_29_2_8 6.045903051930866
R24364 n_29_2_8 n_30_2_8 12.338577657000856
R24365 n_29_2_8 n_29_3_8 6000.952848018146
R24366 n_29_2_8 n_29_2_9 6.045903051930866
R24367 n_29_2_9 n_30_2_9 12.338577657000856
R24368 n_29_2_9 n_29_3_9 6000.952848018146
R24369 n_29_2_9 n_29_2_10 6.045903051930866
R24370 n_29_2_10 n_30_2_10 12.338577657000856
R24371 n_29_2_10 n_29_3_10 6000.952848018146
R24372 n_29_2_10 n_29_2_11 6.045903051930827
R24373 n_29_2_11 n_30_2_11 12.338577657001014
R24374 n_29_2_11 n_29_3_11 6000.9528480182225
R24375 n_29_2_11 n_29_2_12 6.045903051930807
R24376 n_29_2_12 n_30_2_12 12.33857765700094
R24377 n_29_2_12 n_29_3_12 6000.952848018184
R24378 n_29_2_12 n_29_2_13 6.045903051930866
R24379 n_29_2_13 n_30_2_13 12.33857765700078
R24380 n_29_2_13 n_29_3_13 6000.952848018108
R24381 n_29_2_13 n_29_2_14 30.229515259654406
R24382 n_29_2_14 n_30_2_14 1.3709530730000923
R24383 n_29_2_14 n_29_3_14 666.7725386686815
R24384 n_29_2_14 n_29_2_15 934.0920215233298
R24385 n_29_2_15 n_30_2_15 453.44272889477605
R24386 n_29_2_15 n_29_3_15 220535.01716466417
R24387 n_29_3_0 n_30_3_0 6.4777532699254365
R24388 n_29_3_0 n_29_4_0 1646.6785714286648
R24389 n_29_3_0 n_29_3_1 748.1805026764463
R24390 n_29_3_1 n_30_3_1 9.06885457789561
R24391 n_29_3_1 n_29_4_1 2305.35000000013
R24392 n_29_3_1 n_29_3_2 1700.4102333555597
R24393 n_29_3_2 n_30_3_2 16.19438317481359
R24394 n_29_3_2 n_29_4_2 4116.696428571661
R24395 n_29_3_2 n_29_3_3 1591.5839784208038
R24396 n_29_3_3 n_30_3_3 226.72136444739002
R24397 n_29_3_3 n_29_4_3 57633.75000000321
R24398 n_29_3_3 n_29_3_4 21.160660681758092
R24399 n_29_3_4 n_30_3_4 6.870344377193637
R24400 n_29_3_4 n_29_4_4 1746.4772727273698
R24401 n_29_3_4 n_29_3_5 17.489933828800055
R24402 n_29_3_5 n_30_3_5 43.18502179950286
R24403 n_29_3_5 n_29_3_6 6.0459030519308845
R24404 n_29_3_6 n_30_3_6 7.197503633250478
R24405 n_29_3_6 n_29_3_7 8.205154141906192
R24406 n_29_3_7 n_30_3_7 12.338577657000856
R24407 n_29_3_7 n_29_3_8 6.045903051930866
R24408 n_29_3_8 n_30_3_8 12.338577657000856
R24409 n_29_3_8 n_29_3_9 6.045903051930866
R24410 n_29_3_9 n_30_3_9 12.338577657000856
R24411 n_29_3_9 n_29_3_10 6.045903051930866
R24412 n_29_3_10 n_30_3_10 12.338577657000856
R24413 n_29_3_10 n_29_3_11 6.045903051930827
R24414 n_29_3_11 n_30_3_11 12.338577657001014
R24415 n_29_3_11 n_29_3_12 6.045903051930807
R24416 n_29_3_12 n_30_3_12 12.33857765700094
R24417 n_29_3_12 n_29_3_13 6.045903051930866
R24418 n_29_3_13 n_30_3_13 12.33857765700078
R24419 n_29_3_13 n_29_3_14 30.229515259654406
R24420 n_29_3_14 n_30_3_14 1.3709530730000923
R24421 n_29_3_14 n_29_3_15 934.0920215233298
R24422 n_29_3_15 n_30_3_15 453.44272889477605
R24423 n_29_3_15 n_29_4_15 115267.50000000537
R24424 n_29_4_0 n_30_4_0 142.8573880669023
R24425 n_29_4_0 n_29_5_0 142.85689764781068
R24426 n_29_4_0 n_29_4_1 16500.028321728507
R24427 n_29_4_1 n_30_4_1 200.0003432936632
R24428 n_29_4_1 n_29_5_1 199.9996567069349
R24429 n_29_4_1 n_29_4_2 37500.06436756479
R24430 n_29_4_2 n_30_4_2 357.1434701672558
R24431 n_29_4_2 n_29_5_2 357.1422441195267
R24432 n_29_4_2 n_29_4_3 35100.060248040645
R24433 n_29_4_3 n_30_4_3 5000.0085823415775
R24434 n_29_4_3 n_29_5_3 4999.991417673369
R24435 n_29_4_3 n_29_4_4 466.6674676852512
R24436 n_29_4_4 n_30_4_4 151.51541158610837
R24437 n_29_4_4 n_29_5_4 151.51489144464753
R24438 n_29_4_15 n_30_4_15 10000.017164683064
R24439 n_29_4_15 n_29_5_15 9999.982835346647
R24440 n_29_5_0 n_30_5_0 142.8573880668998
R24441 n_29_5_0 n_29_6_0 142.85689764781196
R24442 n_29_5_0 n_29_5_1 16500.028321728212
R24443 n_29_5_1 n_30_5_1 200.00034329365968
R24444 n_29_5_1 n_29_6_1 199.9996567069367
R24445 n_29_5_1 n_29_5_2 37500.06436756412
R24446 n_29_5_2 n_30_5_2 357.14347016724946
R24447 n_29_5_2 n_29_6_2 357.1422441195299
R24448 n_29_5_2 n_29_5_3 35100.06024804002
R24449 n_29_5_3 n_30_5_3 5000.008582341488
R24450 n_29_5_3 n_29_6_3 4999.991417673414
R24451 n_29_5_3 n_29_5_4 466.66746768524274
R24452 n_29_5_4 n_30_5_4 151.5154115861057
R24453 n_29_5_4 n_29_6_4 151.51489144464887
R24454 n_29_5_15 n_30_5_15 10000.017164682886
R24455 n_29_5_15 n_29_6_15 9999.982835346736
R24456 n_29_6_0 n_30_6_0 142.8573880668998
R24457 n_29_6_0 n_29_7_0 142.85689764781068
R24458 n_29_6_0 n_29_6_1 16500.028321728212
R24459 n_29_6_1 n_30_6_1 200.00034329365968
R24460 n_29_6_1 n_29_7_1 199.9996567069349
R24461 n_29_6_1 n_29_6_2 37500.06436756412
R24462 n_29_6_2 n_30_6_2 357.14347016724946
R24463 n_29_6_2 n_29_7_2 357.1422441195267
R24464 n_29_6_2 n_29_6_3 35100.06024804002
R24465 n_29_6_3 n_30_6_3 5000.008582341488
R24466 n_29_6_3 n_29_7_3 4999.991417673369
R24467 n_29_6_3 n_29_6_4 466.66746768524274
R24468 n_29_6_4 n_30_6_4 151.5154115861057
R24469 n_29_6_4 n_29_7_4 151.51489144464753
R24470 n_29_6_15 n_30_6_15 10000.017164682886
R24471 n_29_6_15 n_29_7_15 9999.982835346647
R24472 n_29_7_0 n_30_7_0 142.8573880669023
R24473 n_29_7_0 n_29_8_0 4174.885948824138
R24474 n_29_7_0 n_29_7_1 16500.028321728507
R24475 n_29_7_1 n_30_7_1 200.0003432936632
R24476 n_29_7_1 n_29_8_1 5844.840328353792
R24477 n_29_7_1 n_29_7_2 37500.06436756479
R24478 n_29_7_2 n_30_7_2 357.1434701672558
R24479 n_29_7_2 n_29_8_2 10437.214872060345
R24480 n_29_7_2 n_29_7_3 35100.060248040645
R24481 n_29_7_3 n_30_7_3 5000.0085823415775
R24482 n_29_7_3 n_29_8_3 146121.00820884467
R24483 n_29_7_3 n_29_7_4 466.6674676852512
R24484 n_29_7_4 n_30_7_4 151.51541158610837
R24485 n_29_7_4 n_29_8_4 4427.909339661959
R24486 n_29_7_15 n_30_7_15 10000.017164683064
R24487 n_29_7_15 n_29_8_15 292242.01641768677
R24488 n_29_8_0 n_30_8_0 2.486703379443518
R24489 n_29_8_0 n_29_9_0 8206.91500000047
R24490 n_29_8_0 n_29_8_1 287.21424032574873
R24491 n_29_8_1 n_30_8_1 3.481384731220924
R24492 n_29_8_1 n_29_9_1 11489.681000000654
R24493 n_29_8_1 n_29_8_2 652.7596371039743
R24494 n_29_8_2 n_30_8_2 6.216758448608793
R24495 n_29_8_2 n_29_9_2 20517.287500001174
R24496 n_29_8_2 n_29_8_3 610.98302032932
R24497 n_29_8_3 n_30_8_3 87.03461828052303
R24498 n_29_8_3 n_29_9_3 287242.0250000161
R24499 n_29_8_3 n_29_8_4 8.123231039516131
R24500 n_29_8_4 n_30_8_4 2.637412675167365
R24501 n_29_8_4 n_29_9_4 8704.303787879275
R24502 n_29_8_15 n_30_8_15 174.06923656104453
R24503 n_29_8_15 n_29_9_15 574484.050000027
R24504 n_29_9_0 n_30_9_0 2.4867033794435156
R24505 n_29_9_0 n_29_10_0 8206.91500000047
R24506 n_29_9_0 n_29_9_1 287.21424032574845
R24507 n_29_9_1 n_30_9_1 3.4813847312209223
R24508 n_29_9_1 n_29_10_1 11489.681000000654
R24509 n_29_9_1 n_29_9_2 652.7596371039738
R24510 n_29_9_2 n_30_9_2 6.21675844860879
R24511 n_29_9_2 n_29_10_2 20517.287500001174
R24512 n_29_9_2 n_29_9_3 610.9830203293194
R24513 n_29_9_3 n_30_9_3 87.03461828052298
R24514 n_29_9_3 n_29_10_3 287242.0250000161
R24515 n_29_9_3 n_29_9_4 8.123231039516126
R24516 n_29_9_4 n_30_9_4 2.637412675167363
R24517 n_29_9_4 n_29_10_4 8704.303787879275
R24518 n_29_9_15 n_30_9_15 174.06923656104442
R24519 n_29_9_15 n_29_10_15 574484.050000027
R24520 n_29_10_0 n_30_10_0 2.486703379443518
R24521 n_29_10_0 n_29_11_0 8206.915000000467
R24522 n_29_10_0 n_29_10_1 287.21424032574873
R24523 n_29_10_1 n_30_10_1 3.481384731220924
R24524 n_29_10_1 n_29_11_1 11489.68100000065
R24525 n_29_10_1 n_29_10_2 652.7596371039743
R24526 n_29_10_2 n_30_10_2 6.216758448608793
R24527 n_29_10_2 n_29_11_2 20517.287500001166
R24528 n_29_10_2 n_29_10_3 610.98302032932
R24529 n_29_10_3 n_30_10_3 87.03461828052303
R24530 n_29_10_3 n_29_11_3 287242.02500001603
R24531 n_29_10_3 n_29_10_4 8.123231039516131
R24532 n_29_10_4 n_30_10_4 2.637412675167365
R24533 n_29_10_4 n_29_11_4 8704.303787879273
R24534 n_29_10_15 n_30_10_15 174.06923656104453
R24535 n_29_10_15 n_29_11_15 574484.0500000269
R24536 n_29_11_0 n_30_11_0 2.486703379443518
R24537 n_29_11_0 n_29_12_0 4174.886071428809
R24538 n_29_11_0 n_29_11_1 287.21424032574873
R24539 n_29_11_1 n_30_11_1 3.481384731220924
R24540 n_29_11_1 n_29_12_1 5844.840500000332
R24541 n_29_11_1 n_29_11_2 652.7596371039743
R24542 n_29_11_2 n_30_11_2 6.216758448608793
R24543 n_29_11_2 n_29_12_2 10437.215178572025
R24544 n_29_11_2 n_29_11_3 610.98302032932
R24545 n_29_11_3 n_30_11_3 87.03461828052303
R24546 n_29_11_3 n_29_12_3 146121.0125000082
R24547 n_29_11_3 n_29_11_4 8.123231039516131
R24548 n_29_11_4 n_30_11_4 2.637412675167365
R24549 n_29_11_4 n_29_12_4 4427.909469697218
R24550 n_29_11_15 n_30_11_15 174.06923656104453
R24551 n_29_11_15 n_29_12_15 292242.02500001376
R24552 n_29_12_0 n_30_12_0 142.85714285713777
R24553 n_29_12_0 n_29_13_0 142.85714285715304
R24554 n_29_12_0 n_29_12_1 16500.000000000706
R24555 n_29_12_1 n_30_12_1 199.9999999999929
R24556 n_29_12_1 n_29_13_1 200.0000000000142
R24557 n_29_12_1 n_29_12_2 37500.0000000016
R24558 n_29_12_2 n_30_12_2 357.1428571428445
R24559 n_29_12_2 n_29_13_2 357.14285714288263
R24560 n_29_12_2 n_29_12_3 35100.0000000015
R24561 n_29_12_3 n_30_12_3 4999.999999999818
R24562 n_29_12_3 n_29_13_3 5000.000000000352
R24563 n_29_12_3 n_29_12_4 466.666666666687
R24564 n_29_12_4 n_30_12_4 151.51515151514602
R24565 n_29_12_4 n_29_13_4 151.51515151516216
R24566 n_29_12_15 n_30_12_15 9999.999999999549
R24567 n_29_12_15 n_29_13_15 10000.000000000613
R24568 n_29_13_0 n_30_13_0 142.85714285713777
R24569 n_29_13_0 n_29_14_0 142.85714285715304
R24570 n_29_13_0 n_29_13_1 16500.000000000706
R24571 n_29_13_1 n_30_13_1 199.9999999999929
R24572 n_29_13_1 n_29_14_1 200.0000000000142
R24573 n_29_13_1 n_29_13_2 37500.0000000016
R24574 n_29_13_2 n_30_13_2 357.1428571428445
R24575 n_29_13_2 n_29_14_2 357.14285714288263
R24576 n_29_13_2 n_29_13_3 35100.0000000015
R24577 n_29_13_3 n_30_13_3 4999.999999999818
R24578 n_29_13_3 n_29_14_3 5000.000000000352
R24579 n_29_13_3 n_29_13_4 466.666666666687
R24580 n_29_13_4 n_30_13_4 151.51515151514602
R24581 n_29_13_4 n_29_14_4 151.51515151516216
R24582 n_29_13_15 n_30_13_15 9999.999999999549
R24583 n_29_13_15 n_29_14_15 10000.000000000613
R24584 n_29_14_0 n_30_14_0 142.85714285713777
R24585 n_29_14_0 n_29_15_0 142.85714285715304
R24586 n_29_14_0 n_29_14_1 16500.000000000706
R24587 n_29_14_1 n_30_14_1 199.9999999999929
R24588 n_29_14_1 n_29_15_1 200.0000000000142
R24589 n_29_14_1 n_29_14_2 37500.0000000016
R24590 n_29_14_2 n_30_14_2 357.1428571428445
R24591 n_29_14_2 n_29_15_2 357.14285714288263
R24592 n_29_14_2 n_29_14_3 35100.0000000015
R24593 n_29_14_3 n_30_14_3 4999.999999999818
R24594 n_29_14_3 n_29_15_3 5000.000000000352
R24595 n_29_14_3 n_29_14_4 466.666666666687
R24596 n_29_14_4 n_30_14_4 151.51515151514602
R24597 n_29_14_4 n_29_15_4 151.51515151516216
R24598 n_29_14_15 n_30_14_15 9999.999999999549
R24599 n_29_14_15 n_29_15_15 10000.000000000613
R24600 n_29_15_0 n_30_15_0 142.85714285713777
R24601 n_29_15_0 n_29_16_0 4174.886071428808
R24602 n_29_15_0 n_29_15_1 16500.000000000706
R24603 n_29_15_1 n_30_15_1 199.9999999999929
R24604 n_29_15_1 n_29_16_1 5844.8405000003295
R24605 n_29_15_1 n_29_15_2 37500.0000000016
R24606 n_29_15_2 n_30_15_2 357.1428571428445
R24607 n_29_15_2 n_29_16_2 10437.21517857202
R24608 n_29_15_2 n_29_15_3 35100.0000000015
R24609 n_29_15_3 n_30_15_3 4999.999999999818
R24610 n_29_15_3 n_29_16_3 146121.0125000081
R24611 n_29_15_3 n_29_15_4 466.666666666687
R24612 n_29_15_4 n_30_15_4 151.51515151514602
R24613 n_29_15_4 n_29_16_4 4427.909469697215
R24614 n_29_15_15 n_30_15_15 9999.999999999549
R24615 n_29_15_15 n_29_16_15 292242.0250000136
R24616 n_29_16_0 n_30_16_0 2.4867033794435196
R24617 n_29_16_0 n_29_17_0 8206.915000000467
R24618 n_29_16_0 n_29_16_1 287.21424032574885
R24619 n_29_16_1 n_30_16_1 3.4813847312209263
R24620 n_29_16_1 n_29_17_1 11489.681000000652
R24621 n_29_16_1 n_29_16_2 652.7596371039747
R24622 n_29_16_2 n_30_16_2 6.216758448608798
R24623 n_29_16_2 n_29_17_2 20517.28750000117
R24624 n_29_16_2 n_29_16_3 610.9830203293203
R24625 n_29_16_3 n_30_16_3 87.03461828052308
R24626 n_29_16_3 n_29_17_3 287242.02500001603
R24627 n_29_16_3 n_29_16_4 8.123231039516137
R24628 n_29_16_4 n_30_16_4 2.637412675167366
R24629 n_29_16_4 n_29_17_4 8704.303787879273
R24630 n_29_16_15 n_30_16_15 174.06923656104462
R24631 n_29_16_15 n_29_17_15 574484.0500000269
R24632 n_29_17_0 n_30_17_0 2.4867033794435156
R24633 n_29_17_0 n_29_18_0 8206.915000000472
R24634 n_29_17_0 n_29_17_1 287.21424032574845
R24635 n_29_17_1 n_30_17_1 3.4813847312209223
R24636 n_29_17_1 n_29_18_1 11489.681000000657
R24637 n_29_17_1 n_29_17_2 652.7596371039738
R24638 n_29_17_2 n_30_17_2 6.21675844860879
R24639 n_29_17_2 n_29_18_2 20517.28750000118
R24640 n_29_17_2 n_29_17_3 610.9830203293194
R24641 n_29_17_3 n_30_17_3 87.03461828052298
R24642 n_29_17_3 n_29_18_3 287242.0250000162
R24643 n_29_17_3 n_29_17_4 8.123231039516126
R24644 n_29_17_4 n_30_17_4 2.637412675167363
R24645 n_29_17_4 n_29_18_4 8704.303787879278
R24646 n_29_17_15 n_30_17_15 174.06923656104442
R24647 n_29_17_15 n_29_18_15 574484.0500000273
R24648 n_29_18_0 n_30_18_0 2.4867033794435156
R24649 n_29_18_0 n_29_19_0 8206.915000000467
R24650 n_29_18_0 n_29_18_1 287.21424032574845
R24651 n_29_18_1 n_30_18_1 3.4813847312209223
R24652 n_29_18_1 n_29_19_1 11489.681000000652
R24653 n_29_18_1 n_29_18_2 652.7596371039738
R24654 n_29_18_2 n_30_18_2 6.21675844860879
R24655 n_29_18_2 n_29_19_2 20517.28750000117
R24656 n_29_18_2 n_29_18_3 610.9830203293194
R24657 n_29_18_3 n_30_18_3 87.03461828052298
R24658 n_29_18_3 n_29_19_3 287242.02500001603
R24659 n_29_18_3 n_29_18_4 8.123231039516126
R24660 n_29_18_4 n_30_18_4 2.637412675167363
R24661 n_29_18_4 n_29_19_4 8704.303787879273
R24662 n_29_18_15 n_30_18_15 174.06923656104442
R24663 n_29_18_15 n_29_19_15 574484.0500000269
R24664 n_29_19_0 n_30_19_0 2.4867033794435196
R24665 n_29_19_0 n_29_20_0 4174.886084484427
R24666 n_29_19_0 n_29_19_1 287.21424032574885
R24667 n_29_19_1 n_30_19_1 3.4813847312209263
R24668 n_29_19_1 n_29_20_1 5844.840518278195
R24669 n_29_19_1 n_29_19_2 652.7596371039747
R24670 n_29_19_2 n_30_19_2 6.216758448608798
R24671 n_29_19_2 n_29_20_2 10437.215211211065
R24672 n_29_19_2 n_29_19_3 610.9830203293203
R24673 n_29_19_3 n_30_19_3 87.03461828052308
R24674 n_29_19_3 n_29_20_3 146121.01295695477
R24675 n_29_19_3 n_29_19_4 8.123231039516137
R24676 n_29_19_4 n_30_19_4 2.637412675167366
R24677 n_29_19_4 n_29_20_4 4427.909483544083
R24678 n_29_19_15 n_30_19_15 174.06923656104462
R24679 n_29_19_15 n_29_20_15 292242.0259139069
R24680 n_29_20_0 n_30_20_0 142.85711674590496
R24681 n_29_20_0 n_29_21_0 142.85716896839065
R24682 n_29_20_0 n_29_20_1 16499.99698415331
R24683 n_29_20_1 n_30_20_1 199.9999634442669
R24684 n_29_20_1 n_29_21_1 200.00003655574685
R24685 n_29_20_1 n_29_20_2 37499.99314580298
R24686 n_29_20_2 n_30_20_2 357.14279186476244
R24687 n_29_20_2 n_29_21_2 357.1429224209766
R24688 n_29_20_2 n_29_20_3 35099.99358447159
R24689 n_29_20_3 n_30_20_3 4999.999086106669
R24690 n_29_20_3 n_29_21_3 5000.0009138936675
R24691 n_29_20_3 n_29_20_4 466.66658136999297
R24692 n_29_20_4 n_30_20_4 151.51512382141422
R24693 n_29_20_4 n_29_21_4 151.515179208899
R24694 n_29_20_15 n_30_20_15 9999.998172213247
R24695 n_29_20_15 n_29_21_15 10000.001827787244
R24696 n_29_21_0 n_30_21_0 142.85711674590496
R24697 n_29_21_0 n_29_22_0 142.85716896838557
R24698 n_29_21_0 n_29_21_1 16499.99698415331
R24699 n_29_21_1 n_30_21_1 199.9999634442669
R24700 n_29_21_1 n_29_22_1 200.00003655573977
R24701 n_29_21_1 n_29_21_2 37499.99314580298
R24702 n_29_21_2 n_30_21_2 357.14279186476244
R24703 n_29_21_2 n_29_22_2 357.14292242096394
R24704 n_29_21_2 n_29_21_3 35099.99358447159
R24705 n_29_21_3 n_30_21_3 4999.999086106669
R24706 n_29_21_3 n_29_22_3 5000.00091389349
R24707 n_29_21_3 n_29_21_4 466.66658136999297
R24708 n_29_21_4 n_30_21_4 151.51512382141422
R24709 n_29_21_4 n_29_22_4 151.51517920889364
R24710 n_29_21_15 n_30_21_15 9999.998172213247
R24711 n_29_21_15 n_29_22_15 10000.00182778689
R24712 n_29_22_0 n_30_22_0 142.8571167459151
R24713 n_29_22_0 n_29_23_0 142.85716896838557
R24714 n_29_22_0 n_29_22_1 16499.996984154484
R24715 n_29_22_1 n_30_22_1 199.99996344428115
R24716 n_29_22_1 n_29_23_1 200.00003655573977
R24717 n_29_22_1 n_29_22_2 37499.993145805645
R24718 n_29_22_2 n_30_22_2 357.1427918647878
R24719 n_29_22_2 n_29_23_2 357.14292242096394
R24720 n_29_22_2 n_29_22_3 35099.99358447408
R24721 n_29_22_3 n_30_22_3 4999.999086107024
R24722 n_29_22_3 n_29_23_3 5000.00091389349
R24723 n_29_22_3 n_29_22_4 466.66658137002617
R24724 n_29_22_4 n_30_22_4 151.51512382142496
R24725 n_29_22_4 n_29_23_4 151.51517920889364
R24726 n_29_22_15 n_30_22_15 9999.99817221396
R24727 n_29_22_15 n_29_23_15 10000.00182778689
R24728 n_29_23_0 n_30_23_0 142.85711674590496
R24729 n_29_23_0 n_29_24_0 1646.6785714286684
R24730 n_29_23_0 n_29_23_1 16499.99698415331
R24731 n_29_23_1 n_30_23_1 199.9999634442669
R24732 n_29_23_1 n_29_24_1 2305.3500000001354
R24733 n_29_23_1 n_29_23_2 37499.99314580298
R24734 n_29_23_2 n_30_23_2 357.14279186476244
R24735 n_29_23_2 n_29_24_2 4116.69642857167
R24736 n_29_23_2 n_29_23_3 35099.99358447159
R24737 n_29_23_3 n_30_23_3 4999.999086106669
R24738 n_29_23_3 n_29_24_3 57633.75000000334
R24739 n_29_23_3 n_29_23_4 466.66658136999297
R24740 n_29_23_4 n_30_23_4 151.51512382141422
R24741 n_29_23_4 n_29_24_4 1746.4772727273737
R24742 n_29_23_15 n_30_23_15 9999.998172213247
R24743 n_29_23_15 n_29_24_15 115267.50000000562
R24744 n_29_24_0 n_30_24_0 6.477753827788552
R24745 n_29_24_0 n_29_25_0 3150.499973888941
R24746 n_29_24_0 n_29_24_1 748.1805671096362
R24747 n_29_24_1 n_30_24_1 9.068855358903972
R24748 n_29_24_1 n_29_25_1 4410.6999634445165
R24749 n_29_24_1 n_29_24_2 1700.4103797946275
R24750 n_29_24_2 n_30_24_2 16.19438456947138
R24751 n_29_24_2 n_29_25_2 7876.249934722353
R24752 n_29_24_2 n_29_24_3 1591.5841154877714
R24753 n_29_24_3 n_30_24_3 226.72138397259914
R24754 n_29_24_3 n_29_25_3 110267.49908611283
R24755 n_29_24_3 n_29_24_4 21.160662504110938
R24756 n_29_24_4 n_30_24_4 6.87034496886664
R24757 n_29_24_4 n_29_25_4 3341.4393662458433
R24758 n_29_24_4 n_29_24_5 17.48993533503047
R24759 n_29_24_5 n_30_24_5 43.18502551859031
R24760 n_29_24_5 n_29_25_5 21003.333159259586
R24761 n_29_24_5 n_29_24_6 6.045903572603126
R24762 n_29_24_6 n_30_24_6 7.197504253098384
R24763 n_29_24_6 n_29_25_6 3500.555526543264
R24764 n_29_24_6 n_29_24_7 8.205154848532803
R24765 n_29_24_7 n_30_24_7 12.338578719597269
R24766 n_29_24_7 n_29_25_7 6000.952331217043
R24767 n_29_24_7 n_29_24_8 6.045903572603107
R24768 n_29_24_8 n_30_24_8 12.338578719597269
R24769 n_29_24_8 n_29_25_8 6000.952331217043
R24770 n_29_24_8 n_29_24_9 6.045903572603107
R24771 n_29_24_9 n_30_24_9 12.338578719597269
R24772 n_29_24_9 n_29_25_9 6000.952331217043
R24773 n_29_24_9 n_29_24_10 6.045903572603107
R24774 n_29_24_10 n_30_24_10 12.338578719597269
R24775 n_29_24_10 n_29_25_10 6000.952331217043
R24776 n_29_24_10 n_29_24_11 6.045903572603068
R24777 n_29_24_11 n_30_24_11 12.338578719597425
R24778 n_29_24_11 n_29_25_11 6000.95233121712
R24779 n_29_24_11 n_29_24_12 6.045903572603049
R24780 n_29_24_12 n_30_24_12 12.338578719597349
R24781 n_29_24_12 n_29_25_12 6000.952331217082
R24782 n_29_24_12 n_29_24_13 6.045903572603107
R24783 n_29_24_13 n_30_24_13 12.33857871959719
R24784 n_29_24_13 n_29_25_13 6000.952331217006
R24785 n_29_24_13 n_29_24_14 30.229517863015612
R24786 n_29_24_14 n_30_24_14 1.3709531910663602
R24787 n_29_24_14 n_29_25_14 666.7724812463368
R24788 n_29_24_14 n_29_24_15 934.092101967191
R24789 n_29_24_15 n_30_24_15 453.4427679451942
R24790 n_29_24_15 n_29_25_15 220534.99817222366
R24791 n_29_25_0 n_30_25_0 6.477753827788574
R24792 n_29_25_0 n_29_26_0 3150.499973888941
R24793 n_29_25_0 n_29_25_1 748.1805671096386
R24794 n_29_25_1 n_30_25_1 9.068855358904003
R24795 n_29_25_1 n_29_26_1 4410.6999634445165
R24796 n_29_25_1 n_29_25_2 1700.4103797946332
R24797 n_29_25_2 n_30_25_2 16.19438456947143
R24798 n_29_25_2 n_29_26_2 7876.249934722353
R24799 n_29_25_2 n_29_25_3 1591.5841154877767
R24800 n_29_25_3 n_30_25_3 226.72138397259985
R24801 n_29_25_3 n_29_26_3 110267.49908611283
R24802 n_29_25_3 n_29_25_4 21.16066250411101
R24803 n_29_25_4 n_30_25_4 6.870344968866663
R24804 n_29_25_4 n_29_26_4 3341.4393662458433
R24805 n_29_25_4 n_29_25_5 17.489935335030527
R24806 n_29_25_5 n_30_25_5 43.18502551859045
R24807 n_29_25_5 n_29_26_5 21003.333159259586
R24808 n_29_25_5 n_29_25_6 6.045903572603145
R24809 n_29_25_6 n_30_25_6 7.197504253098408
R24810 n_29_25_6 n_29_26_6 3500.555526543264
R24811 n_29_25_6 n_29_25_7 8.205154848532832
R24812 n_29_25_7 n_30_25_7 12.33857871959731
R24813 n_29_25_7 n_29_26_7 6000.952331217043
R24814 n_29_25_7 n_29_25_8 6.045903572603127
R24815 n_29_25_8 n_30_25_8 12.33857871959731
R24816 n_29_25_8 n_29_26_8 6000.952331217043
R24817 n_29_25_8 n_29_25_9 6.045903572603127
R24818 n_29_25_9 n_30_25_9 12.33857871959731
R24819 n_29_25_9 n_29_26_9 6000.952331217043
R24820 n_29_25_9 n_29_25_10 6.045903572603127
R24821 n_29_25_10 n_30_25_10 12.33857871959731
R24822 n_29_25_10 n_29_26_10 6000.952331217043
R24823 n_29_25_10 n_29_25_11 6.045903572603088
R24824 n_29_25_11 n_30_25_11 12.338578719597468
R24825 n_29_25_11 n_29_26_11 6000.95233121712
R24826 n_29_25_11 n_29_25_12 6.045903572603068
R24827 n_29_25_12 n_30_25_12 12.338578719597384
R24828 n_29_25_12 n_29_26_12 6000.952331217082
R24829 n_29_25_12 n_29_25_13 6.045903572603127
R24830 n_29_25_13 n_30_25_13 12.338578719597233
R24831 n_29_25_13 n_29_26_13 6000.952331217006
R24832 n_29_25_13 n_29_25_14 30.229517863015708
R24833 n_29_25_14 n_30_25_14 1.3709531910663646
R24834 n_29_25_14 n_29_26_14 666.7724812463368
R24835 n_29_25_14 n_29_25_15 934.092101967194
R24836 n_29_25_15 n_30_25_15 453.44276794519567
R24837 n_29_25_15 n_29_26_15 220534.99817222366
R24838 n_29_26_0 n_30_26_0 6.477753827788552
R24839 n_29_26_0 n_29_27_0 3150.499973888946
R24840 n_29_26_0 n_29_26_1 748.1805671096362
R24841 n_29_26_1 n_30_26_1 9.068855358903972
R24842 n_29_26_1 n_29_27_1 4410.699963444524
R24843 n_29_26_1 n_29_26_2 1700.4103797946275
R24844 n_29_26_2 n_30_26_2 16.19438456947138
R24845 n_29_26_2 n_29_27_2 7876.249934722365
R24846 n_29_26_2 n_29_26_3 1591.5841154877714
R24847 n_29_26_3 n_30_26_3 226.72138397259914
R24848 n_29_26_3 n_29_27_3 110267.499086113
R24849 n_29_26_3 n_29_26_4 21.160662504110938
R24850 n_29_26_4 n_30_26_4 6.87034496886664
R24851 n_29_26_4 n_29_27_4 3341.4393662458483
R24852 n_29_26_4 n_29_26_5 17.48993533503047
R24853 n_29_26_5 n_30_26_5 43.18502551859031
R24854 n_29_26_5 n_29_27_5 21003.33315925962
R24855 n_29_26_5 n_29_26_6 6.045903572603126
R24856 n_29_26_6 n_30_26_6 7.197504253098384
R24857 n_29_26_6 n_29_27_6 3500.5555265432695
R24858 n_29_26_6 n_29_26_7 8.205154848532803
R24859 n_29_26_7 n_30_26_7 12.338578719597269
R24860 n_29_26_7 n_29_27_7 6000.952331217052
R24861 n_29_26_7 n_29_26_8 6.045903572603107
R24862 n_29_26_8 n_30_26_8 12.338578719597269
R24863 n_29_26_8 n_29_27_8 6000.952331217052
R24864 n_29_26_8 n_29_26_9 6.045903572603107
R24865 n_29_26_9 n_30_26_9 12.338578719597269
R24866 n_29_26_9 n_29_27_9 6000.952331217052
R24867 n_29_26_9 n_29_26_10 6.045903572603107
R24868 n_29_26_10 n_30_26_10 12.338578719597269
R24869 n_29_26_10 n_29_27_10 6000.952331217052
R24870 n_29_26_10 n_29_26_11 6.045903572603068
R24871 n_29_26_11 n_30_26_11 12.338578719597425
R24872 n_29_26_11 n_29_27_11 6000.9523312171295
R24873 n_29_26_11 n_29_26_12 6.045903572603049
R24874 n_29_26_12 n_30_26_12 12.338578719597349
R24875 n_29_26_12 n_29_27_12 6000.952331217091
R24876 n_29_26_12 n_29_26_13 6.045903572603107
R24877 n_29_26_13 n_30_26_13 12.33857871959719
R24878 n_29_26_13 n_29_27_13 6000.952331217015
R24879 n_29_26_13 n_29_26_14 30.229517863015612
R24880 n_29_26_14 n_30_26_14 1.3709531910663602
R24881 n_29_26_14 n_29_27_14 666.7724812463379
R24882 n_29_26_14 n_29_26_15 934.092101967191
R24883 n_29_26_15 n_30_26_15 453.4427679451942
R24884 n_29_26_15 n_29_27_15 220534.998172224
R24885 n_29_27_0 n_30_27_0 6.477753827788552
R24886 n_29_27_0 n_29_27_1 748.1805671096362
R24887 n_29_27_1 n_30_27_1 9.068855358903972
R24888 n_29_27_1 n_29_27_2 1700.4103797946275
R24889 n_29_27_2 n_30_27_2 16.19438456947138
R24890 n_29_27_2 n_29_27_3 1591.5841154877714
R24891 n_29_27_3 n_30_27_3 226.72138397259914
R24892 n_29_27_3 n_29_27_4 21.160662504110938
R24893 n_29_27_4 n_30_27_4 6.87034496886664
R24894 n_29_27_4 n_29_27_5 17.48993533503047
R24895 n_29_27_5 n_30_27_5 43.18502551859031
R24896 n_29_27_5 n_29_27_6 6.045903572603126
R24897 n_29_27_6 n_30_27_6 7.197504253098384
R24898 n_29_27_6 n_29_27_7 8.205154848532803
R24899 n_29_27_7 n_30_27_7 12.338578719597269
R24900 n_29_27_7 n_29_27_8 6.045903572603107
R24901 n_29_27_8 n_30_27_8 12.338578719597269
R24902 n_29_27_8 n_29_27_9 6.045903572603107
R24903 n_29_27_9 n_30_27_9 12.338578719597269
R24904 n_29_27_9 n_29_27_10 6.045903572603107
R24905 n_29_27_10 n_30_27_10 12.338578719597269
R24906 n_29_27_10 n_29_27_11 6.045903572603068
R24907 n_29_27_11 n_30_27_11 12.338578719597425
R24908 n_29_27_11 n_29_27_12 6.045903572603049
R24909 n_29_27_12 n_30_27_12 12.338578719597349
R24910 n_29_27_12 n_29_27_13 6.045903572603107
R24911 n_29_27_13 n_30_27_13 12.33857871959719
R24912 n_29_27_13 n_29_27_14 30.229517863015612
R24913 n_29_27_14 n_30_27_14 1.3709531910663602
R24914 n_29_27_14 n_29_27_15 934.092101967191
R24915 n_29_27_15 n_30_27_15 453.4427679451942
R24916 n_30_0_0 n_31_0_0 6.4777532699256675
R24917 n_30_0_0 n_30_1_0 3150.5002452092954
R24918 n_30_0_0 n_30_0_1 748.1805026763932
R24919 n_30_0_1 n_31_0_1 9.068854577895932
R24920 n_30_0_1 n_30_1_1 4410.700343293014
R24921 n_30_0_1 n_30_0_2 1700.4102333554388
R24922 n_30_0_2 n_31_0_2 16.194383174814167
R24923 n_30_0_2 n_30_1_2 7876.25061302324
R24924 n_30_0_2 n_30_0_3 1591.5839784206908
R24925 n_30_0_3 n_31_0_3 226.7213644473981
R24926 n_30_0_3 n_30_1_3 110267.50858232524
R24927 n_30_0_3 n_30_0_4 21.160660681756593
R24928 n_30_0_4 n_31_0_4 6.870344377193882
R24929 n_30_0_4 n_30_1_4 3341.4396540098564
R24930 n_30_0_4 n_30_0_5 17.489933828798815
R24931 n_30_0_5 n_31_0_5 43.1850217995044
R24932 n_30_0_5 n_30_1_5 21003.33496806195
R24933 n_30_0_5 n_30_0_6 6.045903051930455
R24934 n_30_0_6 n_31_0_6 7.197503633250734
R24935 n_30_0_6 n_30_1_6 3500.5558280103255
R24936 n_30_0_6 n_30_0_7 8.205154141905608
R24937 n_30_0_7 n_31_0_7 12.338577657001295
R24938 n_30_0_7 n_30_1_7 6000.95284801772
R24939 n_30_0_7 n_30_0_8 6.045903051930436
R24940 n_30_0_8 n_31_0_8 12.338577657001295
R24941 n_30_0_8 n_30_1_8 6000.95284801772
R24942 n_30_0_8 n_30_0_9 6.045903051930436
R24943 n_30_0_9 n_31_0_9 12.338577657001295
R24944 n_30_0_9 n_30_1_9 6000.95284801772
R24945 n_30_0_9 n_30_0_10 6.045903051930436
R24946 n_30_0_10 n_31_0_10 12.338577657001295
R24947 n_30_0_10 n_30_1_10 6000.95284801772
R24948 n_30_0_10 n_30_0_11 6.045903051930397
R24949 n_30_0_11 n_31_0_11 12.338577657001453
R24950 n_30_0_11 n_30_1_11 6000.952848017796
R24951 n_30_0_11 n_30_0_12 6.045903051930377
R24952 n_30_0_12 n_31_0_12 12.338577657001379
R24953 n_30_0_12 n_30_1_12 6000.952848017758
R24954 n_30_0_12 n_30_0_13 6.045903051930436
R24955 n_30_0_13 n_31_0_13 12.338577657001219
R24956 n_30_0_13 n_30_1_13 6000.952848017681
R24957 n_30_0_13 n_30_0_14 30.229515259652253
R24958 n_30_0_14 n_31_0_14 1.3709530730001411
R24959 n_30_0_14 n_30_1_14 666.7725386686341
R24960 n_30_0_14 n_30_0_15 934.0920215232634
R24961 n_30_0_15 n_31_0_15 453.4427288947922
R24962 n_30_0_15 n_30_1_15 220535.01716464857
R24963 n_30_1_0 n_31_1_0 6.4777532699256675
R24964 n_30_1_0 n_30_2_0 3150.5002452092954
R24965 n_30_1_0 n_30_1_1 748.1805026763932
R24966 n_30_1_1 n_31_1_1 9.068854577895932
R24967 n_30_1_1 n_30_2_1 4410.700343293014
R24968 n_30_1_1 n_30_1_2 1700.4102333554388
R24969 n_30_1_2 n_31_1_2 16.194383174814167
R24970 n_30_1_2 n_30_2_2 7876.25061302324
R24971 n_30_1_2 n_30_1_3 1591.5839784206908
R24972 n_30_1_3 n_31_1_3 226.7213644473981
R24973 n_30_1_3 n_30_2_3 110267.50858232524
R24974 n_30_1_3 n_30_1_4 21.160660681756593
R24975 n_30_1_4 n_31_1_4 6.870344377193882
R24976 n_30_1_4 n_30_2_4 3341.4396540098564
R24977 n_30_1_4 n_30_1_5 17.489933828798815
R24978 n_30_1_5 n_31_1_5 43.1850217995044
R24979 n_30_1_5 n_30_2_5 21003.33496806195
R24980 n_30_1_5 n_30_1_6 6.045903051930455
R24981 n_30_1_6 n_31_1_6 7.197503633250734
R24982 n_30_1_6 n_30_2_6 3500.5558280103255
R24983 n_30_1_6 n_30_1_7 8.205154141905608
R24984 n_30_1_7 n_31_1_7 12.338577657001295
R24985 n_30_1_7 n_30_2_7 6000.95284801772
R24986 n_30_1_7 n_30_1_8 6.045903051930436
R24987 n_30_1_8 n_31_1_8 12.338577657001295
R24988 n_30_1_8 n_30_2_8 6000.95284801772
R24989 n_30_1_8 n_30_1_9 6.045903051930436
R24990 n_30_1_9 n_31_1_9 12.338577657001295
R24991 n_30_1_9 n_30_2_9 6000.95284801772
R24992 n_30_1_9 n_30_1_10 6.045903051930436
R24993 n_30_1_10 n_31_1_10 12.338577657001295
R24994 n_30_1_10 n_30_2_10 6000.95284801772
R24995 n_30_1_10 n_30_1_11 6.045903051930397
R24996 n_30_1_11 n_31_1_11 12.338577657001453
R24997 n_30_1_11 n_30_2_11 6000.952848017796
R24998 n_30_1_11 n_30_1_12 6.045903051930377
R24999 n_30_1_12 n_31_1_12 12.338577657001379
R25000 n_30_1_12 n_30_2_12 6000.952848017758
R25001 n_30_1_12 n_30_1_13 6.045903051930436
R25002 n_30_1_13 n_31_1_13 12.338577657001219
R25003 n_30_1_13 n_30_2_13 6000.952848017681
R25004 n_30_1_13 n_30_1_14 30.229515259652253
R25005 n_30_1_14 n_31_1_14 1.3709530730001411
R25006 n_30_1_14 n_30_2_14 666.7725386686341
R25007 n_30_1_14 n_30_1_15 934.0920215232634
R25008 n_30_1_15 n_31_1_15 453.4427288947922
R25009 n_30_1_15 n_30_2_15 220535.01716464857
R25010 n_30_2_0 n_31_2_0 6.4777532699256675
R25011 n_30_2_0 n_30_3_0 3150.5002452092954
R25012 n_30_2_0 n_30_2_1 748.1805026763932
R25013 n_30_2_1 n_31_2_1 9.068854577895932
R25014 n_30_2_1 n_30_3_1 4410.700343293014
R25015 n_30_2_1 n_30_2_2 1700.4102333554388
R25016 n_30_2_2 n_31_2_2 16.194383174814167
R25017 n_30_2_2 n_30_3_2 7876.25061302324
R25018 n_30_2_2 n_30_2_3 1591.5839784206908
R25019 n_30_2_3 n_31_2_3 226.7213644473981
R25020 n_30_2_3 n_30_3_3 110267.50858232524
R25021 n_30_2_3 n_30_2_4 21.160660681756593
R25022 n_30_2_4 n_31_2_4 6.870344377193882
R25023 n_30_2_4 n_30_3_4 3341.4396540098564
R25024 n_30_2_4 n_30_2_5 17.489933828798815
R25025 n_30_2_5 n_31_2_5 43.1850217995044
R25026 n_30_2_5 n_30_3_5 21003.33496806195
R25027 n_30_2_5 n_30_2_6 6.045903051930455
R25028 n_30_2_6 n_31_2_6 7.197503633250734
R25029 n_30_2_6 n_30_3_6 3500.5558280103255
R25030 n_30_2_6 n_30_2_7 8.205154141905608
R25031 n_30_2_7 n_31_2_7 12.338577657001295
R25032 n_30_2_7 n_30_3_7 6000.95284801772
R25033 n_30_2_7 n_30_2_8 6.045903051930436
R25034 n_30_2_8 n_31_2_8 12.338577657001295
R25035 n_30_2_8 n_30_3_8 6000.95284801772
R25036 n_30_2_8 n_30_2_9 6.045903051930436
R25037 n_30_2_9 n_31_2_9 12.338577657001295
R25038 n_30_2_9 n_30_3_9 6000.95284801772
R25039 n_30_2_9 n_30_2_10 6.045903051930436
R25040 n_30_2_10 n_31_2_10 12.338577657001295
R25041 n_30_2_10 n_30_3_10 6000.95284801772
R25042 n_30_2_10 n_30_2_11 6.045903051930397
R25043 n_30_2_11 n_31_2_11 12.338577657001453
R25044 n_30_2_11 n_30_3_11 6000.952848017796
R25045 n_30_2_11 n_30_2_12 6.045903051930377
R25046 n_30_2_12 n_31_2_12 12.338577657001379
R25047 n_30_2_12 n_30_3_12 6000.952848017758
R25048 n_30_2_12 n_30_2_13 6.045903051930436
R25049 n_30_2_13 n_31_2_13 12.338577657001219
R25050 n_30_2_13 n_30_3_13 6000.952848017681
R25051 n_30_2_13 n_30_2_14 30.229515259652253
R25052 n_30_2_14 n_31_2_14 1.3709530730001411
R25053 n_30_2_14 n_30_3_14 666.7725386686341
R25054 n_30_2_14 n_30_2_15 934.0920215232634
R25055 n_30_2_15 n_31_2_15 453.4427288947922
R25056 n_30_2_15 n_30_3_15 220535.01716464857
R25057 n_30_3_0 n_31_3_0 6.4777532699256675
R25058 n_30_3_0 n_30_4_0 1646.6785714285472
R25059 n_30_3_0 n_30_3_1 748.1805026763932
R25060 n_30_3_1 n_31_3_1 9.068854577895932
R25061 n_30_3_1 n_30_4_1 2305.3499999999667
R25062 n_30_3_1 n_30_3_2 1700.4102333554388
R25063 n_30_3_2 n_31_3_2 16.194383174814167
R25064 n_30_3_2 n_30_4_2 4116.696428571369
R25065 n_30_3_2 n_30_3_3 1591.5839784206908
R25066 n_30_3_3 n_31_3_3 226.7213644473981
R25067 n_30_3_3 n_30_4_3 57633.749999999105
R25068 n_30_3_3 n_30_3_4 21.160660681756593
R25069 n_30_3_4 n_31_3_4 6.870344377193882
R25070 n_30_3_4 n_30_4_4 1746.477272727246
R25071 n_30_3_4 n_30_3_5 17.489933828798815
R25072 n_30_3_5 n_31_3_5 43.1850217995044
R25073 n_30_3_5 n_30_3_6 6.045903051930455
R25074 n_30_3_6 n_31_3_6 7.197503633250734
R25075 n_30_3_6 n_30_3_7 8.205154141905608
R25076 n_30_3_7 n_31_3_7 12.338577657001295
R25077 n_30_3_7 n_30_3_8 6.045903051930436
R25078 n_30_3_8 n_31_3_8 12.338577657001295
R25079 n_30_3_8 n_30_3_9 6.045903051930436
R25080 n_30_3_9 n_31_3_9 12.338577657001295
R25081 n_30_3_9 n_30_3_10 6.045903051930436
R25082 n_30_3_10 n_31_3_10 12.338577657001295
R25083 n_30_3_10 n_30_3_11 6.045903051930397
R25084 n_30_3_11 n_31_3_11 12.338577657001453
R25085 n_30_3_11 n_30_3_12 6.045903051930377
R25086 n_30_3_12 n_31_3_12 12.338577657001379
R25087 n_30_3_12 n_30_3_13 6.045903051930436
R25088 n_30_3_13 n_31_3_13 12.338577657001219
R25089 n_30_3_13 n_30_3_14 30.229515259652253
R25090 n_30_3_14 n_31_3_14 1.3709530730001411
R25091 n_30_3_14 n_30_3_15 934.0920215232634
R25092 n_30_3_15 n_31_3_15 453.4427288947922
R25093 n_30_3_15 n_30_4_15 115267.4999999972
R25094 n_30_4_0 n_31_4_0 142.8573880669074
R25095 n_30_4_0 n_30_5_0 142.8568976478005
R25096 n_30_4_0 n_30_4_1 16500.028321727335
R25097 n_30_4_1 n_31_4_1 200.00034329367034
R25098 n_30_4_1 n_30_5_1 199.99965670692075
R25099 n_30_4_1 n_30_4_2 37500.064367562125
R25100 n_30_4_2 n_31_4_2 357.1434701672685
R25101 n_30_4_2 n_30_5_2 357.14224411950136
R25102 n_30_4_2 n_30_4_3 35100.06024803815
R25103 n_30_4_3 n_31_4_3 5000.008582341755
R25104 n_30_4_3 n_30_5_3 4999.9914176730135
R25105 n_30_4_3 n_30_4_4 466.66746768521796
R25106 n_30_4_4 n_31_4_4 151.51541158611377
R25107 n_30_4_4 n_30_5_4 151.5148914446368
R25108 n_30_4_15 n_31_4_15 10000.01716468342
R25109 n_30_4_15 n_30_5_15 9999.982835345938
R25110 n_30_5_0 n_31_5_0 142.8573880669049
R25111 n_30_5_0 n_30_6_0 142.8568976478018
R25112 n_30_5_0 n_30_5_1 16500.02832172704
R25113 n_30_5_1 n_31_5_1 200.0003432936668
R25114 n_30_5_1 n_30_6_1 199.9996567069225
R25115 n_30_5_1 n_30_5_2 37500.06436756146
R25116 n_30_5_2 n_31_5_2 357.14347016726214
R25117 n_30_5_2 n_30_6_2 357.1422441195045
R25118 n_30_5_2 n_30_5_3 35100.06024803753
R25119 n_30_5_3 n_31_5_3 5000.008582341666
R25120 n_30_5_3 n_30_6_3 4999.991417673058
R25121 n_30_5_3 n_30_5_4 466.66746768520966
R25122 n_30_5_4 n_31_5_4 151.51541158611107
R25123 n_30_5_4 n_30_6_4 151.51489144463812
R25124 n_30_5_15 n_31_5_15 10000.017164683242
R25125 n_30_5_15 n_30_6_15 9999.982835346027
R25126 n_30_6_0 n_31_6_0 142.8573880669049
R25127 n_30_6_0 n_30_7_0 142.8568976478005
R25128 n_30_6_0 n_30_6_1 16500.02832172704
R25129 n_30_6_1 n_31_6_1 200.0003432936668
R25130 n_30_6_1 n_30_7_1 199.99965670692075
R25131 n_30_6_1 n_30_6_2 37500.06436756146
R25132 n_30_6_2 n_31_6_2 357.14347016726214
R25133 n_30_6_2 n_30_7_2 357.14224411950136
R25134 n_30_6_2 n_30_6_3 35100.06024803753
R25135 n_30_6_3 n_31_6_3 5000.008582341666
R25136 n_30_6_3 n_30_7_3 4999.9914176730135
R25137 n_30_6_3 n_30_6_4 466.66746768520966
R25138 n_30_6_4 n_31_6_4 151.51541158611107
R25139 n_30_6_4 n_30_7_4 151.5148914446368
R25140 n_30_6_15 n_31_6_15 10000.017164683242
R25141 n_30_6_15 n_30_7_15 9999.982835345938
R25142 n_30_7_0 n_31_7_0 142.8573880669074
R25143 n_30_7_0 n_30_8_0 4174.885948823841
R25144 n_30_7_0 n_30_7_1 16500.028321727335
R25145 n_30_7_1 n_31_7_1 200.00034329367034
R25146 n_30_7_1 n_30_8_1 5844.840328353377
R25147 n_30_7_1 n_30_7_2 37500.064367562125
R25148 n_30_7_2 n_31_7_2 357.1434701672685
R25149 n_30_7_2 n_30_8_2 10437.214872059603
R25150 n_30_7_2 n_30_7_3 35100.06024803815
R25151 n_30_7_3 n_31_7_3 5000.008582341755
R25152 n_30_7_3 n_30_8_3 146121.00820883428
R25153 n_30_7_3 n_30_7_4 466.66746768521796
R25154 n_30_7_4 n_31_7_4 151.51541158611377
R25155 n_30_7_4 n_30_8_4 4427.909339661646
R25156 n_30_7_15 n_31_7_15 10000.01716468342
R25157 n_30_7_15 n_30_8_15 292242.01641766605
R25158 n_30_8_0 n_31_8_0 2.486703379443606
R25159 n_30_8_0 n_30_9_0 8206.914999999884
R25160 n_30_8_0 n_30_8_1 287.21424032572827
R25161 n_30_8_1 n_31_8_1 3.481384731221048
R25162 n_30_8_1 n_30_9_1 11489.680999999839
R25163 n_30_8_1 n_30_8_2 652.759637103928
R25164 n_30_8_2 n_31_8_2 6.216758448609014
R25165 n_30_8_2 n_30_9_2 20517.287499999715
R25166 n_30_8_2 n_30_8_3 610.9830203292765
R25167 n_30_8_3 n_31_8_3 87.03461828052613
R25168 n_30_8_3 n_30_9_3 287242.0249999957
R25169 n_30_8_3 n_30_8_4 8.123231039515554
R25170 n_30_8_4 n_31_8_4 2.6374126751674587
R25171 n_30_8_4 n_30_9_4 8704.30378787866
R25172 n_30_8_15 n_31_8_15 174.0692365610507
R25173 n_30_8_15 n_30_9_15 574484.0499999863
R25174 n_30_9_0 n_31_9_0 2.486703379443604
R25175 n_30_9_0 n_30_10_0 8206.914999999884
R25176 n_30_9_0 n_30_9_1 287.2142403257281
R25177 n_30_9_1 n_31_9_1 3.481384731221046
R25178 n_30_9_1 n_30_10_1 11489.680999999839
R25179 n_30_9_1 n_30_9_2 652.7596371039276
R25180 n_30_9_2 n_31_9_2 6.216758448609011
R25181 n_30_9_2 n_30_10_2 20517.287499999715
R25182 n_30_9_2 n_30_9_3 610.9830203292762
R25183 n_30_9_3 n_31_9_3 87.03461828052608
R25184 n_30_9_3 n_30_10_3 287242.0249999957
R25185 n_30_9_3 n_30_9_4 8.123231039515549
R25186 n_30_9_4 n_31_9_4 2.637412675167457
R25187 n_30_9_4 n_30_10_4 8704.30378787866
R25188 n_30_9_15 n_31_9_15 174.06923656105062
R25189 n_30_9_15 n_30_10_15 574484.0499999863
R25190 n_30_10_0 n_31_10_0 2.486703379443606
R25191 n_30_10_0 n_30_11_0 8206.914999999883
R25192 n_30_10_0 n_30_10_1 287.21424032572827
R25193 n_30_10_1 n_31_10_1 3.481384731221048
R25194 n_30_10_1 n_30_11_1 11489.680999999835
R25195 n_30_10_1 n_30_10_2 652.759637103928
R25196 n_30_10_2 n_31_10_2 6.216758448609014
R25197 n_30_10_2 n_30_11_2 20517.287499999708
R25198 n_30_10_2 n_30_10_3 610.9830203292765
R25199 n_30_10_3 n_31_10_3 87.03461828052613
R25200 n_30_10_3 n_30_11_3 287242.0249999956
R25201 n_30_10_3 n_30_10_4 8.123231039515554
R25202 n_30_10_4 n_31_10_4 2.6374126751674587
R25203 n_30_10_4 n_30_11_4 8704.303787878656
R25204 n_30_10_15 n_31_10_15 174.0692365610507
R25205 n_30_10_15 n_30_11_15 574484.0499999862
R25206 n_30_11_0 n_31_11_0 2.486703379443606
R25207 n_30_11_0 n_30_12_0 4174.886071428513
R25208 n_30_11_0 n_30_11_1 287.21424032572827
R25209 n_30_11_1 n_31_11_1 3.481384731221048
R25210 n_30_11_1 n_30_12_1 5844.8404999999175
R25211 n_30_11_1 n_30_11_2 652.759637103928
R25212 n_30_11_2 n_31_11_2 6.216758448609014
R25213 n_30_11_2 n_30_12_2 10437.215178571283
R25214 n_30_11_2 n_30_11_3 610.9830203292765
R25215 n_30_11_3 n_31_11_3 87.03461828052613
R25216 n_30_11_3 n_30_12_3 146121.0124999978
R25217 n_30_11_3 n_30_11_4 8.123231039515554
R25218 n_30_11_4 n_31_11_4 2.6374126751674587
R25219 n_30_11_4 n_30_12_4 4427.909469696904
R25220 n_30_11_15 n_31_11_15 174.0692365610507
R25221 n_30_11_15 n_30_12_15 292242.02499999304
R25222 n_30_12_0 n_31_12_0 142.85714285714286
R25223 n_30_12_0 n_30_13_0 142.85714285714286
R25224 n_30_12_0 n_30_12_1 16499.99999999953
R25225 n_30_12_1 n_31_12_1 200.00000000000003
R25226 n_30_12_1 n_30_13_1 200.00000000000003
R25227 n_30_12_1 n_30_12_2 37499.99999999893
R25228 n_30_12_2 n_31_12_2 357.1428571428572
R25229 n_30_12_2 n_30_13_2 357.1428571428572
R25230 n_30_12_2 n_30_12_3 35099.999999999
R25231 n_30_12_3 n_31_12_3 4999.999999999996
R25232 n_30_12_3 n_30_13_3 4999.999999999996
R25233 n_30_12_3 n_30_12_4 466.66666666665384
R25234 n_30_12_4 n_31_12_4 151.51515151515142
R25235 n_30_12_4 n_30_13_4 151.51515151515142
R25236 n_30_12_15 n_31_12_15 9999.999999999904
R25237 n_30_12_15 n_30_13_15 9999.999999999904
R25238 n_30_13_0 n_31_13_0 142.85714285714286
R25239 n_30_13_0 n_30_14_0 142.85714285714286
R25240 n_30_13_0 n_30_13_1 16499.99999999953
R25241 n_30_13_1 n_31_13_1 200.00000000000003
R25242 n_30_13_1 n_30_14_1 200.00000000000003
R25243 n_30_13_1 n_30_13_2 37499.99999999893
R25244 n_30_13_2 n_31_13_2 357.1428571428572
R25245 n_30_13_2 n_30_14_2 357.1428571428572
R25246 n_30_13_2 n_30_13_3 35099.999999999
R25247 n_30_13_3 n_31_13_3 4999.999999999996
R25248 n_30_13_3 n_30_14_3 4999.999999999996
R25249 n_30_13_3 n_30_13_4 466.66666666665384
R25250 n_30_13_4 n_31_13_4 151.51515151515142
R25251 n_30_13_4 n_30_14_4 151.51515151515142
R25252 n_30_13_15 n_31_13_15 9999.999999999904
R25253 n_30_13_15 n_30_14_15 9999.999999999904
R25254 n_30_14_0 n_31_14_0 142.85714285714286
R25255 n_30_14_0 n_30_15_0 142.85714285714286
R25256 n_30_14_0 n_30_14_1 16499.99999999953
R25257 n_30_14_1 n_31_14_1 200.00000000000003
R25258 n_30_14_1 n_30_15_1 200.00000000000003
R25259 n_30_14_1 n_30_14_2 37499.99999999893
R25260 n_30_14_2 n_31_14_2 357.1428571428572
R25261 n_30_14_2 n_30_15_2 357.1428571428572
R25262 n_30_14_2 n_30_14_3 35099.999999999
R25263 n_30_14_3 n_31_14_3 4999.999999999996
R25264 n_30_14_3 n_30_15_3 4999.999999999996
R25265 n_30_14_3 n_30_14_4 466.66666666665384
R25266 n_30_14_4 n_31_14_4 151.51515151515142
R25267 n_30_14_4 n_30_15_4 151.51515151515142
R25268 n_30_14_15 n_31_14_15 9999.999999999904
R25269 n_30_14_15 n_30_15_15 9999.999999999904
R25270 n_30_15_0 n_31_15_0 142.85714285714286
R25271 n_30_15_0 n_30_16_0 4174.88607142851
R25272 n_30_15_0 n_30_15_1 16499.99999999953
R25273 n_30_15_1 n_31_15_1 200.00000000000003
R25274 n_30_15_1 n_30_16_1 5844.840499999915
R25275 n_30_15_1 n_30_15_2 37499.99999999893
R25276 n_30_15_2 n_31_15_2 357.1428571428572
R25277 n_30_15_2 n_30_16_2 10437.215178571278
R25278 n_30_15_2 n_30_15_3 35099.999999999
R25279 n_30_15_3 n_31_15_3 4999.999999999996
R25280 n_30_15_3 n_30_16_3 146121.0124999977
R25281 n_30_15_3 n_30_15_4 466.66666666665384
R25282 n_30_15_4 n_31_15_4 151.51515151515142
R25283 n_30_15_4 n_30_16_4 4427.909469696901
R25284 n_30_15_15 n_31_15_15 9999.999999999904
R25285 n_30_15_15 n_30_16_15 292242.02499999286
R25286 n_30_16_0 n_31_16_0 2.486703379443608
R25287 n_30_16_0 n_30_17_0 8206.914999999883
R25288 n_30_16_0 n_30_16_1 287.21424032572844
R25289 n_30_16_1 n_31_16_1 3.48138473122105
R25290 n_30_16_1 n_30_17_1 11489.680999999837
R25291 n_30_16_1 n_30_16_2 652.7596371039283
R25292 n_30_16_2 n_31_16_2 6.216758448609019
R25293 n_30_16_2 n_30_17_2 20517.287499999708
R25294 n_30_16_2 n_30_16_3 610.9830203292769
R25295 n_30_16_3 n_31_16_3 87.03461828052617
R25296 n_30_16_3 n_30_17_3 287242.0249999956
R25297 n_30_16_3 n_30_16_4 8.12323103951556
R25298 n_30_16_4 n_31_16_4 2.6374126751674596
R25299 n_30_16_4 n_30_17_4 8704.303787878656
R25300 n_30_16_15 n_31_16_15 174.06923656105081
R25301 n_30_16_15 n_30_17_15 574484.0499999862
R25302 n_30_17_0 n_31_17_0 2.486703379443604
R25303 n_30_17_0 n_30_18_0 8206.914999999888
R25304 n_30_17_0 n_30_17_1 287.2142403257281
R25305 n_30_17_1 n_31_17_1 3.481384731221046
R25306 n_30_17_1 n_30_18_1 11489.680999999842
R25307 n_30_17_1 n_30_17_2 652.7596371039276
R25308 n_30_17_2 n_31_17_2 6.216758448609011
R25309 n_30_17_2 n_30_18_2 20517.287499999722
R25310 n_30_17_2 n_30_17_3 610.9830203292762
R25311 n_30_17_3 n_31_17_3 87.03461828052608
R25312 n_30_17_3 n_30_18_3 287242.0249999958
R25313 n_30_17_3 n_30_17_4 8.123231039515549
R25314 n_30_17_4 n_31_17_4 2.637412675167457
R25315 n_30_17_4 n_30_18_4 8704.303787878662
R25316 n_30_17_15 n_31_17_15 174.06923656105062
R25317 n_30_17_15 n_30_18_15 574484.0499999865
R25318 n_30_18_0 n_31_18_0 2.486703379443604
R25319 n_30_18_0 n_30_19_0 8206.914999999883
R25320 n_30_18_0 n_30_18_1 287.2142403257281
R25321 n_30_18_1 n_31_18_1 3.481384731221046
R25322 n_30_18_1 n_30_19_1 11489.680999999837
R25323 n_30_18_1 n_30_18_2 652.7596371039276
R25324 n_30_18_2 n_31_18_2 6.216758448609011
R25325 n_30_18_2 n_30_19_2 20517.287499999708
R25326 n_30_18_2 n_30_18_3 610.9830203292762
R25327 n_30_18_3 n_31_18_3 87.03461828052608
R25328 n_30_18_3 n_30_19_3 287242.0249999956
R25329 n_30_18_3 n_30_18_4 8.123231039515549
R25330 n_30_18_4 n_31_18_4 2.637412675167457
R25331 n_30_18_4 n_30_19_4 8704.303787878656
R25332 n_30_18_15 n_31_18_15 174.06923656105062
R25333 n_30_18_15 n_30_19_15 574484.0499999862
R25334 n_30_19_0 n_31_19_0 2.486703379443608
R25335 n_30_19_0 n_30_20_0 4174.886084484129
R25336 n_30_19_0 n_30_19_1 287.21424032572844
R25337 n_30_19_1 n_31_19_1 3.48138473122105
R25338 n_30_19_1 n_30_20_1 5844.8405182777815
R25339 n_30_19_1 n_30_19_2 652.7596371039283
R25340 n_30_19_2 n_31_19_2 6.216758448609019
R25341 n_30_19_2 n_30_20_2 10437.215211210323
R25342 n_30_19_2 n_30_19_3 610.9830203292769
R25343 n_30_19_3 n_31_19_3 87.03461828052617
R25344 n_30_19_3 n_30_20_3 146121.01295694438
R25345 n_30_19_3 n_30_19_4 8.12323103951556
R25346 n_30_19_4 n_31_19_4 2.6374126751674596
R25347 n_30_19_4 n_30_20_4 4427.90948354377
R25348 n_30_19_15 n_31_19_15 174.06923656105081
R25349 n_30_19_15 n_30_20_15 292242.0259138862
R25350 n_30_20_0 n_31_20_0 142.85711674591005
R25351 n_30_20_0 n_30_21_0 142.85716896838048
R25352 n_30_20_0 n_30_20_1 16499.996984152138
R25353 n_30_20_1 n_31_20_1 199.99996344427402
R25354 n_30_20_1 n_30_21_1 200.00003655573266
R25355 n_30_20_1 n_30_20_2 37499.99314580031
R25356 n_30_20_2 n_31_20_2 357.1427918647751
R25357 n_30_20_2 n_30_21_2 357.1429224209512
R25358 n_30_20_2 n_30_20_3 35099.99358446909
R25359 n_30_20_3 n_31_20_3 4999.999086106846
R25360 n_30_20_3 n_30_21_3 5000.000913893312
R25361 n_30_20_3 n_30_20_4 466.66658136996
R25362 n_30_20_4 n_31_20_4 151.51512382141962
R25363 n_30_20_4 n_30_21_4 151.51517920888827
R25364 n_30_20_15 n_31_20_15 9999.998172213604
R25365 n_30_20_15 n_30_21_15 10000.001827786537
R25366 n_30_21_0 n_31_21_0 142.85711674591005
R25367 n_30_21_0 n_30_22_0 142.8571689683754
R25368 n_30_21_0 n_30_21_1 16499.996984152138
R25369 n_30_21_1 n_31_21_1 199.99996344427402
R25370 n_30_21_1 n_30_22_1 200.00003655572556
R25371 n_30_21_1 n_30_21_2 37499.99314580031
R25372 n_30_21_2 n_31_21_2 357.1427918647751
R25373 n_30_21_2 n_30_22_2 357.14292242093853
R25374 n_30_21_2 n_30_21_3 35099.99358446909
R25375 n_30_21_3 n_31_21_3 4999.999086106846
R25376 n_30_21_3 n_30_22_3 5000.000913893135
R25377 n_30_21_3 n_30_21_4 466.66658136996
R25378 n_30_21_4 n_31_21_4 151.51512382141962
R25379 n_30_21_4 n_30_22_4 151.5151792088829
R25380 n_30_21_15 n_31_21_15 9999.998172213604
R25381 n_30_21_15 n_30_22_15 10000.001827786182
R25382 n_30_22_0 n_31_22_0 142.85711674592017
R25383 n_30_22_0 n_30_23_0 142.8571689683754
R25384 n_30_22_0 n_30_22_1 16499.99698415331
R25385 n_30_22_1 n_31_22_1 199.99996344428826
R25386 n_30_22_1 n_30_23_1 200.00003655572556
R25387 n_30_22_1 n_30_22_2 37499.99314580298
R25388 n_30_22_2 n_31_22_2 357.1427918648005
R25389 n_30_22_2 n_30_23_2 357.14292242093853
R25390 n_30_22_2 n_30_22_3 35099.99358447159
R25391 n_30_22_3 n_31_22_3 4999.999086107202
R25392 n_30_22_3 n_30_23_3 5000.000913893135
R25393 n_30_22_3 n_30_22_4 466.66658136999297
R25394 n_30_22_4 n_31_22_4 151.51512382143036
R25395 n_30_22_4 n_30_23_4 151.5151792088829
R25396 n_30_22_15 n_31_22_15 9999.998172214315
R25397 n_30_22_15 n_30_23_15 10000.001827786182
R25398 n_30_23_0 n_31_23_0 142.85711674591005
R25399 n_30_23_0 n_30_24_0 1646.678571428551
R25400 n_30_23_0 n_30_23_1 16499.996984152138
R25401 n_30_23_1 n_31_23_1 199.99996344427402
R25402 n_30_23_1 n_30_24_1 2305.3499999999717
R25403 n_30_23_1 n_30_23_2 37499.99314580031
R25404 n_30_23_2 n_31_23_2 357.1427918647751
R25405 n_30_23_2 n_30_24_2 4116.696428571378
R25406 n_30_23_2 n_30_23_3 35099.99358446909
R25407 n_30_23_3 n_31_23_3 4999.999086106846
R25408 n_30_23_3 n_30_24_3 57633.749999999236
R25409 n_30_23_3 n_30_23_4 466.66658136996
R25410 n_30_23_4 n_31_23_4 151.51512382141962
R25411 n_30_23_4 n_30_24_4 1746.4772727272498
R25412 n_30_23_15 n_31_23_15 9999.998172213604
R25413 n_30_23_15 n_30_24_15 115267.49999999745
R25414 n_30_24_0 n_31_24_0 6.477753827788782
R25415 n_30_24_0 n_30_25_0 3150.499973888717
R25416 n_30_24_0 n_30_24_1 748.1805671095831
R25417 n_30_24_1 n_31_24_1 9.068855358904296
R25418 n_30_24_1 n_30_25_1 4410.699963444204
R25419 n_30_24_1 n_30_24_2 1700.410379794507
R25420 n_30_24_2 n_31_24_2 16.194384569471957
R25421 n_30_24_2 n_30_25_2 7876.249934721793
R25422 n_30_24_2 n_30_24_3 1591.5841154876584
R25423 n_30_24_3 n_31_24_3 226.72138397260719
R25424 n_30_24_3 n_30_25_3 110267.49908610499
R25425 n_30_24_3 n_30_24_4 21.16066250410944
R25426 n_30_24_4 n_31_24_4 6.870344968866884
R25427 n_30_24_4 n_30_25_4 3341.439366245606
R25428 n_30_24_4 n_30_24_5 17.48993533502923
R25429 n_30_24_5 n_31_24_5 43.18502551859185
R25430 n_30_24_5 n_30_25_5 21003.33315925809
R25431 n_30_24_5 n_30_24_6 6.045903572602696
R25432 n_30_24_6 n_31_24_6 7.19750425309864
R25433 n_30_24_6 n_30_25_6 3500.5555265430157
R25434 n_30_24_6 n_30_24_7 8.20515484853222
R25435 n_30_24_7 n_31_24_7 12.338578719597708
R25436 n_30_24_7 n_30_25_7 6000.952331216617
R25437 n_30_24_7 n_30_24_8 6.045903572602677
R25438 n_30_24_8 n_31_24_8 12.338578719597708
R25439 n_30_24_8 n_30_25_8 6000.952331216617
R25440 n_30_24_8 n_30_24_9 6.045903572602677
R25441 n_30_24_9 n_31_24_9 12.338578719597708
R25442 n_30_24_9 n_30_25_9 6000.952331216617
R25443 n_30_24_9 n_30_24_10 6.045903572602677
R25444 n_30_24_10 n_31_24_10 12.338578719597708
R25445 n_30_24_10 n_30_25_10 6000.952331216617
R25446 n_30_24_10 n_30_24_11 6.045903572602638
R25447 n_30_24_11 n_31_24_11 12.338578719597864
R25448 n_30_24_11 n_30_25_11 6000.952331216693
R25449 n_30_24_11 n_30_24_12 6.045903572602619
R25450 n_30_24_12 n_31_24_12 12.338578719597788
R25451 n_30_24_12 n_30_25_12 6000.952331216655
R25452 n_30_24_12 n_30_24_13 6.045903572602677
R25453 n_30_24_13 n_31_24_13 12.33857871959763
R25454 n_30_24_13 n_30_25_13 6000.952331216578
R25455 n_30_24_13 n_30_24_14 30.229517863013463
R25456 n_30_24_14 n_31_24_14 1.370953191066409
R25457 n_30_24_14 n_30_25_14 666.7724812462893
R25458 n_30_24_14 n_30_24_15 934.0921019671247
R25459 n_30_24_15 n_31_24_15 453.4427679452103
R25460 n_30_24_15 n_30_25_15 220534.99817220803
R25461 n_30_25_0 n_31_25_0 6.477753827788804
R25462 n_30_25_0 n_30_26_0 3150.499973888717
R25463 n_30_25_0 n_30_25_1 748.1805671095855
R25464 n_30_25_1 n_31_25_1 9.068855358904324
R25465 n_30_25_1 n_30_26_1 4410.699963444204
R25466 n_30_25_1 n_30_25_2 1700.4103797945122
R25467 n_30_25_2 n_31_25_2 16.19438456947201
R25468 n_30_25_2 n_30_26_2 7876.249934721793
R25469 n_30_25_2 n_30_25_3 1591.5841154876634
R25470 n_30_25_3 n_31_25_3 226.72138397260792
R25471 n_30_25_3 n_30_26_3 110267.49908610499
R25472 n_30_25_3 n_30_25_4 21.160662504109506
R25473 n_30_25_4 n_31_25_4 6.870344968866907
R25474 n_30_25_4 n_30_26_4 3341.439366245606
R25475 n_30_25_4 n_30_25_5 17.489935335029287
R25476 n_30_25_5 n_31_25_5 43.185025518591985
R25477 n_30_25_5 n_30_26_5 21003.33315925809
R25478 n_30_25_5 n_30_25_6 6.0459035726027155
R25479 n_30_25_6 n_31_25_6 7.197504253098664
R25480 n_30_25_6 n_30_26_6 3500.5555265430157
R25481 n_30_25_6 n_30_25_7 8.205154848532247
R25482 n_30_25_7 n_31_25_7 12.338578719597749
R25483 n_30_25_7 n_30_26_7 6000.952331216617
R25484 n_30_25_7 n_30_25_8 6.045903572602697
R25485 n_30_25_8 n_31_25_8 12.338578719597749
R25486 n_30_25_8 n_30_26_8 6000.952331216617
R25487 n_30_25_8 n_30_25_9 6.045903572602697
R25488 n_30_25_9 n_31_25_9 12.338578719597749
R25489 n_30_25_9 n_30_26_9 6000.952331216617
R25490 n_30_25_9 n_30_25_10 6.045903572602697
R25491 n_30_25_10 n_31_25_10 12.338578719597749
R25492 n_30_25_10 n_30_26_10 6000.952331216617
R25493 n_30_25_10 n_30_25_11 6.045903572602658
R25494 n_30_25_11 n_31_25_11 12.338578719597907
R25495 n_30_25_11 n_30_26_11 6000.952331216693
R25496 n_30_25_11 n_30_25_12 6.045903572602638
R25497 n_30_25_12 n_31_25_12 12.338578719597823
R25498 n_30_25_12 n_30_26_12 6000.952331216655
R25499 n_30_25_12 n_30_25_13 6.045903572602697
R25500 n_30_25_13 n_31_25_13 12.338578719597672
R25501 n_30_25_13 n_30_26_13 6000.952331216578
R25502 n_30_25_13 n_30_25_14 30.22951786301356
R25503 n_30_25_14 n_31_25_14 1.3709531910664134
R25504 n_30_25_14 n_30_26_14 666.7724812462893
R25505 n_30_25_14 n_30_25_15 934.0921019671276
R25506 n_30_25_15 n_31_25_15 453.44276794521176
R25507 n_30_25_15 n_30_26_15 220534.99817220803
R25508 n_30_26_0 n_31_26_0 6.477753827788782
R25509 n_30_26_0 n_30_27_0 3150.499973888722
R25510 n_30_26_0 n_30_26_1 748.1805671095831
R25511 n_30_26_1 n_31_26_1 9.068855358904296
R25512 n_30_26_1 n_30_27_1 4410.699963444211
R25513 n_30_26_1 n_30_26_2 1700.410379794507
R25514 n_30_26_2 n_31_26_2 16.194384569471957
R25515 n_30_26_2 n_30_27_2 7876.249934721805
R25516 n_30_26_2 n_30_26_3 1591.5841154876584
R25517 n_30_26_3 n_31_26_3 226.72138397260719
R25518 n_30_26_3 n_30_27_3 110267.49908610516
R25519 n_30_26_3 n_30_26_4 21.16066250410944
R25520 n_30_26_4 n_31_26_4 6.870344968866884
R25521 n_30_26_4 n_30_27_4 3341.4393662456114
R25522 n_30_26_4 n_30_26_5 17.48993533502923
R25523 n_30_26_5 n_31_26_5 43.18502551859185
R25524 n_30_26_5 n_30_27_5 21003.333159258123
R25525 n_30_26_5 n_30_26_6 6.045903572602696
R25526 n_30_26_6 n_31_26_6 7.19750425309864
R25527 n_30_26_6 n_30_27_6 3500.555526543021
R25528 n_30_26_6 n_30_26_7 8.20515484853222
R25529 n_30_26_7 n_31_26_7 12.338578719597708
R25530 n_30_26_7 n_30_27_7 6000.952331216627
R25531 n_30_26_7 n_30_26_8 6.045903572602677
R25532 n_30_26_8 n_31_26_8 12.338578719597708
R25533 n_30_26_8 n_30_27_8 6000.952331216627
R25534 n_30_26_8 n_30_26_9 6.045903572602677
R25535 n_30_26_9 n_31_26_9 12.338578719597708
R25536 n_30_26_9 n_30_27_9 6000.952331216627
R25537 n_30_26_9 n_30_26_10 6.045903572602677
R25538 n_30_26_10 n_31_26_10 12.338578719597708
R25539 n_30_26_10 n_30_27_10 6000.952331216627
R25540 n_30_26_10 n_30_26_11 6.045903572602638
R25541 n_30_26_11 n_31_26_11 12.338578719597864
R25542 n_30_26_11 n_30_27_11 6000.952331216702
R25543 n_30_26_11 n_30_26_12 6.045903572602619
R25544 n_30_26_12 n_31_26_12 12.338578719597788
R25545 n_30_26_12 n_30_27_12 6000.952331216665
R25546 n_30_26_12 n_30_26_13 6.045903572602677
R25547 n_30_26_13 n_31_26_13 12.33857871959763
R25548 n_30_26_13 n_30_27_13 6000.952331216588
R25549 n_30_26_13 n_30_26_14 30.229517863013463
R25550 n_30_26_14 n_31_26_14 1.370953191066409
R25551 n_30_26_14 n_30_27_14 666.7724812462903
R25552 n_30_26_14 n_30_26_15 934.0921019671247
R25553 n_30_26_15 n_31_26_15 453.4427679452103
R25554 n_30_26_15 n_30_27_15 220534.99817220838
R25555 n_30_27_0 n_31_27_0 6.477753827788782
R25556 n_30_27_0 n_30_27_1 748.1805671095831
R25557 n_30_27_1 n_31_27_1 9.068855358904296
R25558 n_30_27_1 n_30_27_2 1700.410379794507
R25559 n_30_27_2 n_31_27_2 16.194384569471957
R25560 n_30_27_2 n_30_27_3 1591.5841154876584
R25561 n_30_27_3 n_31_27_3 226.72138397260719
R25562 n_30_27_3 n_30_27_4 21.16066250410944
R25563 n_30_27_4 n_31_27_4 6.870344968866884
R25564 n_30_27_4 n_30_27_5 17.48993533502923
R25565 n_30_27_5 n_31_27_5 43.18502551859185
R25566 n_30_27_5 n_30_27_6 6.045903572602696
R25567 n_30_27_6 n_31_27_6 7.19750425309864
R25568 n_30_27_6 n_30_27_7 8.20515484853222
R25569 n_30_27_7 n_31_27_7 12.338578719597708
R25570 n_30_27_7 n_30_27_8 6.045903572602677
R25571 n_30_27_8 n_31_27_8 12.338578719597708
R25572 n_30_27_8 n_30_27_9 6.045903572602677
R25573 n_30_27_9 n_31_27_9 12.338578719597708
R25574 n_30_27_9 n_30_27_10 6.045903572602677
R25575 n_30_27_10 n_31_27_10 12.338578719597708
R25576 n_30_27_10 n_30_27_11 6.045903572602638
R25577 n_30_27_11 n_31_27_11 12.338578719597864
R25578 n_30_27_11 n_30_27_12 6.045903572602619
R25579 n_30_27_12 n_31_27_12 12.338578719597788
R25580 n_30_27_12 n_30_27_13 6.045903572602677
R25581 n_30_27_13 n_31_27_13 12.33857871959763
R25582 n_30_27_13 n_30_27_14 30.229517863013463
R25583 n_30_27_14 n_31_27_14 1.370953191066409
R25584 n_30_27_14 n_30_27_15 934.0921019671247
R25585 n_30_27_15 n_31_27_15 453.4427679452103
R25586 n_31_0_0 n_32_0_0 19.585244109562872
R25587 n_31_0_0 n_31_1_0 3150.5002452092954
R25588 n_31_0_0 n_31_0_1 748.1805026763932
R25589 n_31_0_1 n_32_0_1 27.419341753388018
R25590 n_31_0_1 n_31_1_1 4410.700343293014
R25591 n_31_0_1 n_31_0_2 1700.4102333554388
R25592 n_31_0_2 n_32_0_2 48.963110273907176
R25593 n_31_0_2 n_31_1_2 7876.25061302324
R25594 n_31_0_2 n_31_0_3 1591.5839784206908
R25595 n_31_0_3 n_32_0_3 685.4835438346998
R25596 n_31_0_3 n_31_1_3 110267.50858232524
R25597 n_31_0_3 n_31_0_4 21.160660681756593
R25598 n_31_0_4 n_32_0_4 20.77222860105151
R25599 n_31_0_4 n_31_1_4 3341.4396540098564
R25600 n_31_0_4 n_31_0_5 17.489933828798815
R25601 n_31_0_5 n_32_0_5 130.56829406375232
R25602 n_31_0_5 n_31_1_5 21003.33496806195
R25603 n_31_0_5 n_31_0_6 6.045903051930455
R25604 n_31_0_6 n_32_0_6 21.761382343958726
R25605 n_31_0_6 n_31_1_6 3500.5558280103255
R25606 n_31_0_6 n_31_0_7 8.205154141905608
R25607 n_31_0_7 n_32_0_7 37.30522687535793
R25608 n_31_0_7 n_31_1_7 6000.95284801772
R25609 n_31_0_7 n_31_0_8 6.045903051930436
R25610 n_31_0_8 n_32_0_8 37.30522687535793
R25611 n_31_0_8 n_31_1_8 6000.95284801772
R25612 n_31_0_8 n_31_0_9 6.045903051930436
R25613 n_31_0_9 n_32_0_9 37.30522687535793
R25614 n_31_0_9 n_31_1_9 6000.95284801772
R25615 n_31_0_9 n_31_0_10 6.045903051930436
R25616 n_31_0_10 n_32_0_10 37.30522687535793
R25617 n_31_0_10 n_31_1_10 6000.95284801772
R25618 n_31_0_10 n_31_0_11 6.045903051930397
R25619 n_31_0_11 n_32_0_11 37.30522687535841
R25620 n_31_0_11 n_31_1_11 6000.952848017796
R25621 n_31_0_11 n_31_0_12 6.045903051930377
R25622 n_31_0_12 n_32_0_12 37.30522687535818
R25623 n_31_0_12 n_31_1_12 6000.952848017758
R25624 n_31_0_12 n_31_0_13 6.045903051930436
R25625 n_31_0_13 n_32_0_13 37.3052268753577
R25626 n_31_0_13 n_31_1_13 6000.952848017681
R25627 n_31_0_13 n_31_0_14 30.229515259652253
R25628 n_31_0_14 n_32_0_14 4.145025208373095
R25629 n_31_0_14 n_31_1_14 666.7725386686341
R25630 n_31_0_14 n_31_0_15 934.0920215232634
R25631 n_31_0_15 n_32_0_15 1370.9670876693874
R25632 n_31_0_15 n_31_1_15 220535.01716464857
R25633 n_31_1_0 n_32_1_0 19.585244109562872
R25634 n_31_1_0 n_31_2_0 3150.5002452092954
R25635 n_31_1_0 n_31_1_1 748.1805026763932
R25636 n_31_1_1 n_32_1_1 27.419341753388018
R25637 n_31_1_1 n_31_2_1 4410.700343293014
R25638 n_31_1_1 n_31_1_2 1700.4102333554388
R25639 n_31_1_2 n_32_1_2 48.963110273907176
R25640 n_31_1_2 n_31_2_2 7876.25061302324
R25641 n_31_1_2 n_31_1_3 1591.5839784206908
R25642 n_31_1_3 n_32_1_3 685.4835438346998
R25643 n_31_1_3 n_31_2_3 110267.50858232524
R25644 n_31_1_3 n_31_1_4 21.160660681756593
R25645 n_31_1_4 n_32_1_4 20.77222860105151
R25646 n_31_1_4 n_31_2_4 3341.4396540098564
R25647 n_31_1_4 n_31_1_5 17.489933828798815
R25648 n_31_1_5 n_32_1_5 130.56829406375232
R25649 n_31_1_5 n_31_2_5 21003.33496806195
R25650 n_31_1_5 n_31_1_6 6.045903051930455
R25651 n_31_1_6 n_32_1_6 21.761382343958726
R25652 n_31_1_6 n_31_2_6 3500.5558280103255
R25653 n_31_1_6 n_31_1_7 8.205154141905608
R25654 n_31_1_7 n_32_1_7 37.30522687535793
R25655 n_31_1_7 n_31_2_7 6000.95284801772
R25656 n_31_1_7 n_31_1_8 6.045903051930436
R25657 n_31_1_8 n_32_1_8 37.30522687535793
R25658 n_31_1_8 n_31_2_8 6000.95284801772
R25659 n_31_1_8 n_31_1_9 6.045903051930436
R25660 n_31_1_9 n_32_1_9 37.30522687535793
R25661 n_31_1_9 n_31_2_9 6000.95284801772
R25662 n_31_1_9 n_31_1_10 6.045903051930436
R25663 n_31_1_10 n_32_1_10 37.30522687535793
R25664 n_31_1_10 n_31_2_10 6000.95284801772
R25665 n_31_1_10 n_31_1_11 6.045903051930397
R25666 n_31_1_11 n_32_1_11 37.30522687535841
R25667 n_31_1_11 n_31_2_11 6000.952848017796
R25668 n_31_1_11 n_31_1_12 6.045903051930377
R25669 n_31_1_12 n_32_1_12 37.30522687535818
R25670 n_31_1_12 n_31_2_12 6000.952848017758
R25671 n_31_1_12 n_31_1_13 6.045903051930436
R25672 n_31_1_13 n_32_1_13 37.3052268753577
R25673 n_31_1_13 n_31_2_13 6000.952848017681
R25674 n_31_1_13 n_31_1_14 30.229515259652253
R25675 n_31_1_14 n_32_1_14 4.145025208373095
R25676 n_31_1_14 n_31_2_14 666.7725386686341
R25677 n_31_1_14 n_31_1_15 934.0920215232634
R25678 n_31_1_15 n_32_1_15 1370.9670876693874
R25679 n_31_1_15 n_31_2_15 220535.01716464857
R25680 n_31_2_0 n_32_2_0 19.585244109562872
R25681 n_31_2_0 n_31_3_0 3150.5002452092954
R25682 n_31_2_0 n_31_2_1 748.1805026763932
R25683 n_31_2_1 n_32_2_1 27.419341753388018
R25684 n_31_2_1 n_31_3_1 4410.700343293014
R25685 n_31_2_1 n_31_2_2 1700.4102333554388
R25686 n_31_2_2 n_32_2_2 48.963110273907176
R25687 n_31_2_2 n_31_3_2 7876.25061302324
R25688 n_31_2_2 n_31_2_3 1591.5839784206908
R25689 n_31_2_3 n_32_2_3 685.4835438346998
R25690 n_31_2_3 n_31_3_3 110267.50858232524
R25691 n_31_2_3 n_31_2_4 21.160660681756593
R25692 n_31_2_4 n_32_2_4 20.77222860105151
R25693 n_31_2_4 n_31_3_4 3341.4396540098564
R25694 n_31_2_4 n_31_2_5 17.489933828798815
R25695 n_31_2_5 n_32_2_5 130.56829406375232
R25696 n_31_2_5 n_31_3_5 21003.33496806195
R25697 n_31_2_5 n_31_2_6 6.045903051930455
R25698 n_31_2_6 n_32_2_6 21.761382343958726
R25699 n_31_2_6 n_31_3_6 3500.5558280103255
R25700 n_31_2_6 n_31_2_7 8.205154141905608
R25701 n_31_2_7 n_32_2_7 37.30522687535793
R25702 n_31_2_7 n_31_3_7 6000.95284801772
R25703 n_31_2_7 n_31_2_8 6.045903051930436
R25704 n_31_2_8 n_32_2_8 37.30522687535793
R25705 n_31_2_8 n_31_3_8 6000.95284801772
R25706 n_31_2_8 n_31_2_9 6.045903051930436
R25707 n_31_2_9 n_32_2_9 37.30522687535793
R25708 n_31_2_9 n_31_3_9 6000.95284801772
R25709 n_31_2_9 n_31_2_10 6.045903051930436
R25710 n_31_2_10 n_32_2_10 37.30522687535793
R25711 n_31_2_10 n_31_3_10 6000.95284801772
R25712 n_31_2_10 n_31_2_11 6.045903051930397
R25713 n_31_2_11 n_32_2_11 37.30522687535841
R25714 n_31_2_11 n_31_3_11 6000.952848017796
R25715 n_31_2_11 n_31_2_12 6.045903051930377
R25716 n_31_2_12 n_32_2_12 37.30522687535818
R25717 n_31_2_12 n_31_3_12 6000.952848017758
R25718 n_31_2_12 n_31_2_13 6.045903051930436
R25719 n_31_2_13 n_32_2_13 37.3052268753577
R25720 n_31_2_13 n_31_3_13 6000.952848017681
R25721 n_31_2_13 n_31_2_14 30.229515259652253
R25722 n_31_2_14 n_32_2_14 4.145025208373095
R25723 n_31_2_14 n_31_3_14 666.7725386686341
R25724 n_31_2_14 n_31_2_15 934.0920215232634
R25725 n_31_2_15 n_32_2_15 1370.9670876693874
R25726 n_31_2_15 n_31_3_15 220535.01716464857
R25727 n_31_3_0 n_32_3_0 19.585244109562872
R25728 n_31_3_0 n_31_4_0 1646.6785714285472
R25729 n_31_3_0 n_31_3_1 748.1805026763932
R25730 n_31_3_1 n_32_3_1 27.419341753388018
R25731 n_31_3_1 n_31_4_1 2305.3499999999667
R25732 n_31_3_1 n_31_3_2 1700.4102333554388
R25733 n_31_3_2 n_32_3_2 48.963110273907176
R25734 n_31_3_2 n_31_4_2 4116.696428571369
R25735 n_31_3_2 n_31_3_3 1591.5839784206908
R25736 n_31_3_3 n_32_3_3 685.4835438346998
R25737 n_31_3_3 n_31_4_3 57633.749999999105
R25738 n_31_3_3 n_31_3_4 21.160660681756593
R25739 n_31_3_4 n_32_3_4 20.77222860105151
R25740 n_31_3_4 n_31_4_4 1746.477272727246
R25741 n_31_3_4 n_31_3_5 17.489933828798815
R25742 n_31_3_5 n_32_3_5 130.56829406375232
R25743 n_31_3_5 n_31_3_6 6.045903051930455
R25744 n_31_3_6 n_32_3_6 21.761382343958726
R25745 n_31_3_6 n_31_3_7 8.205154141905608
R25746 n_31_3_7 n_32_3_7 37.30522687535793
R25747 n_31_3_7 n_31_3_8 6.045903051930436
R25748 n_31_3_8 n_32_3_8 37.30522687535793
R25749 n_31_3_8 n_31_3_9 6.045903051930436
R25750 n_31_3_9 n_32_3_9 37.30522687535793
R25751 n_31_3_9 n_31_3_10 6.045903051930436
R25752 n_31_3_10 n_32_3_10 37.30522687535793
R25753 n_31_3_10 n_31_3_11 6.045903051930397
R25754 n_31_3_11 n_32_3_11 37.30522687535841
R25755 n_31_3_11 n_31_3_12 6.045903051930377
R25756 n_31_3_12 n_32_3_12 37.30522687535818
R25757 n_31_3_12 n_31_3_13 6.045903051930436
R25758 n_31_3_13 n_32_3_13 37.3052268753577
R25759 n_31_3_13 n_31_3_14 30.229515259652253
R25760 n_31_3_14 n_32_3_14 4.145025208373095
R25761 n_31_3_14 n_31_3_15 934.0920215232634
R25762 n_31_3_15 n_32_3_15 1370.9670876693874
R25763 n_31_3_15 n_31_4_15 115267.4999999972
R25764 n_31_4_0 n_32_4_0 431.92395597016025
R25765 n_31_4_0 n_31_5_0 142.8568976478005
R25766 n_31_4_0 n_31_4_1 16500.028321727335
R25767 n_31_4_1 n_32_4_1 604.6935383582244
R25768 n_31_4_1 n_31_5_1 199.99965670692075
R25769 n_31_4_1 n_31_4_2 37500.064367562125
R25770 n_31_4_2 n_32_4_2 1079.8098899254007
R25771 n_31_4_2 n_31_5_2 357.14224411950136
R25772 n_31_4_2 n_31_4_3 35100.06024803815
R25773 n_31_4_3 n_32_4_3 15117.338458955597
R25774 n_31_4_3 n_31_5_3 4999.9914176730135
R25775 n_31_4_3 n_31_4_4 466.66746768521796
R25776 n_31_4_4 n_32_4_4 458.1011654228969
R25777 n_31_4_4 n_31_5_4 151.5148914446368
R25778 n_31_4_15 n_32_4_15 30234.676917910925
R25779 n_31_4_15 n_31_5_15 9999.982835345938
R25780 n_31_5_0 n_32_5_0 431.92395597015263
R25781 n_31_5_0 n_31_6_0 142.8568976478018
R25782 n_31_5_0 n_31_5_1 16500.02832172704
R25783 n_31_5_1 n_32_5_1 604.6935383582136
R25784 n_31_5_1 n_31_6_1 199.9996567069225
R25785 n_31_5_1 n_31_5_2 37500.06436756146
R25786 n_31_5_2 n_32_5_2 1079.8098899253814
R25787 n_31_5_2 n_31_6_2 357.1422441195045
R25788 n_31_5_2 n_31_5_3 35100.06024803753
R25789 n_31_5_3 n_32_5_3 15117.338458955328
R25790 n_31_5_3 n_31_6_3 4999.991417673058
R25791 n_31_5_3 n_31_5_4 466.66746768520966
R25792 n_31_5_4 n_32_5_4 458.1011654228887
R25793 n_31_5_4 n_31_6_4 151.51489144463812
R25794 n_31_5_15 n_32_5_15 30234.676917910387
R25795 n_31_5_15 n_31_6_15 9999.982835346027
R25796 n_31_6_0 n_32_6_0 431.92395597015263
R25797 n_31_6_0 n_31_7_0 142.8568976478005
R25798 n_31_6_0 n_31_6_1 16500.02832172704
R25799 n_31_6_1 n_32_6_1 604.6935383582136
R25800 n_31_6_1 n_31_7_1 199.99965670692075
R25801 n_31_6_1 n_31_6_2 37500.06436756146
R25802 n_31_6_2 n_32_6_2 1079.8098899253814
R25803 n_31_6_2 n_31_7_2 357.14224411950136
R25804 n_31_6_2 n_31_6_3 35100.06024803753
R25805 n_31_6_3 n_32_6_3 15117.338458955328
R25806 n_31_6_3 n_31_7_3 4999.9914176730135
R25807 n_31_6_3 n_31_6_4 466.66746768520966
R25808 n_31_6_4 n_32_6_4 458.1011654228887
R25809 n_31_6_4 n_31_7_4 151.5148914446368
R25810 n_31_6_15 n_32_6_15 30234.676917910387
R25811 n_31_6_15 n_31_7_15 9999.982835345938
R25812 n_31_7_0 n_32_7_0 431.92395597016025
R25813 n_31_7_0 n_31_8_0 4174.885948823841
R25814 n_31_7_0 n_31_7_1 16500.028321727335
R25815 n_31_7_1 n_32_7_1 604.6935383582244
R25816 n_31_7_1 n_31_8_1 5844.840328353377
R25817 n_31_7_1 n_31_7_2 37500.064367562125
R25818 n_31_7_2 n_32_7_2 1079.8098899254007
R25819 n_31_7_2 n_31_8_2 10437.214872059603
R25820 n_31_7_2 n_31_7_3 35100.06024803815
R25821 n_31_7_3 n_32_7_3 15117.338458955597
R25822 n_31_7_3 n_31_8_3 146121.00820883428
R25823 n_31_7_3 n_31_7_4 466.66746768521796
R25824 n_31_7_4 n_32_7_4 458.1011654228969
R25825 n_31_7_4 n_31_8_4 4427.909339661646
R25826 n_31_7_15 n_32_7_15 30234.676917910925
R25827 n_31_7_15 n_31_8_15 292242.01641766605
R25828 n_31_8_0 n_32_8_0 7.518454421626473
R25829 n_31_8_0 n_31_9_0 8206.914999999884
R25830 n_31_8_0 n_31_8_1 287.21424032572827
R25831 n_31_8_1 n_32_8_1 10.525836190277062
R25832 n_31_8_1 n_31_9_1 11489.680999999839
R25833 n_31_8_1 n_31_8_2 652.759637103928
R25834 n_31_8_2 n_32_8_2 18.79613605406618
R25835 n_31_8_2 n_31_9_2 20517.287499999715
R25836 n_31_8_2 n_31_8_3 610.9830203292765
R25837 n_31_8_3 n_32_8_3 263.1459047569263
R25838 n_31_8_3 n_31_9_3 287242.0249999957
R25839 n_31_8_3 n_31_8_4 8.123231039515554
R25840 n_31_8_4 n_32_8_4 7.974118325967464
R25841 n_31_8_4 n_31_9_4 8704.30378787866
R25842 n_31_8_15 n_32_8_15 526.2918095138479
R25843 n_31_8_15 n_31_9_15 574484.0499999863
R25844 n_31_9_0 n_32_9_0 7.518454421626466
R25845 n_31_9_0 n_31_10_0 8206.914999999884
R25846 n_31_9_0 n_31_9_1 287.2142403257281
R25847 n_31_9_1 n_32_9_1 10.525836190277055
R25848 n_31_9_1 n_31_10_1 11489.680999999839
R25849 n_31_9_1 n_31_9_2 652.7596371039276
R25850 n_31_9_2 n_32_9_2 18.79613605406617
R25851 n_31_9_2 n_31_10_2 20517.287499999715
R25852 n_31_9_2 n_31_9_3 610.9830203292762
R25853 n_31_9_3 n_32_9_3 263.14590475692614
R25854 n_31_9_3 n_31_10_3 287242.0249999957
R25855 n_31_9_3 n_31_9_4 8.123231039515549
R25856 n_31_9_4 n_32_9_4 7.974118325967459
R25857 n_31_9_4 n_31_10_4 8704.30378787866
R25858 n_31_9_15 n_32_9_15 526.2918095138476
R25859 n_31_9_15 n_31_10_15 574484.0499999863
R25860 n_31_10_0 n_32_10_0 7.518454421626473
R25861 n_31_10_0 n_31_11_0 8206.914999999883
R25862 n_31_10_0 n_31_10_1 287.21424032572827
R25863 n_31_10_1 n_32_10_1 10.525836190277062
R25864 n_31_10_1 n_31_11_1 11489.680999999835
R25865 n_31_10_1 n_31_10_2 652.759637103928
R25866 n_31_10_2 n_32_10_2 18.79613605406618
R25867 n_31_10_2 n_31_11_2 20517.287499999708
R25868 n_31_10_2 n_31_10_3 610.9830203292765
R25869 n_31_10_3 n_32_10_3 263.1459047569263
R25870 n_31_10_3 n_31_11_3 287242.0249999956
R25871 n_31_10_3 n_31_10_4 8.123231039515554
R25872 n_31_10_4 n_32_10_4 7.974118325967464
R25873 n_31_10_4 n_31_11_4 8704.303787878656
R25874 n_31_10_15 n_32_10_15 526.2918095138479
R25875 n_31_10_15 n_31_11_15 574484.0499999862
R25876 n_31_11_0 n_32_11_0 7.518454421626473
R25877 n_31_11_0 n_31_12_0 4174.886071428513
R25878 n_31_11_0 n_31_11_1 287.21424032572827
R25879 n_31_11_1 n_32_11_1 10.525836190277062
R25880 n_31_11_1 n_31_12_1 5844.8404999999175
R25881 n_31_11_1 n_31_11_2 652.759637103928
R25882 n_31_11_2 n_32_11_2 18.79613605406618
R25883 n_31_11_2 n_31_12_2 10437.215178571283
R25884 n_31_11_2 n_31_11_3 610.9830203292765
R25885 n_31_11_3 n_32_11_3 263.1459047569263
R25886 n_31_11_3 n_31_12_3 146121.0124999978
R25887 n_31_11_3 n_31_11_4 8.123231039515554
R25888 n_31_11_4 n_32_11_4 7.974118325967464
R25889 n_31_11_4 n_31_12_4 4427.909469696904
R25890 n_31_11_15 n_32_11_15 526.2918095138479
R25891 n_31_11_15 n_31_12_15 292242.02499999304
R25892 n_31_12_0 n_32_12_0 431.92321458763206
R25893 n_31_12_0 n_31_13_0 142.85714285714286
R25894 n_31_12_0 n_31_12_1 16499.99999999953
R25895 n_31_12_1 n_32_12_1 604.6925004226849
R25896 n_31_12_1 n_31_13_1 200.00000000000003
R25897 n_31_12_1 n_31_12_2 37499.99999999893
R25898 n_31_12_2 n_32_12_2 1079.8080364690804
R25899 n_31_12_2 n_31_13_2 357.1428571428572
R25900 n_31_12_2 n_31_12_3 35099.999999999
R25901 n_31_12_3 n_32_12_3 15117.31251056711
R25902 n_31_12_3 n_31_13_3 4999.999999999996
R25903 n_31_12_3 n_31_12_4 466.66666666665384
R25904 n_31_12_4 n_32_12_4 458.1003791080943
R25905 n_31_12_4 n_31_13_4 151.51515151515142
R25906 n_31_12_15 n_32_12_15 30234.625021133954
R25907 n_31_12_15 n_31_13_15 9999.999999999904
R25908 n_31_13_0 n_32_13_0 431.92321458763206
R25909 n_31_13_0 n_31_14_0 142.85714285714286
R25910 n_31_13_0 n_31_13_1 16499.99999999953
R25911 n_31_13_1 n_32_13_1 604.6925004226849
R25912 n_31_13_1 n_31_14_1 200.00000000000003
R25913 n_31_13_1 n_31_13_2 37499.99999999893
R25914 n_31_13_2 n_32_13_2 1079.8080364690804
R25915 n_31_13_2 n_31_14_2 357.1428571428572
R25916 n_31_13_2 n_31_13_3 35099.999999999
R25917 n_31_13_3 n_32_13_3 15117.31251056711
R25918 n_31_13_3 n_31_14_3 4999.999999999996
R25919 n_31_13_3 n_31_13_4 466.66666666665384
R25920 n_31_13_4 n_32_13_4 458.1003791080943
R25921 n_31_13_4 n_31_14_4 151.51515151515142
R25922 n_31_13_15 n_32_13_15 30234.625021133954
R25923 n_31_13_15 n_31_14_15 9999.999999999904
R25924 n_31_14_0 n_32_14_0 431.92321458763206
R25925 n_31_14_0 n_31_15_0 142.85714285714286
R25926 n_31_14_0 n_31_14_1 16499.99999999953
R25927 n_31_14_1 n_32_14_1 604.6925004226849
R25928 n_31_14_1 n_31_15_1 200.00000000000003
R25929 n_31_14_1 n_31_14_2 37499.99999999893
R25930 n_31_14_2 n_32_14_2 1079.8080364690804
R25931 n_31_14_2 n_31_15_2 357.1428571428572
R25932 n_31_14_2 n_31_14_3 35099.999999999
R25933 n_31_14_3 n_32_14_3 15117.31251056711
R25934 n_31_14_3 n_31_15_3 4999.999999999996
R25935 n_31_14_3 n_31_14_4 466.66666666665384
R25936 n_31_14_4 n_32_14_4 458.1003791080943
R25937 n_31_14_4 n_31_15_4 151.51515151515142
R25938 n_31_14_15 n_32_14_15 30234.625021133954
R25939 n_31_14_15 n_31_15_15 9999.999999999904
R25940 n_31_15_0 n_32_15_0 431.92321458763206
R25941 n_31_15_0 n_31_16_0 4174.88607142851
R25942 n_31_15_0 n_31_15_1 16499.99999999953
R25943 n_31_15_1 n_32_15_1 604.6925004226849
R25944 n_31_15_1 n_31_16_1 5844.840499999915
R25945 n_31_15_1 n_31_15_2 37499.99999999893
R25946 n_31_15_2 n_32_15_2 1079.8080364690804
R25947 n_31_15_2 n_31_16_2 10437.215178571278
R25948 n_31_15_2 n_31_15_3 35099.999999999
R25949 n_31_15_3 n_32_15_3 15117.31251056711
R25950 n_31_15_3 n_31_16_3 146121.0124999977
R25951 n_31_15_3 n_31_15_4 466.66666666665384
R25952 n_31_15_4 n_32_15_4 458.1003791080943
R25953 n_31_15_4 n_31_16_4 4427.909469696901
R25954 n_31_15_15 n_32_15_15 30234.625021133954
R25955 n_31_15_15 n_31_16_15 292242.02499999286
R25956 n_31_16_0 n_32_16_0 7.518454421626478
R25957 n_31_16_0 n_31_17_0 8206.914999999883
R25958 n_31_16_0 n_31_16_1 287.21424032572844
R25959 n_31_16_1 n_32_16_1 10.525836190277069
R25960 n_31_16_1 n_31_17_1 11489.680999999837
R25961 n_31_16_1 n_31_16_2 652.7596371039283
R25962 n_31_16_2 n_32_16_2 18.796136054066192
R25963 n_31_16_2 n_31_17_2 20517.287499999708
R25964 n_31_16_2 n_31_16_3 610.9830203292769
R25965 n_31_16_3 n_32_16_3 263.1459047569264
R25966 n_31_16_3 n_31_17_3 287242.0249999956
R25967 n_31_16_3 n_31_16_4 8.12323103951556
R25968 n_31_16_4 n_32_16_4 7.974118325967467
R25969 n_31_16_4 n_31_17_4 8704.303787878656
R25970 n_31_16_15 n_32_16_15 526.2918095138482
R25971 n_31_16_15 n_31_17_15 574484.0499999862
R25972 n_31_17_0 n_32_17_0 7.518454421626466
R25973 n_31_17_0 n_31_18_0 8206.914999999888
R25974 n_31_17_0 n_31_17_1 287.2142403257281
R25975 n_31_17_1 n_32_17_1 10.525836190277055
R25976 n_31_17_1 n_31_18_1 11489.680999999842
R25977 n_31_17_1 n_31_17_2 652.7596371039276
R25978 n_31_17_2 n_32_17_2 18.79613605406617
R25979 n_31_17_2 n_31_18_2 20517.287499999722
R25980 n_31_17_2 n_31_17_3 610.9830203292762
R25981 n_31_17_3 n_32_17_3 263.14590475692614
R25982 n_31_17_3 n_31_18_3 287242.0249999958
R25983 n_31_17_3 n_31_17_4 8.123231039515549
R25984 n_31_17_4 n_32_17_4 7.974118325967459
R25985 n_31_17_4 n_31_18_4 8704.303787878662
R25986 n_31_17_15 n_32_17_15 526.2918095138476
R25987 n_31_17_15 n_31_18_15 574484.0499999865
R25988 n_31_18_0 n_32_18_0 7.518454421626466
R25989 n_31_18_0 n_31_19_0 8206.914999999883
R25990 n_31_18_0 n_31_18_1 287.2142403257281
R25991 n_31_18_1 n_32_18_1 10.525836190277055
R25992 n_31_18_1 n_31_19_1 11489.680999999837
R25993 n_31_18_1 n_31_18_2 652.7596371039276
R25994 n_31_18_2 n_32_18_2 18.79613605406617
R25995 n_31_18_2 n_31_19_2 20517.287499999708
R25996 n_31_18_2 n_31_18_3 610.9830203292762
R25997 n_31_18_3 n_32_18_3 263.14590475692614
R25998 n_31_18_3 n_31_19_3 287242.0249999956
R25999 n_31_18_3 n_31_18_4 8.123231039515549
R26000 n_31_18_4 n_32_18_4 7.974118325967459
R26001 n_31_18_4 n_31_19_4 8704.303787878656
R26002 n_31_18_15 n_32_18_15 526.2918095138476
R26003 n_31_18_15 n_31_19_15 574484.0499999862
R26004 n_31_19_0 n_32_19_0 7.518454421626478
R26005 n_31_19_0 n_31_20_0 4174.886084484129
R26006 n_31_19_0 n_31_19_1 287.21424032572844
R26007 n_31_19_1 n_32_19_1 10.525836190277069
R26008 n_31_19_1 n_31_20_1 5844.8405182777815
R26009 n_31_19_1 n_31_19_2 652.7596371039283
R26010 n_31_19_2 n_32_19_2 18.796136054066192
R26011 n_31_19_2 n_31_20_2 10437.215211210323
R26012 n_31_19_2 n_31_19_3 610.9830203292769
R26013 n_31_19_3 n_32_19_3 263.1459047569264
R26014 n_31_19_3 n_31_20_3 146121.01295694438
R26015 n_31_19_3 n_31_19_4 8.12323103951556
R26016 n_31_19_4 n_32_19_4 7.974118325967467
R26017 n_31_19_4 n_31_20_4 4427.90948354377
R26018 n_31_19_15 n_32_19_15 526.2918095138482
R26019 n_31_19_15 n_31_20_15 292242.0259138862
R26020 n_31_20_0 n_32_20_0 431.92313564129876
R26021 n_31_20_0 n_31_21_0 142.85716896838048
R26022 n_31_20_0 n_31_20_1 16499.996984152138
R26023 n_31_20_1 n_32_20_1 604.6923898978181
R26024 n_31_20_1 n_31_21_1 200.00003655573266
R26025 n_31_20_1 n_31_20_2 37499.99314580031
R26026 n_31_20_2 n_32_20_2 1079.807839103247
R26027 n_31_20_2 n_31_21_2 357.1429224209512
R26028 n_31_20_2 n_31_20_3 35099.99358446909
R26029 n_31_20_3 n_32_20_3 15117.30974744544
R26030 n_31_20_3 n_31_21_3 5000.000913893312
R26031 n_31_20_3 n_31_20_4 466.66658136996
R26032 n_31_20_4 n_32_20_4 458.1002953771346
R26033 n_31_20_4 n_31_21_4 151.51517920888827
R26034 n_31_20_15 n_32_20_15 30234.619494890612
R26035 n_31_20_15 n_31_21_15 10000.001827786537
R26036 n_31_21_0 n_32_21_0 431.92313564129876
R26037 n_31_21_0 n_31_22_0 142.8571689683754
R26038 n_31_21_0 n_31_21_1 16499.996984152138
R26039 n_31_21_1 n_32_21_1 604.6923898978181
R26040 n_31_21_1 n_31_22_1 200.00003655572556
R26041 n_31_21_1 n_31_21_2 37499.99314580031
R26042 n_31_21_2 n_32_21_2 1079.807839103247
R26043 n_31_21_2 n_31_22_2 357.14292242093853
R26044 n_31_21_2 n_31_21_3 35099.99358446909
R26045 n_31_21_3 n_32_21_3 15117.30974744544
R26046 n_31_21_3 n_31_22_3 5000.000913893135
R26047 n_31_21_3 n_31_21_4 466.66658136996
R26048 n_31_21_4 n_32_21_4 458.1002953771346
R26049 n_31_21_4 n_31_22_4 151.5151792088829
R26050 n_31_21_15 n_32_21_15 30234.619494890612
R26051 n_31_21_15 n_31_22_15 10000.001827786182
R26052 n_31_22_0 n_32_22_0 431.9231356413294
R26053 n_31_22_0 n_31_23_0 142.8571689683754
R26054 n_31_22_0 n_31_22_1 16499.99698415331
R26055 n_31_22_1 n_32_22_1 604.6923898978612
R26056 n_31_22_1 n_31_23_1 200.00003655572556
R26057 n_31_22_1 n_31_22_2 37499.99314580298
R26058 n_31_22_2 n_32_22_2 1079.8078391033234
R26059 n_31_22_2 n_31_23_2 357.14292242093853
R26060 n_31_22_2 n_31_22_3 35099.99358447159
R26061 n_31_22_3 n_32_22_3 15117.309747446514
R26062 n_31_22_3 n_31_23_3 5000.000913893135
R26063 n_31_22_3 n_31_22_4 466.66658136999297
R26064 n_31_22_4 n_32_22_4 458.10029537716713
R26065 n_31_22_4 n_31_23_4 151.5151792088829
R26066 n_31_22_15 n_32_22_15 30234.61949489276
R26067 n_31_22_15 n_31_23_15 10000.001827786182
R26068 n_31_23_0 n_32_23_0 431.92313564129876
R26069 n_31_23_0 n_31_24_0 1646.678571428551
R26070 n_31_23_0 n_31_23_1 16499.996984152138
R26071 n_31_23_1 n_32_23_1 604.6923898978181
R26072 n_31_23_1 n_31_24_1 2305.3499999999717
R26073 n_31_23_1 n_31_23_2 37499.99314580031
R26074 n_31_23_2 n_32_23_2 1079.807839103247
R26075 n_31_23_2 n_31_24_2 4116.696428571378
R26076 n_31_23_2 n_31_23_3 35099.99358446909
R26077 n_31_23_3 n_32_23_3 15117.30974744544
R26078 n_31_23_3 n_31_24_3 57633.749999999236
R26079 n_31_23_3 n_31_23_4 466.66658136996
R26080 n_31_23_4 n_32_23_4 458.1002953771346
R26081 n_31_23_4 n_31_24_4 1746.4772727272498
R26082 n_31_23_15 n_32_23_15 30234.619494890612
R26083 n_31_23_15 n_31_24_15 115267.49999999745
R26084 n_31_24_0 n_32_24_0 19.585245796241082
R26085 n_31_24_0 n_31_25_0 3150.499973888717
R26086 n_31_24_0 n_31_24_1 748.1805671095831
R26087 n_31_24_1 n_32_24_1 27.419344114737516
R26088 n_31_24_1 n_31_25_1 4410.699963444204
R26089 n_31_24_1 n_31_24_2 1700.410379794507
R26090 n_31_24_2 n_32_24_2 48.96311449060272
R26091 n_31_24_2 n_31_25_2 7876.249934721793
R26092 n_31_24_2 n_31_24_3 1591.5841154876584
R26093 n_31_24_3 n_32_24_3 685.4836028684373
R26094 n_31_24_3 n_31_25_3 110267.49908610499
R26095 n_31_24_3 n_31_24_4 21.16066250410944
R26096 n_31_24_4 n_32_24_4 20.772230389952643
R26097 n_31_24_4 n_31_25_4 3341.439366245606
R26098 n_31_24_4 n_31_24_5 17.48993533502923
R26099 n_31_24_5 n_32_24_5 130.56830530827378
R26100 n_31_24_5 n_31_25_5 21003.33315925809
R26101 n_31_24_5 n_31_24_6 6.045903572602696
R26102 n_31_24_6 n_32_24_6 21.76138421804563
R26103 n_31_24_6 n_31_25_6 3500.5555265430157
R26104 n_31_24_6 n_31_24_7 8.20515484853222
R26105 n_31_24_7 n_32_24_7 37.30523008807834
R26106 n_31_24_7 n_31_25_7 6000.952331216617
R26107 n_31_24_7 n_31_24_8 6.045903572602677
R26108 n_31_24_8 n_32_24_8 37.30523008807834
R26109 n_31_24_8 n_31_25_8 6000.952331216617
R26110 n_31_24_8 n_31_24_9 6.045903572602677
R26111 n_31_24_9 n_32_24_9 37.30523008807834
R26112 n_31_24_9 n_31_25_9 6000.952331216617
R26113 n_31_24_9 n_31_24_10 6.045903572602677
R26114 n_31_24_10 n_32_24_10 37.30523008807834
R26115 n_31_24_10 n_31_25_10 6000.952331216617
R26116 n_31_24_10 n_31_24_11 6.045903572602638
R26117 n_31_24_11 n_32_24_11 37.30523008807881
R26118 n_31_24_11 n_31_25_11 6000.952331216693
R26119 n_31_24_11 n_31_24_12 6.045903572602619
R26120 n_31_24_12 n_32_24_12 37.305230088078574
R26121 n_31_24_12 n_31_25_12 6000.952331216655
R26122 n_31_24_12 n_31_24_13 6.045903572602677
R26123 n_31_24_13 n_32_24_13 37.305230088078105
R26124 n_31_24_13 n_31_25_13 6000.952331216578
R26125 n_31_24_13 n_31_24_14 30.229517863013463
R26126 n_31_24_14 n_32_24_14 4.145025565342028
R26127 n_31_24_14 n_31_25_14 666.7724812462893
R26128 n_31_24_14 n_31_24_15 934.0921019671247
R26129 n_31_24_15 n_32_24_15 1370.9672057368623
R26130 n_31_24_15 n_31_25_15 220534.99817220803
R26131 n_31_25_0 n_32_25_0 19.585245796241146
R26132 n_31_25_0 n_31_26_0 3150.499973888717
R26133 n_31_25_0 n_31_25_1 748.1805671095855
R26134 n_31_25_1 n_32_25_1 27.4193441147376
R26135 n_31_25_1 n_31_26_1 4410.699963444204
R26136 n_31_25_1 n_31_25_2 1700.4103797945122
R26137 n_31_25_2 n_32_25_2 48.96311449060287
R26138 n_31_25_2 n_31_26_2 7876.249934721793
R26139 n_31_25_2 n_31_25_3 1591.5841154876634
R26140 n_31_25_3 n_32_25_3 685.4836028684396
R26141 n_31_25_3 n_31_26_3 110267.49908610499
R26142 n_31_25_3 n_31_25_4 21.160662504109506
R26143 n_31_25_4 n_32_25_4 20.772230389952718
R26144 n_31_25_4 n_31_26_4 3341.439366245606
R26145 n_31_25_4 n_31_25_5 17.489935335029287
R26146 n_31_25_5 n_32_25_5 130.5683053082742
R26147 n_31_25_5 n_31_26_5 21003.33315925809
R26148 n_31_25_5 n_31_25_6 6.0459035726027155
R26149 n_31_25_6 n_32_25_6 21.7613842180457
R26150 n_31_25_6 n_31_26_6 3500.5555265430157
R26151 n_31_25_6 n_31_25_7 8.205154848532247
R26152 n_31_25_7 n_32_25_7 37.30523008807846
R26153 n_31_25_7 n_31_26_7 6000.952331216617
R26154 n_31_25_7 n_31_25_8 6.045903572602697
R26155 n_31_25_8 n_32_25_8 37.30523008807846
R26156 n_31_25_8 n_31_26_8 6000.952331216617
R26157 n_31_25_8 n_31_25_9 6.045903572602697
R26158 n_31_25_9 n_32_25_9 37.30523008807846
R26159 n_31_25_9 n_31_26_9 6000.952331216617
R26160 n_31_25_9 n_31_25_10 6.045903572602697
R26161 n_31_25_10 n_32_25_10 37.30523008807846
R26162 n_31_25_10 n_31_26_10 6000.952331216617
R26163 n_31_25_10 n_31_25_11 6.045903572602658
R26164 n_31_25_11 n_32_25_11 37.305230088078936
R26165 n_31_25_11 n_31_26_11 6000.952331216693
R26166 n_31_25_11 n_31_25_12 6.045903572602638
R26167 n_31_25_12 n_32_25_12 37.30523008807869
R26168 n_31_25_12 n_31_26_12 6000.952331216655
R26169 n_31_25_12 n_31_25_13 6.045903572602697
R26170 n_31_25_13 n_32_25_13 37.305230088078225
R26171 n_31_25_13 n_31_26_13 6000.952331216578
R26172 n_31_25_13 n_31_25_14 30.22951786301356
R26173 n_31_25_14 n_32_25_14 4.145025565342042
R26174 n_31_25_14 n_31_26_14 666.7724812462893
R26175 n_31_25_14 n_31_25_15 934.0921019671276
R26176 n_31_25_15 n_32_25_15 1370.9672057368668
R26177 n_31_25_15 n_31_26_15 220534.99817220803
R26178 n_31_26_0 n_32_26_0 19.585245796241082
R26179 n_31_26_0 n_31_27_0 3150.499973888722
R26180 n_31_26_0 n_31_26_1 748.1805671095831
R26181 n_31_26_1 n_32_26_1 27.419344114737516
R26182 n_31_26_1 n_31_27_1 4410.699963444211
R26183 n_31_26_1 n_31_26_2 1700.410379794507
R26184 n_31_26_2 n_32_26_2 48.96311449060272
R26185 n_31_26_2 n_31_27_2 7876.249934721805
R26186 n_31_26_2 n_31_26_3 1591.5841154876584
R26187 n_31_26_3 n_32_26_3 685.4836028684373
R26188 n_31_26_3 n_31_27_3 110267.49908610516
R26189 n_31_26_3 n_31_26_4 21.16066250410944
R26190 n_31_26_4 n_32_26_4 20.772230389952643
R26191 n_31_26_4 n_31_27_4 3341.4393662456114
R26192 n_31_26_4 n_31_26_5 17.48993533502923
R26193 n_31_26_5 n_32_26_5 130.56830530827378
R26194 n_31_26_5 n_31_27_5 21003.333159258123
R26195 n_31_26_5 n_31_26_6 6.045903572602696
R26196 n_31_26_6 n_32_26_6 21.76138421804563
R26197 n_31_26_6 n_31_27_6 3500.555526543021
R26198 n_31_26_6 n_31_26_7 8.20515484853222
R26199 n_31_26_7 n_32_26_7 37.30523008807834
R26200 n_31_26_7 n_31_27_7 6000.952331216627
R26201 n_31_26_7 n_31_26_8 6.045903572602677
R26202 n_31_26_8 n_32_26_8 37.30523008807834
R26203 n_31_26_8 n_31_27_8 6000.952331216627
R26204 n_31_26_8 n_31_26_9 6.045903572602677
R26205 n_31_26_9 n_32_26_9 37.30523008807834
R26206 n_31_26_9 n_31_27_9 6000.952331216627
R26207 n_31_26_9 n_31_26_10 6.045903572602677
R26208 n_31_26_10 n_32_26_10 37.30523008807834
R26209 n_31_26_10 n_31_27_10 6000.952331216627
R26210 n_31_26_10 n_31_26_11 6.045903572602638
R26211 n_31_26_11 n_32_26_11 37.30523008807881
R26212 n_31_26_11 n_31_27_11 6000.952331216702
R26213 n_31_26_11 n_31_26_12 6.045903572602619
R26214 n_31_26_12 n_32_26_12 37.305230088078574
R26215 n_31_26_12 n_31_27_12 6000.952331216665
R26216 n_31_26_12 n_31_26_13 6.045903572602677
R26217 n_31_26_13 n_32_26_13 37.305230088078105
R26218 n_31_26_13 n_31_27_13 6000.952331216588
R26219 n_31_26_13 n_31_26_14 30.229517863013463
R26220 n_31_26_14 n_32_26_14 4.145025565342028
R26221 n_31_26_14 n_31_27_14 666.7724812462903
R26222 n_31_26_14 n_31_26_15 934.0921019671247
R26223 n_31_26_15 n_32_26_15 1370.9672057368623
R26224 n_31_26_15 n_31_27_15 220534.99817220838
R26225 n_31_27_0 n_32_27_0 19.585245796241082
R26226 n_31_27_0 n_31_27_1 748.1805671095831
R26227 n_31_27_1 n_32_27_1 27.419344114737516
R26228 n_31_27_1 n_31_27_2 1700.410379794507
R26229 n_31_27_2 n_32_27_2 48.96311449060272
R26230 n_31_27_2 n_31_27_3 1591.5841154876584
R26231 n_31_27_3 n_32_27_3 685.4836028684373
R26232 n_31_27_3 n_31_27_4 21.16066250410944
R26233 n_31_27_4 n_32_27_4 20.772230389952643
R26234 n_31_27_4 n_31_27_5 17.48993533502923
R26235 n_31_27_5 n_32_27_5 130.56830530827378
R26236 n_31_27_5 n_31_27_6 6.045903572602696
R26237 n_31_27_6 n_32_27_6 21.76138421804563
R26238 n_31_27_6 n_31_27_7 8.20515484853222
R26239 n_31_27_7 n_32_27_7 37.30523008807834
R26240 n_31_27_7 n_31_27_8 6.045903572602677
R26241 n_31_27_8 n_32_27_8 37.30523008807834
R26242 n_31_27_8 n_31_27_9 6.045903572602677
R26243 n_31_27_9 n_32_27_9 37.30523008807834
R26244 n_31_27_9 n_31_27_10 6.045903572602677
R26245 n_31_27_10 n_32_27_10 37.30523008807834
R26246 n_31_27_10 n_31_27_11 6.045903572602638
R26247 n_31_27_11 n_32_27_11 37.30523008807881
R26248 n_31_27_11 n_31_27_12 6.045903572602619
R26249 n_31_27_12 n_32_27_12 37.305230088078574
R26250 n_31_27_12 n_31_27_13 6.045903572602677
R26251 n_31_27_13 n_32_27_13 37.305230088078105
R26252 n_31_27_13 n_31_27_14 30.229517863013463
R26253 n_31_27_14 n_32_27_14 4.145025565342028
R26254 n_31_27_14 n_31_27_15 934.0921019671247
R26255 n_31_27_15 n_32_27_15 1370.9672057368623
R26256 n_32_0_0 n_33_0_0 32.69273494920008
R26257 n_32_0_0 n_32_1_0 624.2415416457984
R26258 n_32_0_0 n_32_0_1 148.2448227484626
R26259 n_32_0_1 n_33_0_1 45.7698289288801
R26260 n_32_0_1 n_32_1_1 873.9381583041177
R26261 n_32_0_1 n_32_0_2 336.92005170105136
R26262 n_32_0_2 n_33_0_2 81.73183737300019
R26263 n_32_0_2 n_32_1_2 1560.6038541144958
R26264 n_32_0_2 n_32_0_3 315.35716839218406
R26265 n_32_0_3 n_33_0_3 1144.2457232220015
R26266 n_32_0_3 n_32_1_3 21848.453957602924
R26267 n_32_0_3 n_32_0_4 4.192782865613087
R26268 n_32_0_4 n_33_0_4 34.67411282490914
R26269 n_32_0_4 n_32_1_4 662.0743623516037
R26270 n_32_0_4 n_32_0_5 3.465463388925103
R26271 n_32_0_5 n_33_0_5 217.95156632800027
R26272 n_32_0_5 n_32_1_5 4161.610277638652
R26273 n_32_0_5 n_32_0_6 1.197937961603739
R26274 n_32_0_6 n_33_0_6 36.32526105466672
R26275 n_32_0_6 n_32_1_6 693.6017129397753
R26276 n_32_0_6 n_32_0_7 1.6257729478907872
R26277 n_32_0_7 n_33_0_7 62.27187609371456
R26278 n_32_0_7 n_32_1_7 1189.0315078967615
R26279 n_32_0_7 n_32_0_8 1.1979379616037356
R26280 n_32_0_8 n_33_0_8 62.27187609371456
R26281 n_32_0_8 n_32_1_8 1189.0315078967615
R26282 n_32_0_8 n_32_0_9 1.1979379616037356
R26283 n_32_0_9 n_33_0_9 62.27187609371456
R26284 n_32_0_9 n_32_1_9 1189.0315078967615
R26285 n_32_0_9 n_32_0_10 1.1979379616037356
R26286 n_32_0_10 n_33_0_10 62.27187609371456
R26287 n_32_0_10 n_32_1_10 1189.0315078967615
R26288 n_32_0_10 n_32_0_11 1.1979379616037278
R26289 n_32_0_11 n_33_0_11 62.271876093715356
R26290 n_32_0_11 n_32_1_11 1189.0315078967762
R26291 n_32_0_11 n_32_0_12 1.197937961603724
R26292 n_32_0_12 n_33_0_12 62.27187609371498
R26293 n_32_0_12 n_32_1_12 1189.031507896769
R26294 n_32_0_12 n_32_0_13 1.1979379616037353
R26295 n_32_0_13 n_33_0_13 62.27187609371417
R26296 n_32_0_13 n_32_1_13 1189.031507896754
R26297 n_32_0_13 n_32_0_14 5.989689808018693
R26298 n_32_0_14 n_33_0_14 6.919097343746048
R26299 n_32_0_14 n_32_1_14 132.1146119885288
R26300 n_32_0_14 n_32_0_15 185.0814150677793
R26301 n_32_0_15 n_33_0_15 2288.4914464439826
R26302 n_32_0_15 n_32_1_15 43696.907915205455
R26303 n_32_1_0 n_33_1_0 32.69273494920008
R26304 n_32_1_0 n_32_2_0 624.2415416457984
R26305 n_32_1_0 n_32_1_1 148.2448227484626
R26306 n_32_1_1 n_33_1_1 45.7698289288801
R26307 n_32_1_1 n_32_2_1 873.9381583041177
R26308 n_32_1_1 n_32_1_2 336.92005170105136
R26309 n_32_1_2 n_33_1_2 81.73183737300019
R26310 n_32_1_2 n_32_2_2 1560.6038541144958
R26311 n_32_1_2 n_32_1_3 315.35716839218406
R26312 n_32_1_3 n_33_1_3 1144.2457232220015
R26313 n_32_1_3 n_32_2_3 21848.453957602924
R26314 n_32_1_3 n_32_1_4 4.192782865613087
R26315 n_32_1_4 n_33_1_4 34.67411282490914
R26316 n_32_1_4 n_32_2_4 662.0743623516037
R26317 n_32_1_4 n_32_1_5 3.465463388925103
R26318 n_32_1_5 n_33_1_5 217.95156632800027
R26319 n_32_1_5 n_32_2_5 4161.610277638652
R26320 n_32_1_5 n_32_1_6 1.197937961603739
R26321 n_32_1_6 n_33_1_6 36.32526105466672
R26322 n_32_1_6 n_32_2_6 693.6017129397753
R26323 n_32_1_6 n_32_1_7 1.6257729478907872
R26324 n_32_1_7 n_33_1_7 62.27187609371456
R26325 n_32_1_7 n_32_2_7 1189.0315078967615
R26326 n_32_1_7 n_32_1_8 1.1979379616037356
R26327 n_32_1_8 n_33_1_8 62.27187609371456
R26328 n_32_1_8 n_32_2_8 1189.0315078967615
R26329 n_32_1_8 n_32_1_9 1.1979379616037356
R26330 n_32_1_9 n_33_1_9 62.27187609371456
R26331 n_32_1_9 n_32_2_9 1189.0315078967615
R26332 n_32_1_9 n_32_1_10 1.1979379616037356
R26333 n_32_1_10 n_33_1_10 62.27187609371456
R26334 n_32_1_10 n_32_2_10 1189.0315078967615
R26335 n_32_1_10 n_32_1_11 1.1979379616037278
R26336 n_32_1_11 n_33_1_11 62.271876093715356
R26337 n_32_1_11 n_32_2_11 1189.0315078967762
R26338 n_32_1_11 n_32_1_12 1.197937961603724
R26339 n_32_1_12 n_33_1_12 62.27187609371498
R26340 n_32_1_12 n_32_2_12 1189.031507896769
R26341 n_32_1_12 n_32_1_13 1.1979379616037353
R26342 n_32_1_13 n_33_1_13 62.27187609371417
R26343 n_32_1_13 n_32_2_13 1189.031507896754
R26344 n_32_1_13 n_32_1_14 5.989689808018693
R26345 n_32_1_14 n_33_1_14 6.919097343746048
R26346 n_32_1_14 n_32_2_14 132.1146119885288
R26347 n_32_1_14 n_32_1_15 185.0814150677793
R26348 n_32_1_15 n_33_1_15 2288.4914464439826
R26349 n_32_1_15 n_32_2_15 43696.907915205455
R26350 n_32_2_0 n_33_2_0 32.69273494920008
R26351 n_32_2_0 n_32_3_0 624.2415416457984
R26352 n_32_2_0 n_32_2_1 148.2448227484626
R26353 n_32_2_1 n_33_2_1 45.7698289288801
R26354 n_32_2_1 n_32_3_1 873.9381583041177
R26355 n_32_2_1 n_32_2_2 336.92005170105136
R26356 n_32_2_2 n_33_2_2 81.73183737300019
R26357 n_32_2_2 n_32_3_2 1560.6038541144958
R26358 n_32_2_2 n_32_2_3 315.35716839218406
R26359 n_32_2_3 n_33_2_3 1144.2457232220015
R26360 n_32_2_3 n_32_3_3 21848.453957602924
R26361 n_32_2_3 n_32_2_4 4.192782865613087
R26362 n_32_2_4 n_33_2_4 34.67411282490914
R26363 n_32_2_4 n_32_3_4 662.0743623516037
R26364 n_32_2_4 n_32_2_5 3.465463388925103
R26365 n_32_2_5 n_33_2_5 217.95156632800027
R26366 n_32_2_5 n_32_3_5 4161.610277638652
R26367 n_32_2_5 n_32_2_6 1.197937961603739
R26368 n_32_2_6 n_33_2_6 36.32526105466672
R26369 n_32_2_6 n_32_3_6 693.6017129397753
R26370 n_32_2_6 n_32_2_7 1.6257729478907872
R26371 n_32_2_7 n_33_2_7 62.27187609371456
R26372 n_32_2_7 n_32_3_7 1189.0315078967615
R26373 n_32_2_7 n_32_2_8 1.1979379616037356
R26374 n_32_2_8 n_33_2_8 62.27187609371456
R26375 n_32_2_8 n_32_3_8 1189.0315078967615
R26376 n_32_2_8 n_32_2_9 1.1979379616037356
R26377 n_32_2_9 n_33_2_9 62.27187609371456
R26378 n_32_2_9 n_32_3_9 1189.0315078967615
R26379 n_32_2_9 n_32_2_10 1.1979379616037356
R26380 n_32_2_10 n_33_2_10 62.27187609371456
R26381 n_32_2_10 n_32_3_10 1189.0315078967615
R26382 n_32_2_10 n_32_2_11 1.1979379616037278
R26383 n_32_2_11 n_33_2_11 62.271876093715356
R26384 n_32_2_11 n_32_3_11 1189.0315078967762
R26385 n_32_2_11 n_32_2_12 1.197937961603724
R26386 n_32_2_12 n_33_2_12 62.27187609371498
R26387 n_32_2_12 n_32_3_12 1189.031507896769
R26388 n_32_2_12 n_32_2_13 1.1979379616037353
R26389 n_32_2_13 n_33_2_13 62.27187609371417
R26390 n_32_2_13 n_32_3_13 1189.031507896754
R26391 n_32_2_13 n_32_2_14 5.989689808018693
R26392 n_32_2_14 n_33_2_14 6.919097343746048
R26393 n_32_2_14 n_32_3_14 132.1146119885288
R26394 n_32_2_14 n_32_2_15 185.0814150677793
R26395 n_32_2_15 n_33_2_15 2288.4914464439826
R26396 n_32_2_15 n_32_3_15 43696.907915205455
R26397 n_32_3_0 n_33_3_0 32.69273494920008
R26398 n_32_3_0 n_32_4_0 326.27363593662244
R26399 n_32_3_0 n_32_3_1 148.2448227484626
R26400 n_32_3_1 n_33_3_1 45.7698289288801
R26401 n_32_3_1 n_32_4_1 456.78309031127134
R26402 n_32_3_1 n_32_3_2 336.92005170105136
R26403 n_32_3_2 n_33_3_2 81.73183737300019
R26404 n_32_3_2 n_32_4_2 815.684089841556
R26405 n_32_3_2 n_32_3_3 315.35716839218406
R26406 n_32_3_3 n_33_3_3 1144.2457232220015
R26407 n_32_3_3 n_32_4_3 11419.577257781775
R26408 n_32_3_3 n_32_3_4 4.192782865613087
R26409 n_32_3_4 n_33_3_4 34.67411282490914
R26410 n_32_3_4 n_32_4_4 346.04779569035674
R26411 n_32_3_4 n_32_3_5 3.465463388925103
R26412 n_32_3_5 n_33_3_5 217.95156632800027
R26413 n_32_3_5 n_32_4_5 2175.1575729108145
R26414 n_32_3_5 n_32_3_6 1.197937961603739
R26415 n_32_3_6 n_33_3_6 36.32526105466672
R26416 n_32_3_6 n_32_4_6 362.52626215180237
R26417 n_32_3_6 n_32_3_7 1.6257729478907872
R26418 n_32_3_7 n_33_3_7 62.27187609371456
R26419 n_32_3_7 n_32_4_7 621.4735922602346
R26420 n_32_3_7 n_32_3_8 1.1979379616037356
R26421 n_32_3_8 n_33_3_8 62.27187609371456
R26422 n_32_3_8 n_32_4_8 621.4735922602346
R26423 n_32_3_8 n_32_3_9 1.1979379616037356
R26424 n_32_3_9 n_33_3_9 62.27187609371456
R26425 n_32_3_9 n_32_4_9 621.4735922602346
R26426 n_32_3_9 n_32_3_10 1.1979379616037356
R26427 n_32_3_10 n_33_3_10 62.27187609371456
R26428 n_32_3_10 n_32_4_10 621.4735922602346
R26429 n_32_3_10 n_32_3_11 1.1979379616037278
R26430 n_32_3_11 n_33_3_11 62.271876093715356
R26431 n_32_3_11 n_32_4_11 621.4735922602423
R26432 n_32_3_11 n_32_3_12 1.197937961603724
R26433 n_32_3_12 n_33_3_12 62.27187609371498
R26434 n_32_3_12 n_32_4_12 621.4735922602384
R26435 n_32_3_12 n_32_3_13 1.1979379616037353
R26436 n_32_3_13 n_33_3_13 62.27187609371417
R26437 n_32_3_13 n_32_4_13 621.4735922602306
R26438 n_32_3_13 n_32_3_14 5.989689808018693
R26439 n_32_3_14 n_33_3_14 6.919097343746048
R26440 n_32_3_14 n_32_4_14 69.05262136224815
R26441 n_32_3_14 n_32_3_15 185.0814150677793
R26442 n_32_3_15 n_33_3_15 2288.4914464439826
R26443 n_32_3_15 n_32_4_15 22839.154515563343
R26444 n_32_4_0 n_33_4_0 720.990523873413
R26445 n_32_4_0 n_32_5_0 28.305730227446706
R26446 n_32_4_0 n_32_4_1 3269.323064620219
R26447 n_32_4_1 n_33_4_1 1009.3867334227783
R26448 n_32_4_1 n_32_5_1 39.628022318425394
R26449 n_32_4_1 n_32_4_2 7430.27969231868
R26450 n_32_4_2 n_33_4_2 1802.476309683533
R26451 n_32_4_2 n_32_5_2 70.76432556861675
R26452 n_32_4_2 n_32_4_3 6954.741792010284
R26453 n_32_4_3 n_33_4_3 25234.66833556944
R26454 n_32_4_3 n_32_5_3 990.7005579606339
R26455 n_32_4_3 n_32_4_4 92.46570283774365
R26456 n_32_4_4 n_33_4_4 764.6869192596799
R26457 n_32_4_4 n_32_5_4 30.021229029110113
R26458 n_32_4_4 n_32_4_5 76.42573397813506
R26459 n_32_4_5 n_33_4_5 4806.603492489417
R26460 n_32_4_5 n_32_5_5 188.7048681829779
R26461 n_32_4_5 n_32_4_6 26.41877223935533
R26462 n_32_4_6 n_33_4_6 801.1005820815694
R26463 n_32_4_6 n_32_5_6 31.450811363829644
R26464 n_32_4_6 n_32_4_7 35.85404803912505
R26465 n_32_4_7 n_33_4_7 1373.315283568409
R26466 n_32_4_7 n_32_5_7 53.91567662370813
R26467 n_32_4_7 n_32_4_8 26.41877223935525
R26468 n_32_4_8 n_33_4_8 1373.315283568409
R26469 n_32_4_8 n_32_5_8 53.91567662370813
R26470 n_32_4_8 n_32_4_9 26.41877223935525
R26471 n_32_4_9 n_33_4_9 1373.315283568409
R26472 n_32_4_9 n_32_5_9 53.91567662370813
R26473 n_32_4_9 n_32_4_10 26.41877223935525
R26474 n_32_4_10 n_33_4_10 1373.315283568409
R26475 n_32_4_10 n_32_5_10 53.91567662370813
R26476 n_32_4_10 n_32_4_11 26.41877223935508
R26477 n_32_4_11 n_33_4_11 1373.3152835684264
R26478 n_32_4_11 n_32_5_11 53.915676623708805
R26479 n_32_4_11 n_32_4_12 26.418772239354993
R26480 n_32_4_12 n_33_4_12 1373.3152835684177
R26481 n_32_4_12 n_32_5_12 53.91567662370848
R26482 n_32_4_12 n_32_4_13 26.41877223935525
R26483 n_32_4_13 n_33_4_13 1373.3152835684004
R26484 n_32_4_13 n_32_5_13 53.915676623707796
R26485 n_32_4_13 n_32_4_14 132.09386119677657
R26486 n_32_4_14 n_33_4_14 152.59058706315625
R26487 n_32_4_14 n_32_5_14 5.990630735967558
R26488 n_32_4_14 n_32_4_15 4081.7003109804336
R26489 n_32_4_15 n_33_4_15 50469.33667113843
R26490 n_32_4_15 n_32_5_15 1981.40111592125
R26491 n_32_5_0 n_33_5_0 720.9905238734004
R26492 n_32_5_0 n_32_6_0 28.305730227446958
R26493 n_32_5_0 n_32_5_1 3269.3230646201605
R26494 n_32_5_1 n_33_5_1 1009.3867334227604
R26495 n_32_5_1 n_32_6_1 39.62802231842574
R26496 n_32_5_1 n_32_5_2 7430.279692318547
R26497 n_32_5_2 n_33_5_2 1802.4763096835009
R26498 n_32_5_2 n_32_6_2 70.76432556861738
R26499 n_32_5_2 n_32_5_3 6954.74179201016
R26500 n_32_5_3 n_33_5_3 25234.66833556899
R26501 n_32_5_3 n_32_6_3 990.7005579606426
R26502 n_32_5_3 n_32_5_4 92.46570283774201
R26503 n_32_5_4 n_33_5_4 764.6869192596663
R26504 n_32_5_4 n_32_6_4 30.02122902911038
R26505 n_32_5_4 n_32_5_5 76.4257339781337
R26506 n_32_5_5 n_33_5_5 4806.603492489332
R26507 n_32_5_5 n_32_6_5 188.70486818297957
R26508 n_32_5_5 n_32_5_6 26.418772239354862
R26509 n_32_5_6 n_33_5_6 801.1005820815552
R26510 n_32_5_6 n_32_6_6 31.45081136382992
R26511 n_32_5_6 n_32_5_7 35.854048039124415
R26512 n_32_5_7 n_33_5_7 1373.3152835683848
R26513 n_32_5_7 n_32_6_7 53.915676623708606
R26514 n_32_5_7 n_32_5_8 26.41877223935478
R26515 n_32_5_8 n_33_5_8 1373.3152835683848
R26516 n_32_5_8 n_32_6_8 53.915676623708606
R26517 n_32_5_8 n_32_5_9 26.41877223935478
R26518 n_32_5_9 n_33_5_9 1373.3152835683848
R26519 n_32_5_9 n_32_6_9 53.915676623708606
R26520 n_32_5_9 n_32_5_10 26.41877223935478
R26521 n_32_5_10 n_33_5_10 1373.3152835683848
R26522 n_32_5_10 n_32_6_10 53.915676623708606
R26523 n_32_5_10 n_32_5_11 26.41877223935461
R26524 n_32_5_11 n_33_5_11 1373.315283568402
R26525 n_32_5_11 n_32_6_11 53.91567662370929
R26526 n_32_5_11 n_32_5_12 26.418772239354524
R26527 n_32_5_12 n_33_5_12 1373.3152835683932
R26528 n_32_5_12 n_32_6_12 53.915676623708954
R26529 n_32_5_12 n_32_5_13 26.41877223935478
R26530 n_32_5_13 n_33_5_13 1373.3152835683761
R26531 n_32_5_13 n_32_6_13 53.91567662370827
R26532 n_32_5_13 n_32_5_14 132.0938611967742
R26533 n_32_5_14 n_33_5_14 152.59058706315352
R26534 n_32_5_14 n_32_6_14 5.990630735967612
R26535 n_32_5_14 n_32_5_15 4081.700310980361
R26536 n_32_5_15 n_33_5_15 50469.33667113753
R26537 n_32_5_15 n_32_6_15 1981.4011159212675
R26538 n_32_6_0 n_33_6_0 720.9905238734004
R26539 n_32_6_0 n_32_7_0 28.305730227446706
R26540 n_32_6_0 n_32_6_1 3269.3230646201605
R26541 n_32_6_1 n_33_6_1 1009.3867334227604
R26542 n_32_6_1 n_32_7_1 39.628022318425394
R26543 n_32_6_1 n_32_6_2 7430.279692318547
R26544 n_32_6_2 n_33_6_2 1802.4763096835009
R26545 n_32_6_2 n_32_7_2 70.76432556861675
R26546 n_32_6_2 n_32_6_3 6954.74179201016
R26547 n_32_6_3 n_33_6_3 25234.66833556899
R26548 n_32_6_3 n_32_7_3 990.7005579606339
R26549 n_32_6_3 n_32_6_4 92.46570283774201
R26550 n_32_6_4 n_33_6_4 764.6869192596663
R26551 n_32_6_4 n_32_7_4 30.021229029110113
R26552 n_32_6_4 n_32_6_5 76.4257339781337
R26553 n_32_6_5 n_33_6_5 4806.603492489332
R26554 n_32_6_5 n_32_7_5 188.7048681829779
R26555 n_32_6_5 n_32_6_6 26.418772239354862
R26556 n_32_6_6 n_33_6_6 801.1005820815552
R26557 n_32_6_6 n_32_7_6 31.450811363829644
R26558 n_32_6_6 n_32_6_7 35.854048039124415
R26559 n_32_6_7 n_33_6_7 1373.3152835683848
R26560 n_32_6_7 n_32_7_7 53.91567662370813
R26561 n_32_6_7 n_32_6_8 26.41877223935478
R26562 n_32_6_8 n_33_6_8 1373.3152835683848
R26563 n_32_6_8 n_32_7_8 53.91567662370813
R26564 n_32_6_8 n_32_6_9 26.41877223935478
R26565 n_32_6_9 n_33_6_9 1373.3152835683848
R26566 n_32_6_9 n_32_7_9 53.91567662370813
R26567 n_32_6_9 n_32_6_10 26.41877223935478
R26568 n_32_6_10 n_33_6_10 1373.3152835683848
R26569 n_32_6_10 n_32_7_10 53.91567662370813
R26570 n_32_6_10 n_32_6_11 26.41877223935461
R26571 n_32_6_11 n_33_6_11 1373.315283568402
R26572 n_32_6_11 n_32_7_11 53.915676623708805
R26573 n_32_6_11 n_32_6_12 26.418772239354524
R26574 n_32_6_12 n_33_6_12 1373.3152835683932
R26575 n_32_6_12 n_32_7_12 53.91567662370848
R26576 n_32_6_12 n_32_6_13 26.41877223935478
R26577 n_32_6_13 n_33_6_13 1373.3152835683761
R26578 n_32_6_13 n_32_7_13 53.915676623707796
R26579 n_32_6_13 n_32_6_14 132.0938611967742
R26580 n_32_6_14 n_33_6_14 152.59058706315352
R26581 n_32_6_14 n_32_7_14 5.990630735967558
R26582 n_32_6_14 n_32_6_15 4081.700310980361
R26583 n_32_6_15 n_33_6_15 50469.33667113753
R26584 n_32_6_15 n_32_7_15 1981.40111592125
R26585 n_32_7_0 n_33_7_0 720.990523873413
R26586 n_32_7_0 n_32_8_0 827.2137876682006
R26587 n_32_7_0 n_32_7_1 3269.323064620219
R26588 n_32_7_1 n_33_7_1 1009.3867334227783
R26589 n_32_7_1 n_32_8_1 1158.0993027354807
R26590 n_32_7_1 n_32_7_2 7430.27969231868
R26591 n_32_7_2 n_33_7_2 1802.476309683533
R26592 n_32_7_2 n_32_8_2 2068.0344691705013
R26593 n_32_7_2 n_32_7_3 6954.741792010284
R26594 n_32_7_3 n_33_7_3 25234.66833556944
R26595 n_32_7_3 n_32_8_3 28952.482568386997
R26596 n_32_7_3 n_32_7_4 92.46570283774365
R26597 n_32_7_4 n_33_7_4 764.6869192596799
R26598 n_32_7_4 n_32_8_4 877.3479566177876
R26599 n_32_7_4 n_32_7_5 76.42573397813506
R26600 n_32_7_5 n_33_7_5 4806.603492489417
R26601 n_32_7_5 n_32_8_5 5514.758584454666
R26602 n_32_7_5 n_32_7_6 26.41877223935533
R26603 n_32_7_6 n_33_7_6 801.1005820815694
R26604 n_32_7_6 n_32_8_6 919.1264307424442
R26605 n_32_7_6 n_32_7_7 35.85404803912505
R26606 n_32_7_7 n_33_7_7 1373.315283568409
R26607 n_32_7_7 n_32_8_7 1575.6453098441948
R26608 n_32_7_7 n_32_7_8 26.41877223935525
R26609 n_32_7_8 n_33_7_8 1373.315283568409
R26610 n_32_7_8 n_32_8_8 1575.6453098441948
R26611 n_32_7_8 n_32_7_9 26.41877223935525
R26612 n_32_7_9 n_33_7_9 1373.315283568409
R26613 n_32_7_9 n_32_8_9 1575.6453098441948
R26614 n_32_7_9 n_32_7_10 26.41877223935525
R26615 n_32_7_10 n_33_7_10 1373.315283568409
R26616 n_32_7_10 n_32_8_10 1575.6453098441948
R26617 n_32_7_10 n_32_7_11 26.41877223935508
R26618 n_32_7_11 n_33_7_11 1373.3152835684264
R26619 n_32_7_11 n_32_8_11 1575.6453098442148
R26620 n_32_7_11 n_32_7_12 26.418772239354993
R26621 n_32_7_12 n_33_7_12 1373.3152835684177
R26622 n_32_7_12 n_32_8_12 1575.645309844205
R26623 n_32_7_12 n_32_7_13 26.41877223935525
R26624 n_32_7_13 n_33_7_13 1373.3152835684004
R26625 n_32_7_13 n_32_8_13 1575.6453098441852
R26626 n_32_7_13 n_32_7_14 132.09386119677657
R26627 n_32_7_14 n_33_7_14 152.59058706315625
R26628 n_32_7_14 n_32_8_14 175.0717010937991
R26629 n_32_7_14 n_32_7_15 4081.7003109804336
R26630 n_32_7_15 n_33_7_15 50469.33667113843
R26631 n_32_7_15 n_32_8_15 57904.96513677348
R26632 n_32_8_0 n_33_8_0 12.55020546380934
R26633 n_32_8_0 n_32_9_0 1626.121845108955
R26634 n_32_8_0 n_32_8_1 56.90875931090387
R26635 n_32_8_1 n_33_8_1 17.570287649333075
R26636 n_32_8_1 n_32_9_1 2276.5705831525374
R26637 n_32_8_1 n_32_8_2 129.33808934296334
R26638 n_32_8_2 n_33_8_2 31.375513659523346
R26639 n_32_8_2 n_32_9_2 4065.3046127723874
R26640 n_32_8_2 n_32_8_3 121.06045162501368
R26641 n_32_8_3 n_33_8_3 439.25719123332647
R26642 n_32_8_3 n_32_9_3 56914.26457881338
R26643 n_32_8_3 n_32_8_4 1.6095406673791008
R26644 n_32_8_4 n_33_8_4 13.31082397676747
R26645 n_32_8_4 n_32_9_4 1724.6746842064658
R26646 n_32_8_4 n_32_8_5 1.3303346332419097
R26647 n_32_8_5 n_33_8_5 83.66803642539553
R26648 n_32_8_5 n_32_9_5 10840.812300726358
R26649 n_32_8_5 n_32_8_6 0.4598687621083145
R26650 n_32_8_6 n_33_8_6 13.944672737565922
R26651 n_32_8_6 n_32_9_6 1806.8020501210594
R26652 n_32_8_6 n_32_8_7 0.624107605718426
R26653 n_32_8_7 n_33_8_7 23.905153264398795
R26654 n_32_8_7 n_32_9_7 3097.374943064683
R26655 n_32_8_7 n_32_8_8 0.45986876210831307
R26656 n_32_8_8 n_33_8_8 23.905153264398795
R26657 n_32_8_8 n_32_9_8 3097.374943064683
R26658 n_32_8_8 n_32_8_9 0.45986876210831307
R26659 n_32_8_9 n_33_8_9 23.905153264398795
R26660 n_32_8_9 n_32_9_9 3097.374943064683
R26661 n_32_8_9 n_32_8_10 0.45986876210831307
R26662 n_32_8_10 n_33_8_10 23.905153264398795
R26663 n_32_8_10 n_32_9_10 3097.374943064683
R26664 n_32_8_10 n_32_8_11 0.4598687621083101
R26665 n_32_8_11 n_33_8_11 23.9051532643991
R26666 n_32_8_11 n_32_9_11 3097.374943064722
R26667 n_32_8_11 n_32_8_12 0.4598687621083086
R26668 n_32_8_12 n_33_8_12 23.905153264398947
R26669 n_32_8_12 n_32_9_12 3097.374943064703
R26670 n_32_8_12 n_32_8_13 0.45986876210831307
R26671 n_32_8_13 n_33_8_13 23.905153264398642
R26672 n_32_8_13 n_32_9_13 3097.374943064664
R26673 n_32_8_13 n_32_8_14 2.299343810541571
R26674 n_32_8_14 n_33_8_14 2.6561281404887493
R26675 n_32_8_14 n_32_9_14 344.15277145163077
R26676 n_32_8_14 n_32_8_15 71.04972374573519
R26677 n_32_8_15 n_33_8_15 878.5143824666451
R26678 n_32_8_15 n_32_9_15 113828.52915762574
R26679 n_32_9_0 n_33_9_0 12.550205463809329
R26680 n_32_9_0 n_32_10_0 1626.121845108955
R26681 n_32_9_0 n_32_9_1 56.90875931090384
R26682 n_32_9_1 n_33_9_1 17.570287649333064
R26683 n_32_9_1 n_32_10_1 2276.5705831525374
R26684 n_32_9_1 n_32_9_2 129.33808934296326
R26685 n_32_9_2 n_33_9_2 31.375513659523328
R26686 n_32_9_2 n_32_10_2 4065.3046127723874
R26687 n_32_9_2 n_32_9_3 121.06045162501361
R26688 n_32_9_3 n_33_9_3 439.25719123332624
R26689 n_32_9_3 n_32_10_3 56914.26457881338
R26690 n_32_9_3 n_32_9_4 1.6095406673791
R26691 n_32_9_4 n_33_9_4 13.31082397676746
R26692 n_32_9_4 n_32_10_4 1724.6746842064658
R26693 n_32_9_4 n_32_9_5 1.330334633241909
R26694 n_32_9_5 n_33_9_5 83.66803642539547
R26695 n_32_9_5 n_32_10_5 10840.812300726358
R26696 n_32_9_5 n_32_9_6 0.45986876210831423
R26697 n_32_9_6 n_33_9_6 13.944672737565911
R26698 n_32_9_6 n_32_10_6 1806.8020501210594
R26699 n_32_9_6 n_32_9_7 0.6241076057184257
R26700 n_32_9_7 n_33_9_7 23.90515326439878
R26701 n_32_9_7 n_32_10_7 3097.374943064683
R26702 n_32_9_7 n_32_9_8 0.4598687621083128
R26703 n_32_9_8 n_33_9_8 23.90515326439878
R26704 n_32_9_8 n_32_10_8 3097.374943064683
R26705 n_32_9_8 n_32_9_9 0.4598687621083128
R26706 n_32_9_9 n_33_9_9 23.90515326439878
R26707 n_32_9_9 n_32_10_9 3097.374943064683
R26708 n_32_9_9 n_32_9_10 0.4598687621083128
R26709 n_32_9_10 n_33_9_10 23.90515326439878
R26710 n_32_9_10 n_32_10_10 3097.374943064683
R26711 n_32_9_10 n_32_9_11 0.45986876210830985
R26712 n_32_9_11 n_33_9_11 23.905153264399083
R26713 n_32_9_11 n_32_10_11 3097.374943064722
R26714 n_32_9_11 n_32_9_12 0.4598687621083084
R26715 n_32_9_12 n_33_9_12 23.905153264398933
R26716 n_32_9_12 n_32_10_12 3097.374943064703
R26717 n_32_9_12 n_32_9_13 0.45986876210831285
R26718 n_32_9_13 n_33_9_13 23.905153264398624
R26719 n_32_9_13 n_32_10_13 3097.374943064664
R26720 n_32_9_13 n_32_9_14 2.29934381054157
R26721 n_32_9_14 n_33_9_14 2.6561281404887476
R26722 n_32_9_14 n_32_10_14 344.15277145163077
R26723 n_32_9_14 n_32_9_15 71.04972374573515
R26724 n_32_9_15 n_33_9_15 878.5143824666446
R26725 n_32_9_15 n_32_10_15 113828.52915762574
R26726 n_32_10_0 n_33_10_0 12.55020546380934
R26727 n_32_10_0 n_32_11_0 1626.1218451089546
R26728 n_32_10_0 n_32_10_1 56.90875931090387
R26729 n_32_10_1 n_33_10_1 17.570287649333075
R26730 n_32_10_1 n_32_11_1 2276.5705831525365
R26731 n_32_10_1 n_32_10_2 129.33808934296334
R26732 n_32_10_2 n_33_10_2 31.375513659523346
R26733 n_32_10_2 n_32_11_2 4065.3046127723865
R26734 n_32_10_2 n_32_10_3 121.06045162501368
R26735 n_32_10_3 n_33_10_3 439.25719123332647
R26736 n_32_10_3 n_32_11_3 56914.26457881337
R26737 n_32_10_3 n_32_10_4 1.6095406673791008
R26738 n_32_10_4 n_33_10_4 13.31082397676747
R26739 n_32_10_4 n_32_11_4 1724.6746842064654
R26740 n_32_10_4 n_32_10_5 1.3303346332419097
R26741 n_32_10_5 n_33_10_5 83.66803642539553
R26742 n_32_10_5 n_32_11_5 10840.812300726355
R26743 n_32_10_5 n_32_10_6 0.4598687621083145
R26744 n_32_10_6 n_33_10_6 13.944672737565922
R26745 n_32_10_6 n_32_11_6 1806.802050121059
R26746 n_32_10_6 n_32_10_7 0.624107605718426
R26747 n_32_10_7 n_33_10_7 23.905153264398795
R26748 n_32_10_7 n_32_11_7 3097.374943064682
R26749 n_32_10_7 n_32_10_8 0.45986876210831307
R26750 n_32_10_8 n_33_10_8 23.905153264398795
R26751 n_32_10_8 n_32_11_8 3097.374943064682
R26752 n_32_10_8 n_32_10_9 0.45986876210831307
R26753 n_32_10_9 n_33_10_9 23.905153264398795
R26754 n_32_10_9 n_32_11_9 3097.374943064682
R26755 n_32_10_9 n_32_10_10 0.45986876210831307
R26756 n_32_10_10 n_33_10_10 23.905153264398795
R26757 n_32_10_10 n_32_11_10 3097.374943064682
R26758 n_32_10_10 n_32_10_11 0.4598687621083101
R26759 n_32_10_11 n_33_10_11 23.9051532643991
R26760 n_32_10_11 n_32_11_11 3097.3749430647213
R26761 n_32_10_11 n_32_10_12 0.4598687621083086
R26762 n_32_10_12 n_33_10_12 23.905153264398947
R26763 n_32_10_12 n_32_11_12 3097.374943064702
R26764 n_32_10_12 n_32_10_13 0.45986876210831307
R26765 n_32_10_13 n_33_10_13 23.905153264398642
R26766 n_32_10_13 n_32_11_13 3097.374943064663
R26767 n_32_10_13 n_32_10_14 2.299343810541571
R26768 n_32_10_14 n_33_10_14 2.6561281404887493
R26769 n_32_10_14 n_32_11_14 344.1527714516307
R26770 n_32_10_14 n_32_10_15 71.04972374573519
R26771 n_32_10_15 n_33_10_15 878.5143824666451
R26772 n_32_10_15 n_32_11_15 113828.52915762572
R26773 n_32_11_0 n_33_11_0 12.55020546380934
R26774 n_32_11_0 n_32_12_0 827.2138119611456
R26775 n_32_11_0 n_32_11_1 56.90875931090387
R26776 n_32_11_1 n_33_11_1 17.570287649333075
R26777 n_32_11_1 n_32_12_1 1158.0993367456038
R26778 n_32_11_1 n_32_11_2 129.33808934296334
R26779 n_32_11_2 n_33_11_2 31.375513659523346
R26780 n_32_11_2 n_32_12_2 2068.034529902864
R26781 n_32_11_2 n_32_11_3 121.06045162501368
R26782 n_32_11_3 n_33_11_3 439.25719123332647
R26783 n_32_11_3 n_32_12_3 28952.483418640073
R26784 n_32_11_3 n_32_11_4 1.6095406673791008
R26785 n_32_11_4 n_33_11_4 13.31082397676747
R26786 n_32_11_4 n_32_12_4 877.3479823830323
R26787 n_32_11_4 n_32_11_5 1.3303346332419097
R26788 n_32_11_5 n_33_11_5 83.66803642539553
R26789 n_32_11_5 n_32_12_5 5514.758746407632
R26790 n_32_11_5 n_32_11_6 0.4598687621083145
R26791 n_32_11_6 n_33_11_6 13.944672737565922
R26792 n_32_11_6 n_32_12_6 919.1264577346053
R26793 n_32_11_6 n_32_11_7 0.624107605718426
R26794 n_32_11_7 n_33_11_7 23.905153264398795
R26795 n_32_11_7 n_32_12_7 1575.6453561164712
R26796 n_32_11_7 n_32_11_8 0.45986876210831307
R26797 n_32_11_8 n_33_11_8 23.905153264398795
R26798 n_32_11_8 n_32_12_8 1575.6453561164712
R26799 n_32_11_8 n_32_11_9 0.45986876210831307
R26800 n_32_11_9 n_33_11_9 23.905153264398795
R26801 n_32_11_9 n_32_12_9 1575.6453561164712
R26802 n_32_11_9 n_32_11_10 0.45986876210831307
R26803 n_32_11_10 n_33_11_10 23.905153264398795
R26804 n_32_11_10 n_32_12_10 1575.6453561164712
R26805 n_32_11_10 n_32_11_11 0.4598687621083101
R26806 n_32_11_11 n_33_11_11 23.9051532643991
R26807 n_32_11_11 n_32_12_11 1575.645356116491
R26808 n_32_11_11 n_32_11_12 0.4598687621083086
R26809 n_32_11_12 n_33_11_12 23.905153264398947
R26810 n_32_11_12 n_32_12_12 1575.6453561164815
R26811 n_32_11_12 n_32_11_13 0.45986876210831307
R26812 n_32_11_13 n_33_11_13 23.905153264398642
R26813 n_32_11_13 n_32_12_13 1575.6453561164615
R26814 n_32_11_13 n_32_11_14 2.299343810541571
R26815 n_32_11_14 n_33_11_14 2.6561281404887493
R26816 n_32_11_14 n_32_12_14 175.07170623516313
R26817 n_32_11_14 n_32_11_15 71.04972374573519
R26818 n_32_11_15 n_33_11_15 878.5143824666451
R26819 n_32_11_15 n_32_12_15 57904.96683727963
R26820 n_32_12_0 n_33_12_0 720.9892863181212
R26821 n_32_12_0 n_32_13_0 28.305778813336563
R26822 n_32_12_0 n_32_12_1 3269.3174529402795
R26823 n_32_12_1 n_33_12_1 1009.3850008453699
R26824 n_32_12_1 n_32_13_1 39.628090338671186
R26825 n_32_12_1 n_32_12_2 7430.266938500636
R26826 n_32_12_2 n_33_12_2 1802.4732157953035
R26827 n_32_12_2 n_32_13_2 70.7644470333414
R26828 n_32_12_2 n_32_12_3 6954.729854436595
R26829 n_32_12_3 n_33_12_3 25234.625021134223
R26830 n_32_12_3 n_32_13_3 990.7022584667787
R26831 n_32_12_3 n_32_12_4 92.46554412356353
R26832 n_32_12_4 n_33_12_4 764.6856067010372
R26833 n_32_12_4 n_32_13_4 30.02128055959935
R26834 n_32_12_4 n_32_12_5 76.42560279600659
R26835 n_32_12_5 n_33_12_5 4806.595242120804
R26836 n_32_12_5 n_32_13_5 188.70519208891025
R26837 n_32_12_5 n_32_12_6 26.418726892446728
R26838 n_32_12_6 n_33_12_6 801.0992070201341
R26839 n_32_12_6 n_32_13_6 31.450865348151705
R26840 n_32_12_6 n_32_12_7 35.85398649689195
R26841 n_32_12_7 n_33_12_7 1373.312926320234
R26842 n_32_12_7 n_32_13_7 53.91576916826023
R26843 n_32_12_7 n_32_12_8 26.418726892446646
R26844 n_32_12_8 n_33_12_8 1373.312926320234
R26845 n_32_12_8 n_32_13_8 53.91576916826023
R26846 n_32_12_8 n_32_12_9 26.418726892446646
R26847 n_32_12_9 n_33_12_9 1373.312926320234
R26848 n_32_12_9 n_32_13_9 53.91576916826023
R26849 n_32_12_9 n_32_12_10 26.418726892446646
R26850 n_32_12_10 n_33_12_10 1373.312926320234
R26851 n_32_12_10 n_32_13_10 53.91576916826023
R26852 n_32_12_10 n_32_12_11 26.41872689244648
R26853 n_32_12_11 n_33_12_11 1373.3129263202516
R26854 n_32_12_11 n_32_13_11 53.91576916826091
R26855 n_32_12_11 n_32_12_12 26.418726892446394
R26856 n_32_12_12 n_33_12_12 1373.312926320243
R26857 n_32_12_12 n_32_13_12 53.91576916826058
R26858 n_32_12_12 n_32_12_13 26.41872689244665
R26859 n_32_12_13 n_33_12_13 1373.3129263202254
R26860 n_32_12_13 n_32_13_13 53.9157691682599
R26861 n_32_12_13 n_32_12_14 132.09363446223358
R26862 n_32_12_14 n_33_12_14 152.59032514669235
R26863 n_32_12_14 n_32_13_14 5.99064101869557
R26864 n_32_12_14 n_32_12_15 4081.6933048830547
R26865 n_32_12_15 n_33_12_15 50469.250042268
R26866 n_32_12_15 n_32_13_15 1981.40451693354
R26867 n_32_13_0 n_33_13_0 720.9892863181212
R26868 n_32_13_0 n_32_14_0 28.305778813336563
R26869 n_32_13_0 n_32_13_1 3269.3174529402795
R26870 n_32_13_1 n_33_13_1 1009.3850008453699
R26871 n_32_13_1 n_32_14_1 39.628090338671186
R26872 n_32_13_1 n_32_13_2 7430.266938500636
R26873 n_32_13_2 n_33_13_2 1802.4732157953035
R26874 n_32_13_2 n_32_14_2 70.7644470333414
R26875 n_32_13_2 n_32_13_3 6954.729854436595
R26876 n_32_13_3 n_33_13_3 25234.625021134223
R26877 n_32_13_3 n_32_14_3 990.7022584667787
R26878 n_32_13_3 n_32_13_4 92.46554412356353
R26879 n_32_13_4 n_33_13_4 764.6856067010372
R26880 n_32_13_4 n_32_14_4 30.02128055959935
R26881 n_32_13_4 n_32_13_5 76.42560279600659
R26882 n_32_13_5 n_33_13_5 4806.595242120804
R26883 n_32_13_5 n_32_14_5 188.70519208891025
R26884 n_32_13_5 n_32_13_6 26.418726892446728
R26885 n_32_13_6 n_33_13_6 801.0992070201341
R26886 n_32_13_6 n_32_14_6 31.450865348151705
R26887 n_32_13_6 n_32_13_7 35.85398649689195
R26888 n_32_13_7 n_33_13_7 1373.312926320234
R26889 n_32_13_7 n_32_14_7 53.91576916826023
R26890 n_32_13_7 n_32_13_8 26.418726892446646
R26891 n_32_13_8 n_33_13_8 1373.312926320234
R26892 n_32_13_8 n_32_14_8 53.91576916826023
R26893 n_32_13_8 n_32_13_9 26.418726892446646
R26894 n_32_13_9 n_33_13_9 1373.312926320234
R26895 n_32_13_9 n_32_14_9 53.91576916826023
R26896 n_32_13_9 n_32_13_10 26.418726892446646
R26897 n_32_13_10 n_33_13_10 1373.312926320234
R26898 n_32_13_10 n_32_14_10 53.91576916826023
R26899 n_32_13_10 n_32_13_11 26.41872689244648
R26900 n_32_13_11 n_33_13_11 1373.3129263202516
R26901 n_32_13_11 n_32_14_11 53.91576916826091
R26902 n_32_13_11 n_32_13_12 26.418726892446394
R26903 n_32_13_12 n_33_13_12 1373.312926320243
R26904 n_32_13_12 n_32_14_12 53.91576916826058
R26905 n_32_13_12 n_32_13_13 26.41872689244665
R26906 n_32_13_13 n_33_13_13 1373.3129263202254
R26907 n_32_13_13 n_32_14_13 53.9157691682599
R26908 n_32_13_13 n_32_13_14 132.09363446223358
R26909 n_32_13_14 n_33_13_14 152.59032514669235
R26910 n_32_13_14 n_32_14_14 5.99064101869557
R26911 n_32_13_14 n_32_13_15 4081.6933048830547
R26912 n_32_13_15 n_33_13_15 50469.250042268
R26913 n_32_13_15 n_32_14_15 1981.40451693354
R26914 n_32_14_0 n_33_14_0 720.9892863181212
R26915 n_32_14_0 n_32_15_0 28.305778813336563
R26916 n_32_14_0 n_32_14_1 3269.3174529402795
R26917 n_32_14_1 n_33_14_1 1009.3850008453699
R26918 n_32_14_1 n_32_15_1 39.628090338671186
R26919 n_32_14_1 n_32_14_2 7430.266938500636
R26920 n_32_14_2 n_33_14_2 1802.4732157953035
R26921 n_32_14_2 n_32_15_2 70.7644470333414
R26922 n_32_14_2 n_32_14_3 6954.729854436595
R26923 n_32_14_3 n_33_14_3 25234.625021134223
R26924 n_32_14_3 n_32_15_3 990.7022584667787
R26925 n_32_14_3 n_32_14_4 92.46554412356353
R26926 n_32_14_4 n_33_14_4 764.6856067010372
R26927 n_32_14_4 n_32_15_4 30.02128055959935
R26928 n_32_14_4 n_32_14_5 76.42560279600659
R26929 n_32_14_5 n_33_14_5 4806.595242120804
R26930 n_32_14_5 n_32_15_5 188.70519208891025
R26931 n_32_14_5 n_32_14_6 26.418726892446728
R26932 n_32_14_6 n_33_14_6 801.0992070201341
R26933 n_32_14_6 n_32_15_6 31.450865348151705
R26934 n_32_14_6 n_32_14_7 35.85398649689195
R26935 n_32_14_7 n_33_14_7 1373.312926320234
R26936 n_32_14_7 n_32_15_7 53.91576916826023
R26937 n_32_14_7 n_32_14_8 26.418726892446646
R26938 n_32_14_8 n_33_14_8 1373.312926320234
R26939 n_32_14_8 n_32_15_8 53.91576916826023
R26940 n_32_14_8 n_32_14_9 26.418726892446646
R26941 n_32_14_9 n_33_14_9 1373.312926320234
R26942 n_32_14_9 n_32_15_9 53.91576916826023
R26943 n_32_14_9 n_32_14_10 26.418726892446646
R26944 n_32_14_10 n_33_14_10 1373.312926320234
R26945 n_32_14_10 n_32_15_10 53.91576916826023
R26946 n_32_14_10 n_32_14_11 26.41872689244648
R26947 n_32_14_11 n_33_14_11 1373.3129263202516
R26948 n_32_14_11 n_32_15_11 53.91576916826091
R26949 n_32_14_11 n_32_14_12 26.418726892446394
R26950 n_32_14_12 n_33_14_12 1373.312926320243
R26951 n_32_14_12 n_32_15_12 53.91576916826058
R26952 n_32_14_12 n_32_14_13 26.41872689244665
R26953 n_32_14_13 n_33_14_13 1373.3129263202254
R26954 n_32_14_13 n_32_15_13 53.9157691682599
R26955 n_32_14_13 n_32_14_14 132.09363446223358
R26956 n_32_14_14 n_33_14_14 152.59032514669235
R26957 n_32_14_14 n_32_15_14 5.99064101869557
R26958 n_32_14_14 n_32_14_15 4081.6933048830547
R26959 n_32_14_15 n_33_14_15 50469.250042268
R26960 n_32_14_15 n_32_15_15 1981.40451693354
R26961 n_32_15_0 n_33_15_0 720.9892863181212
R26962 n_32_15_0 n_32_16_0 827.2138119611451
R26963 n_32_15_0 n_32_15_1 3269.3174529402795
R26964 n_32_15_1 n_33_15_1 1009.3850008453699
R26965 n_32_15_1 n_32_16_1 1158.099336745603
R26966 n_32_15_1 n_32_15_2 7430.266938500636
R26967 n_32_15_2 n_33_15_2 1802.4732157953035
R26968 n_32_15_2 n_32_16_2 2068.0345299028627
R26969 n_32_15_2 n_32_15_3 6954.729854436595
R26970 n_32_15_3 n_33_15_3 25234.625021134223
R26971 n_32_15_3 n_32_16_3 28952.483418640055
R26972 n_32_15_3 n_32_15_4 92.46554412356353
R26973 n_32_15_4 n_33_15_4 764.6856067010372
R26974 n_32_15_4 n_32_16_4 877.3479823830318
R26975 n_32_15_4 n_32_15_5 76.42560279600659
R26976 n_32_15_5 n_33_15_5 4806.595242120804
R26977 n_32_15_5 n_32_16_5 5514.75874640763
R26978 n_32_15_5 n_32_15_6 26.418726892446728
R26979 n_32_15_6 n_33_15_6 801.0992070201341
R26980 n_32_15_6 n_32_16_6 919.1264577346047
R26981 n_32_15_6 n_32_15_7 35.85398649689195
R26982 n_32_15_7 n_33_15_7 1373.312926320234
R26983 n_32_15_7 n_32_16_7 1575.6453561164703
R26984 n_32_15_7 n_32_15_8 26.418726892446646
R26985 n_32_15_8 n_33_15_8 1373.312926320234
R26986 n_32_15_8 n_32_16_8 1575.6453561164703
R26987 n_32_15_8 n_32_15_9 26.418726892446646
R26988 n_32_15_9 n_33_15_9 1373.312926320234
R26989 n_32_15_9 n_32_16_9 1575.6453561164703
R26990 n_32_15_9 n_32_15_10 26.418726892446646
R26991 n_32_15_10 n_33_15_10 1373.312926320234
R26992 n_32_15_10 n_32_16_10 1575.6453561164703
R26993 n_32_15_10 n_32_15_11 26.41872689244648
R26994 n_32_15_11 n_33_15_11 1373.3129263202516
R26995 n_32_15_11 n_32_16_11 1575.6453561164901
R26996 n_32_15_11 n_32_15_12 26.418726892446394
R26997 n_32_15_12 n_33_15_12 1373.312926320243
R26998 n_32_15_12 n_32_16_12 1575.6453561164806
R26999 n_32_15_12 n_32_15_13 26.41872689244665
R27000 n_32_15_13 n_33_15_13 1373.3129263202254
R27001 n_32_15_13 n_32_16_13 1575.6453561164606
R27002 n_32_15_13 n_32_15_14 132.09363446223358
R27003 n_32_15_14 n_33_15_14 152.59032514669235
R27004 n_32_15_14 n_32_16_14 175.07170623516302
R27005 n_32_15_14 n_32_15_15 4081.6933048830547
R27006 n_32_15_15 n_33_15_15 50469.250042268
R27007 n_32_15_15 n_32_16_15 57904.96683727959
R27008 n_32_16_0 n_33_16_0 12.550205463809348
R27009 n_32_16_0 n_32_17_0 1626.1218451089546
R27010 n_32_16_0 n_32_16_1 56.9087593109039
R27011 n_32_16_1 n_33_16_1 17.570287649333086
R27012 n_32_16_1 n_32_17_1 2276.5705831525365
R27013 n_32_16_1 n_32_16_2 129.33808934296343
R27014 n_32_16_2 n_33_16_2 31.375513659523367
R27015 n_32_16_2 n_32_17_2 4065.3046127723865
R27016 n_32_16_2 n_32_16_3 121.06045162501377
R27017 n_32_16_3 n_33_16_3 439.2571912333267
R27018 n_32_16_3 n_32_17_3 56914.26457881337
R27019 n_32_16_3 n_32_16_4 1.6095406673791017
R27020 n_32_16_4 n_33_16_4 13.310823976767475
R27021 n_32_16_4 n_32_17_4 1724.6746842064654
R27022 n_32_16_4 n_32_16_5 1.3303346332419106
R27023 n_32_16_5 n_33_16_5 83.66803642539557
R27024 n_32_16_5 n_32_17_5 10840.812300726357
R27025 n_32_16_5 n_32_16_6 0.45986876210831473
R27026 n_32_16_6 n_33_16_6 13.944672737565929
R27027 n_32_16_6 n_32_17_6 1806.802050121059
R27028 n_32_16_6 n_32_16_7 0.6241076057184265
R27029 n_32_16_7 n_33_16_7 23.905153264398805
R27030 n_32_16_7 n_32_17_7 3097.374943064682
R27031 n_32_16_7 n_32_16_8 0.4598687621083133
R27032 n_32_16_8 n_33_16_8 23.905153264398805
R27033 n_32_16_8 n_32_17_8 3097.374943064682
R27034 n_32_16_8 n_32_16_9 0.4598687621083133
R27035 n_32_16_9 n_33_16_9 23.905153264398805
R27036 n_32_16_9 n_32_17_9 3097.374943064682
R27037 n_32_16_9 n_32_16_10 0.4598687621083133
R27038 n_32_16_10 n_33_16_10 23.905153264398805
R27039 n_32_16_10 n_32_17_10 3097.374943064682
R27040 n_32_16_10 n_32_16_11 0.45986876210831035
R27041 n_32_16_11 n_33_16_11 23.905153264399114
R27042 n_32_16_11 n_32_17_11 3097.3749430647213
R27043 n_32_16_11 n_32_16_12 0.45986876210830885
R27044 n_32_16_12 n_33_16_12 23.905153264398958
R27045 n_32_16_12 n_32_17_12 3097.374943064702
R27046 n_32_16_12 n_32_16_13 0.4598687621083133
R27047 n_32_16_13 n_33_16_13 23.905153264398656
R27048 n_32_16_13 n_32_17_13 3097.374943064663
R27049 n_32_16_13 n_32_16_14 2.2993438105415724
R27050 n_32_16_14 n_33_16_14 2.6561281404887507
R27051 n_32_16_14 n_32_17_14 344.15277145163066
R27052 n_32_16_14 n_32_16_15 71.04972374573525
R27053 n_32_16_15 n_33_16_15 878.5143824666457
R27054 n_32_16_15 n_32_17_15 113828.52915762572
R27055 n_32_17_0 n_33_17_0 12.550205463809329
R27056 n_32_17_0 n_32_18_0 1626.1218451089555
R27057 n_32_17_0 n_32_17_1 56.90875931090384
R27058 n_32_17_1 n_33_17_1 17.570287649333064
R27059 n_32_17_1 n_32_18_1 2276.570583152538
R27060 n_32_17_1 n_32_17_2 129.33808934296326
R27061 n_32_17_2 n_33_17_2 31.375513659523328
R27062 n_32_17_2 n_32_18_2 4065.3046127723887
R27063 n_32_17_2 n_32_17_3 121.06045162501361
R27064 n_32_17_3 n_33_17_3 439.25719123332624
R27065 n_32_17_3 n_32_18_3 56914.264578813396
R27066 n_32_17_3 n_32_17_4 1.6095406673791
R27067 n_32_17_4 n_33_17_4 13.31082397676746
R27068 n_32_17_4 n_32_18_4 1724.6746842064663
R27069 n_32_17_4 n_32_17_5 1.330334633241909
R27070 n_32_17_5 n_33_17_5 83.66803642539547
R27071 n_32_17_5 n_32_18_5 10840.812300726362
R27072 n_32_17_5 n_32_17_6 0.45986876210831423
R27073 n_32_17_6 n_33_17_6 13.944672737565911
R27074 n_32_17_6 n_32_18_6 1806.8020501210601
R27075 n_32_17_6 n_32_17_7 0.6241076057184257
R27076 n_32_17_7 n_33_17_7 23.90515326439878
R27077 n_32_17_7 n_32_18_7 3097.374943064684
R27078 n_32_17_7 n_32_17_8 0.4598687621083128
R27079 n_32_17_8 n_33_17_8 23.90515326439878
R27080 n_32_17_8 n_32_18_8 3097.374943064684
R27081 n_32_17_8 n_32_17_9 0.4598687621083128
R27082 n_32_17_9 n_33_17_9 23.90515326439878
R27083 n_32_17_9 n_32_18_9 3097.374943064684
R27084 n_32_17_9 n_32_17_10 0.4598687621083128
R27085 n_32_17_10 n_33_17_10 23.90515326439878
R27086 n_32_17_10 n_32_18_10 3097.374943064684
R27087 n_32_17_10 n_32_17_11 0.45986876210830985
R27088 n_32_17_11 n_33_17_11 23.905153264399083
R27089 n_32_17_11 n_32_18_11 3097.374943064723
R27090 n_32_17_11 n_32_17_12 0.4598687621083084
R27091 n_32_17_12 n_33_17_12 23.905153264398933
R27092 n_32_17_12 n_32_18_12 3097.374943064704
R27093 n_32_17_12 n_32_17_13 0.45986876210831285
R27094 n_32_17_13 n_33_17_13 23.905153264398624
R27095 n_32_17_13 n_32_18_13 3097.3749430646653
R27096 n_32_17_13 n_32_17_14 2.29934381054157
R27097 n_32_17_14 n_33_17_14 2.6561281404887476
R27098 n_32_17_14 n_32_18_14 344.1527714516309
R27099 n_32_17_14 n_32_17_15 71.04972374573515
R27100 n_32_17_15 n_33_17_15 878.5143824666446
R27101 n_32_17_15 n_32_18_15 113828.52915762579
R27102 n_32_18_0 n_33_18_0 12.550205463809329
R27103 n_32_18_0 n_32_19_0 1626.1218451089546
R27104 n_32_18_0 n_32_18_1 56.90875931090384
R27105 n_32_18_1 n_33_18_1 17.570287649333064
R27106 n_32_18_1 n_32_19_1 2276.5705831525365
R27107 n_32_18_1 n_32_18_2 129.33808934296326
R27108 n_32_18_2 n_33_18_2 31.375513659523328
R27109 n_32_18_2 n_32_19_2 4065.3046127723865
R27110 n_32_18_2 n_32_18_3 121.06045162501361
R27111 n_32_18_3 n_33_18_3 439.25719123332624
R27112 n_32_18_3 n_32_19_3 56914.26457881337
R27113 n_32_18_3 n_32_18_4 1.6095406673791
R27114 n_32_18_4 n_33_18_4 13.31082397676746
R27115 n_32_18_4 n_32_19_4 1724.6746842064654
R27116 n_32_18_4 n_32_18_5 1.330334633241909
R27117 n_32_18_5 n_33_18_5 83.66803642539547
R27118 n_32_18_5 n_32_19_5 10840.812300726357
R27119 n_32_18_5 n_32_18_6 0.45986876210831423
R27120 n_32_18_6 n_33_18_6 13.944672737565911
R27121 n_32_18_6 n_32_19_6 1806.802050121059
R27122 n_32_18_6 n_32_18_7 0.6241076057184257
R27123 n_32_18_7 n_33_18_7 23.90515326439878
R27124 n_32_18_7 n_32_19_7 3097.374943064682
R27125 n_32_18_7 n_32_18_8 0.4598687621083128
R27126 n_32_18_8 n_33_18_8 23.90515326439878
R27127 n_32_18_8 n_32_19_8 3097.374943064682
R27128 n_32_18_8 n_32_18_9 0.4598687621083128
R27129 n_32_18_9 n_33_18_9 23.90515326439878
R27130 n_32_18_9 n_32_19_9 3097.374943064682
R27131 n_32_18_9 n_32_18_10 0.4598687621083128
R27132 n_32_18_10 n_33_18_10 23.90515326439878
R27133 n_32_18_10 n_32_19_10 3097.374943064682
R27134 n_32_18_10 n_32_18_11 0.45986876210830985
R27135 n_32_18_11 n_33_18_11 23.905153264399083
R27136 n_32_18_11 n_32_19_11 3097.3749430647213
R27137 n_32_18_11 n_32_18_12 0.4598687621083084
R27138 n_32_18_12 n_33_18_12 23.905153264398933
R27139 n_32_18_12 n_32_19_12 3097.374943064702
R27140 n_32_18_12 n_32_18_13 0.45986876210831285
R27141 n_32_18_13 n_33_18_13 23.905153264398624
R27142 n_32_18_13 n_32_19_13 3097.374943064663
R27143 n_32_18_13 n_32_18_14 2.29934381054157
R27144 n_32_18_14 n_33_18_14 2.6561281404887476
R27145 n_32_18_14 n_32_19_14 344.15277145163066
R27146 n_32_18_14 n_32_18_15 71.04972374573515
R27147 n_32_18_15 n_33_18_15 878.5143824666446
R27148 n_32_18_15 n_32_19_15 113828.52915762572
R27149 n_32_19_0 n_33_19_0 12.550205463809348
R27150 n_32_19_0 n_32_20_0 827.2138145479913
R27151 n_32_19_0 n_32_19_1 56.9087593109039
R27152 n_32_19_1 n_33_19_1 17.570287649333086
R27153 n_32_19_1 n_32_20_1 1158.0993403671878
R27154 n_32_19_1 n_32_19_2 129.33808934296343
R27155 n_32_19_2 n_33_19_2 31.375513659523367
R27156 n_32_19_2 n_32_20_2 2068.034536369978
R27157 n_32_19_2 n_32_19_3 121.06045162501377
R27158 n_32_19_3 n_33_19_3 439.2571912333267
R27159 n_32_19_3 n_32_20_3 28952.48350917967
R27160 n_32_19_3 n_32_19_4 1.6095406673791017
R27161 n_32_19_4 n_33_19_4 13.310823976767475
R27162 n_32_19_4 n_32_20_4 877.3479851266566
R27163 n_32_19_4 n_32_19_5 1.3303346332419106
R27164 n_32_19_5 n_33_19_5 83.66803642539557
R27165 n_32_19_5 n_32_20_5 5514.758763653271
R27166 n_32_19_5 n_32_19_6 0.45986876210831473
R27167 n_32_19_6 n_33_19_6 13.944672737565929
R27168 n_32_19_6 n_32_20_6 919.1264606088783
R27169 n_32_19_6 n_32_19_7 0.6241076057184265
R27170 n_32_19_7 n_33_19_7 23.905153264398805
R27171 n_32_19_7 n_32_20_7 1575.6453610437964
R27172 n_32_19_7 n_32_19_8 0.4598687621083133
R27173 n_32_19_8 n_33_19_8 23.905153264398805
R27174 n_32_19_8 n_32_20_8 1575.6453610437964
R27175 n_32_19_8 n_32_19_9 0.4598687621083133
R27176 n_32_19_9 n_33_19_9 23.905153264398805
R27177 n_32_19_9 n_32_20_9 1575.6453610437964
R27178 n_32_19_9 n_32_19_10 0.4598687621083133
R27179 n_32_19_10 n_33_19_10 23.905153264398805
R27180 n_32_19_10 n_32_20_10 1575.6453610437964
R27181 n_32_19_10 n_32_19_11 0.45986876210831035
R27182 n_32_19_11 n_33_19_11 23.905153264399114
R27183 n_32_19_11 n_32_20_11 1575.6453610438164
R27184 n_32_19_11 n_32_19_12 0.45986876210830885
R27185 n_32_19_12 n_33_19_12 23.905153264398958
R27186 n_32_19_12 n_32_20_12 1575.6453610438066
R27187 n_32_19_12 n_32_19_13 0.4598687621083133
R27188 n_32_19_13 n_33_19_13 23.905153264398656
R27189 n_32_19_13 n_32_20_13 1575.6453610437866
R27190 n_32_19_13 n_32_19_14 2.2993438105415724
R27191 n_32_19_14 n_33_19_14 2.6561281404887507
R27192 n_32_19_14 n_32_20_14 175.0717067826437
R27193 n_32_19_14 n_32_19_15 71.04972374573525
R27194 n_32_19_15 n_33_19_15 878.5143824666457
R27195 n_32_19_15 n_32_20_15 57904.967018358824
R27196 n_32_20_0 n_33_20_0 720.9891545366875
R27197 n_32_20_0 n_32_21_0 28.305783987028974
R27198 n_32_20_0 n_32_20_1 3269.3168553789146
R27199 n_32_20_1 n_33_20_1 1009.3848163513622
R27200 n_32_20_1 n_32_21_1 39.628097581840564
R27201 n_32_20_1 n_32_20_2 7430.265580406624
R27202 n_32_20_2 n_33_20_2 1802.4728863417188
R27203 n_32_20_2 n_32_21_2 70.76445996757244
R27204 n_32_20_2 n_32_20_3 6954.7285832606
R27205 n_32_20_3 n_33_20_3 25234.620408784034
R27206 n_32_20_3 n_32_21_3 990.7024395460132
R27207 n_32_20_3 n_32_20_4 92.46552722283808
R27208 n_32_20_4 n_33_20_4 764.6854669328496
R27209 n_32_20_4 n_32_21_4 30.021286046848882
R27210 n_32_20_4 n_32_20_5 76.42558882703963
R27211 n_32_20_5 n_33_20_5 4806.594363577911
R27212 n_32_20_5 n_32_21_5 188.705226580193
R27213 n_32_20_5 n_32_20_6 26.41872206366802
R27214 n_32_20_6 n_33_20_6 801.0990605963186
R27215 n_32_20_6 n_32_21_6 31.45087109669883
R27216 n_32_20_6 n_32_20_7 35.85397994354942
R27217 n_32_20_7 n_33_20_7 1373.312675307979
R27218 n_32_20_7 n_32_21_7 53.915779022912446
R27219 n_32_20_7 n_32_20_8 26.41872206366794
R27220 n_32_20_8 n_33_20_8 1373.312675307979
R27221 n_32_20_8 n_32_21_8 53.915779022912446
R27222 n_32_20_8 n_32_20_9 26.41872206366794
R27223 n_32_20_9 n_33_20_9 1373.312675307979
R27224 n_32_20_9 n_32_21_9 53.915779022912446
R27225 n_32_20_9 n_32_20_10 26.41872206366794
R27226 n_32_20_10 n_33_20_10 1373.312675307979
R27227 n_32_20_10 n_32_21_10 53.915779022912446
R27228 n_32_20_10 n_32_20_11 26.418722063667772
R27229 n_32_20_11 n_33_20_11 1373.3126753079966
R27230 n_32_20_11 n_32_21_11 53.91577902291313
R27231 n_32_20_11 n_32_20_12 26.418722063667687
R27232 n_32_20_12 n_33_20_12 1373.3126753079875
R27233 n_32_20_12 n_32_21_12 53.915779022912794
R27234 n_32_20_12 n_32_20_13 26.418722063667936
R27235 n_32_20_13 n_33_20_13 1373.3126753079703
R27236 n_32_20_13 n_32_21_13 53.91577902291212
R27237 n_32_20_13 n_32_20_14 132.09361031834004
R27238 n_32_20_14 n_33_20_14 152.5902972564418
R27239 n_32_20_14 n_32_21_14 5.990642113656927
R27240 n_32_20_14 n_32_20_15 4081.6925588367444
R27241 n_32_20_15 n_33_20_15 50469.24081756762
R27242 n_32_20_15 n_32_21_15 1981.4048790920087
R27243 n_32_21_0 n_33_21_0 720.9891545366875
R27244 n_32_21_0 n_32_22_0 28.30578398702797
R27245 n_32_21_0 n_32_21_1 3269.3168553789146
R27246 n_32_21_1 n_33_21_1 1009.3848163513622
R27247 n_32_21_1 n_32_22_1 39.62809758183916
R27248 n_32_21_1 n_32_21_2 7430.265580406624
R27249 n_32_21_2 n_33_21_2 1802.4728863417188
R27250 n_32_21_2 n_32_22_2 70.76445996756992
R27251 n_32_21_2 n_32_21_3 6954.7285832606
R27252 n_32_21_3 n_33_21_3 25234.620408784034
R27253 n_32_21_3 n_32_22_3 990.702439545978
R27254 n_32_21_3 n_32_21_4 92.46552722283808
R27255 n_32_21_4 n_33_21_4 764.6854669328496
R27256 n_32_21_4 n_32_22_4 30.021286046847816
R27257 n_32_21_4 n_32_21_5 76.42558882703963
R27258 n_32_21_5 n_33_21_5 4806.594363577911
R27259 n_32_21_5 n_32_22_5 188.70522658018632
R27260 n_32_21_5 n_32_21_6 26.41872206366802
R27261 n_32_21_6 n_33_21_6 801.0990605963186
R27262 n_32_21_6 n_32_22_6 31.45087109669771
R27263 n_32_21_6 n_32_21_7 35.85397994354942
R27264 n_32_21_7 n_33_21_7 1373.312675307979
R27265 n_32_21_7 n_32_22_7 53.915779022910534
R27266 n_32_21_7 n_32_21_8 26.41872206366794
R27267 n_32_21_8 n_33_21_8 1373.312675307979
R27268 n_32_21_8 n_32_22_8 53.915779022910534
R27269 n_32_21_8 n_32_21_9 26.41872206366794
R27270 n_32_21_9 n_33_21_9 1373.312675307979
R27271 n_32_21_9 n_32_22_9 53.915779022910534
R27272 n_32_21_9 n_32_21_10 26.41872206366794
R27273 n_32_21_10 n_33_21_10 1373.312675307979
R27274 n_32_21_10 n_32_22_10 53.915779022910534
R27275 n_32_21_10 n_32_21_11 26.418722063667772
R27276 n_32_21_11 n_33_21_11 1373.3126753079966
R27277 n_32_21_11 n_32_22_11 53.91577902291121
R27278 n_32_21_11 n_32_21_12 26.418722063667687
R27279 n_32_21_12 n_33_21_12 1373.3126753079875
R27280 n_32_21_12 n_32_22_12 53.91577902291088
R27281 n_32_21_12 n_32_21_13 26.418722063667936
R27282 n_32_21_13 n_33_21_13 1373.3126753079703
R27283 n_32_21_13 n_32_22_13 53.9157790229102
R27284 n_32_21_13 n_32_21_14 132.09361031834004
R27285 n_32_21_14 n_33_21_14 152.5902972564418
R27286 n_32_21_14 n_32_22_14 5.990642113656714
R27287 n_32_21_14 n_32_21_15 4081.6925588367444
R27288 n_32_21_15 n_33_21_15 50469.24081756762
R27289 n_32_21_15 n_32_22_15 1981.4048790919383
R27290 n_32_22_0 n_33_22_0 720.9891545367386
R27291 n_32_22_0 n_32_23_0 28.30578398702797
R27292 n_32_22_0 n_32_22_1 3269.316855379147
R27293 n_32_22_1 n_33_22_1 1009.384816351434
R27294 n_32_22_1 n_32_23_1 39.62809758183916
R27295 n_32_22_1 n_32_22_2 7430.265580407153
R27296 n_32_22_2 n_33_22_2 1802.4728863418466
R27297 n_32_22_2 n_32_23_2 70.76445996756992
R27298 n_32_22_2 n_32_22_3 6954.728583261095
R27299 n_32_22_3 n_33_22_3 25234.620408785828
R27300 n_32_22_3 n_32_23_3 990.702439545978
R27301 n_32_22_3 n_32_22_4 92.46552722284464
R27302 n_32_22_4 n_33_22_4 764.6854669329039
R27303 n_32_22_4 n_32_23_4 30.021286046847816
R27304 n_32_22_4 n_32_22_5 76.42558882704506
R27305 n_32_22_5 n_33_22_5 4806.594363578253
R27306 n_32_22_5 n_32_23_5 188.70522658018632
R27307 n_32_22_5 n_32_22_6 26.418722063669897
R27308 n_32_22_6 n_33_22_6 801.0990605963755
R27309 n_32_22_6 n_32_23_6 31.45087109669771
R27310 n_32_22_6 n_32_22_7 35.85397994355196
R27311 n_32_22_7 n_33_22_7 1373.3126753080767
R27312 n_32_22_7 n_32_23_7 53.915779022910534
R27313 n_32_22_7 n_32_22_8 26.418722063669815
R27314 n_32_22_8 n_33_22_8 1373.3126753080767
R27315 n_32_22_8 n_32_23_8 53.915779022910534
R27316 n_32_22_8 n_32_22_9 26.418722063669815
R27317 n_32_22_9 n_33_22_9 1373.3126753080767
R27318 n_32_22_9 n_32_23_9 53.915779022910534
R27319 n_32_22_9 n_32_22_10 26.418722063669815
R27320 n_32_22_10 n_33_22_10 1373.3126753080767
R27321 n_32_22_10 n_32_23_10 53.915779022910534
R27322 n_32_22_10 n_32_22_11 26.418722063669648
R27323 n_32_22_11 n_33_22_11 1373.312675308094
R27324 n_32_22_11 n_32_23_11 53.91577902291121
R27325 n_32_22_11 n_32_22_12 26.418722063669563
R27326 n_32_22_12 n_33_22_12 1373.3126753080853
R27327 n_32_22_12 n_32_23_12 53.91577902291088
R27328 n_32_22_12 n_32_22_13 26.41872206366981
R27329 n_32_22_13 n_33_22_13 1373.3126753080678
R27330 n_32_22_13 n_32_23_13 53.9157790229102
R27331 n_32_22_13 n_32_22_14 132.0936103183494
R27332 n_32_22_14 n_33_22_14 152.59029725645263
R27333 n_32_22_14 n_32_23_14 5.990642113656714
R27334 n_32_22_14 n_32_22_15 4081.692558837034
R27335 n_32_22_15 n_33_22_15 50469.240817571204
R27336 n_32_22_15 n_32_23_15 1981.4048790919383
R27337 n_32_23_0 n_33_23_0 720.9891545366875
R27338 n_32_23_0 n_32_24_0 326.2736359366231
R27339 n_32_23_0 n_32_23_1 3269.3168553789146
R27340 n_32_23_1 n_33_23_1 1009.3848163513622
R27341 n_32_23_1 n_32_24_1 456.7830903112724
R27342 n_32_23_1 n_32_23_2 7430.265580406624
R27343 n_32_23_2 n_33_23_2 1802.4728863417188
R27344 n_32_23_2 n_32_24_2 815.6840898415578
R27345 n_32_23_2 n_32_23_3 6954.7285832606
R27346 n_32_23_3 n_33_23_3 25234.620408784034
R27347 n_32_23_3 n_32_24_3 11419.5772577818
R27348 n_32_23_3 n_32_23_4 92.46552722283808
R27349 n_32_23_4 n_33_23_4 764.6854669328496
R27350 n_32_23_4 n_32_24_4 346.04779569035753
R27351 n_32_23_4 n_32_23_5 76.42558882703963
R27352 n_32_23_5 n_33_23_5 4806.594363577911
R27353 n_32_23_5 n_32_24_5 2175.157572910819
R27354 n_32_23_5 n_32_23_6 26.41872206366802
R27355 n_32_23_6 n_33_23_6 801.0990605963186
R27356 n_32_23_6 n_32_24_6 362.52626215180317
R27357 n_32_23_6 n_32_23_7 35.85397994354942
R27358 n_32_23_7 n_33_23_7 1373.312675307979
R27359 n_32_23_7 n_32_24_7 621.4735922602358
R27360 n_32_23_7 n_32_23_8 26.41872206366794
R27361 n_32_23_8 n_33_23_8 1373.312675307979
R27362 n_32_23_8 n_32_24_8 621.4735922602358
R27363 n_32_23_8 n_32_23_9 26.41872206366794
R27364 n_32_23_9 n_33_23_9 1373.312675307979
R27365 n_32_23_9 n_32_24_9 621.4735922602358
R27366 n_32_23_9 n_32_23_10 26.41872206366794
R27367 n_32_23_10 n_33_23_10 1373.312675307979
R27368 n_32_23_10 n_32_24_10 621.4735922602358
R27369 n_32_23_10 n_32_23_11 26.418722063667772
R27370 n_32_23_11 n_33_23_11 1373.3126753079966
R27371 n_32_23_11 n_32_24_11 621.4735922602437
R27372 n_32_23_11 n_32_23_12 26.418722063667687
R27373 n_32_23_12 n_33_23_12 1373.3126753079875
R27374 n_32_23_12 n_32_24_12 621.4735922602399
R27375 n_32_23_12 n_32_23_13 26.418722063667936
R27376 n_32_23_13 n_33_23_13 1373.3126753079703
R27377 n_32_23_13 n_32_24_13 621.4735922602321
R27378 n_32_23_13 n_32_23_14 132.09361031834004
R27379 n_32_23_14 n_33_23_14 152.5902972564418
R27380 n_32_23_14 n_32_24_14 69.05262136224829
R27381 n_32_23_14 n_32_23_15 4081.6925588367444
R27382 n_32_23_15 n_33_23_15 50469.24081756762
R27383 n_32_23_15 n_32_24_15 22839.154515563394
R27384 n_32_24_0 n_33_24_0 32.69273776469338
R27385 n_32_24_0 n_32_25_0 624.2414878862163
R27386 n_32_24_0 n_32_24_1 148.24483551528397
R27387 n_32_24_1 n_33_24_1 45.76983287057074
R27388 n_32_24_1 n_32_25_1 873.9380830407028
R27389 n_32_24_1 n_32_24_2 336.9200807165545
R27390 n_32_24_2 n_33_24_2 81.73184441173348
R27391 n_32_24_2 n_32_25_2 1560.6037197155406
R27392 n_32_24_2 n_32_24_3 315.357195550695
R27393 n_32_24_3 n_33_24_3 1144.2458217642675
R27394 n_32_24_3 n_32_25_3 21848.45207601755
R27395 n_32_24_3 n_32_24_4 4.192783226694903
R27396 n_32_24_4 n_33_24_4 34.674115811038405
R27397 n_32_24_4 n_32_25_4 662.0743053338651
R27398 n_32_24_4 n_32_24_5 3.4654636873702773
R27399 n_32_24_5 n_33_24_5 217.95158509795573
R27400 n_32_24_5 n_32_25_5 4161.609919241439
R27401 n_32_24_5 n_32_24_6 1.1979380647699724
R27402 n_32_24_6 n_33_24_6 36.32526418299262
R27403 n_32_24_6 n_32_25_6 693.6016532069063
R27404 n_32_24_6 n_32_24_7 1.6257730879021035
R27405 n_32_24_7 n_33_24_7 62.271881456558965
R27406 n_32_24_7 n_32_25_7 1189.0314054975574
R27407 n_32_24_7 n_32_24_8 1.1979380647699687
R27408 n_32_24_8 n_33_24_8 62.271881456558965
R27409 n_32_24_8 n_32_25_8 1189.0314054975574
R27410 n_32_24_8 n_32_24_9 1.1979380647699687
R27411 n_32_24_9 n_33_24_9 62.271881456558965
R27412 n_32_24_9 n_32_25_9 1189.0314054975574
R27413 n_32_24_9 n_32_24_10 1.1979380647699687
R27414 n_32_24_10 n_33_24_10 62.271881456558965
R27415 n_32_24_10 n_32_25_10 1189.0314054975574
R27416 n_32_24_10 n_32_24_11 1.1979380647699611
R27417 n_32_24_11 n_33_24_11 62.271881456559754
R27418 n_32_24_11 n_32_25_11 1189.0314054975725
R27419 n_32_24_11 n_32_24_12 1.1979380647699571
R27420 n_32_24_12 n_33_24_12 62.27188145655936
R27421 n_32_24_12 n_32_25_12 1189.0314054975652
R27422 n_32_24_12 n_32_24_13 1.1979380647699687
R27423 n_32_24_13 n_33_24_13 62.271881456558575
R27424 n_32_24_13 n_32_25_13 1189.0314054975502
R27425 n_32_24_13 n_32_24_14 5.9896903238498584
R27426 n_32_24_14 n_33_24_14 6.9190979396176475
R27427 n_32_24_14 n_32_25_14 132.11460061083946
R27428 n_32_24_14 n_32_24_15 185.08143100696236
R27429 n_32_24_15 n_33_24_15 2288.4916435285145
R27430 n_32_24_15 n_32_25_15 43696.90415203471
R27431 n_32_25_0 n_33_25_0 32.69273776469349
R27432 n_32_25_0 n_32_26_0 624.2414878862163
R27433 n_32_25_0 n_32_25_1 148.24483551528445
R27434 n_32_25_1 n_33_25_1 45.76983287057088
R27435 n_32_25_1 n_32_26_1 873.9380830407028
R27436 n_32_25_1 n_32_25_2 336.92008071655556
R27437 n_32_25_2 n_33_25_2 81.73184441173373
R27438 n_32_25_2 n_32_26_2 1560.6037197155406
R27439 n_32_25_2 n_32_25_3 315.357195550696
R27440 n_32_25_3 n_33_25_3 1144.245821764271
R27441 n_32_25_3 n_32_26_3 21848.45207601755
R27442 n_32_25_3 n_32_25_4 4.1927832266949165
R27443 n_32_25_4 n_33_25_4 34.674115811038526
R27444 n_32_25_4 n_32_26_4 662.0743053338651
R27445 n_32_25_4 n_32_25_5 3.4654636873702884
R27446 n_32_25_5 n_33_25_5 217.9515850979564
R27447 n_32_25_5 n_32_26_5 4161.609919241439
R27448 n_32_25_5 n_32_25_6 1.1979380647699762
R27449 n_32_25_6 n_33_25_6 36.32526418299273
R27450 n_32_25_6 n_32_26_6 693.6016532069063
R27451 n_32_25_6 n_32_25_7 1.6257730879021088
R27452 n_32_25_7 n_33_25_7 62.27188145655917
R27453 n_32_25_7 n_32_26_7 1189.0314054975574
R27454 n_32_25_7 n_32_25_8 1.1979380647699727
R27455 n_32_25_8 n_33_25_8 62.27188145655917
R27456 n_32_25_8 n_32_26_8 1189.0314054975574
R27457 n_32_25_8 n_32_25_9 1.1979380647699727
R27458 n_32_25_9 n_33_25_9 62.27188145655917
R27459 n_32_25_9 n_32_26_9 1189.0314054975574
R27460 n_32_25_9 n_32_25_10 1.1979380647699727
R27461 n_32_25_10 n_33_25_10 62.27188145655917
R27462 n_32_25_10 n_32_26_10 1189.0314054975574
R27463 n_32_25_10 n_32_25_11 1.1979380647699651
R27464 n_32_25_11 n_33_25_11 62.27188145655997
R27465 n_32_25_11 n_32_26_11 1189.0314054975725
R27466 n_32_25_11 n_32_25_12 1.1979380647699611
R27467 n_32_25_12 n_33_25_12 62.27188145655955
R27468 n_32_25_12 n_32_26_12 1189.0314054975652
R27469 n_32_25_12 n_32_25_13 1.1979380647699727
R27470 n_32_25_13 n_33_25_13 62.27188145655878
R27471 n_32_25_13 n_32_26_13 1189.0314054975502
R27472 n_32_25_13 n_32_25_14 5.989690323849878
R27473 n_32_25_14 n_33_25_14 6.91909793961767
R27474 n_32_25_14 n_32_26_14 132.11460061083946
R27475 n_32_25_14 n_32_25_15 185.08143100696296
R27476 n_32_25_15 n_33_25_15 2288.4916435285218
R27477 n_32_25_15 n_32_26_15 43696.90415203471
R27478 n_32_26_0 n_33_26_0 32.69273776469338
R27479 n_32_26_0 n_32_27_0 624.2414878862173
R27480 n_32_26_0 n_32_26_1 148.24483551528397
R27481 n_32_26_1 n_33_26_1 45.76983287057074
R27482 n_32_26_1 n_32_27_1 873.9380830407042
R27483 n_32_26_1 n_32_26_2 336.9200807165545
R27484 n_32_26_2 n_33_26_2 81.73184441173348
R27485 n_32_26_2 n_32_27_2 1560.603719715543
R27486 n_32_26_2 n_32_26_3 315.357195550695
R27487 n_32_26_3 n_33_26_3 1144.2458217642675
R27488 n_32_26_3 n_32_27_3 21848.452076017587
R27489 n_32_26_3 n_32_26_4 4.192783226694903
R27490 n_32_26_4 n_33_26_4 34.674115811038405
R27491 n_32_26_4 n_32_27_4 662.0743053338662
R27492 n_32_26_4 n_32_26_5 3.4654636873702773
R27493 n_32_26_5 n_33_26_5 217.95158509795573
R27494 n_32_26_5 n_32_27_5 4161.609919241445
R27495 n_32_26_5 n_32_26_6 1.1979380647699724
R27496 n_32_26_6 n_33_26_6 36.32526418299262
R27497 n_32_26_6 n_32_27_6 693.6016532069075
R27498 n_32_26_6 n_32_26_7 1.6257730879021035
R27499 n_32_26_7 n_33_26_7 62.271881456558965
R27500 n_32_26_7 n_32_27_7 1189.0314054975593
R27501 n_32_26_7 n_32_26_8 1.1979380647699687
R27502 n_32_26_8 n_33_26_8 62.271881456558965
R27503 n_32_26_8 n_32_27_8 1189.0314054975593
R27504 n_32_26_8 n_32_26_9 1.1979380647699687
R27505 n_32_26_9 n_33_26_9 62.271881456558965
R27506 n_32_26_9 n_32_27_9 1189.0314054975593
R27507 n_32_26_9 n_32_26_10 1.1979380647699687
R27508 n_32_26_10 n_33_26_10 62.271881456558965
R27509 n_32_26_10 n_32_27_10 1189.0314054975593
R27510 n_32_26_10 n_32_26_11 1.1979380647699611
R27511 n_32_26_11 n_33_26_11 62.271881456559754
R27512 n_32_26_11 n_32_27_11 1189.0314054975743
R27513 n_32_26_11 n_32_26_12 1.1979380647699571
R27514 n_32_26_12 n_33_26_12 62.27188145655936
R27515 n_32_26_12 n_32_27_12 1189.031405497567
R27516 n_32_26_12 n_32_26_13 1.1979380647699687
R27517 n_32_26_13 n_33_26_13 62.271881456558575
R27518 n_32_26_13 n_32_27_13 1189.031405497552
R27519 n_32_26_13 n_32_26_14 5.9896903238498584
R27520 n_32_26_14 n_33_26_14 6.9190979396176475
R27521 n_32_26_14 n_32_27_14 132.11460061083966
R27522 n_32_26_14 n_32_26_15 185.08143100696236
R27523 n_32_26_15 n_33_26_15 2288.4916435285145
R27524 n_32_26_15 n_32_27_15 43696.90415203478
R27525 n_32_27_0 n_33_27_0 32.69273776469338
R27526 n_32_27_0 n_32_27_1 148.24483551528397
R27527 n_32_27_1 n_33_27_1 45.76983287057074
R27528 n_32_27_1 n_32_27_2 336.9200807165545
R27529 n_32_27_2 n_33_27_2 81.73184441173348
R27530 n_32_27_2 n_32_27_3 315.357195550695
R27531 n_32_27_3 n_33_27_3 1144.2458217642675
R27532 n_32_27_3 n_32_27_4 4.192783226694903
R27533 n_32_27_4 n_33_27_4 34.674115811038405
R27534 n_32_27_4 n_32_27_5 3.4654636873702773
R27535 n_32_27_5 n_33_27_5 217.95158509795573
R27536 n_32_27_5 n_32_27_6 1.1979380647699724
R27537 n_32_27_6 n_33_27_6 36.32526418299262
R27538 n_32_27_6 n_32_27_7 1.6257730879021035
R27539 n_32_27_7 n_33_27_7 62.271881456558965
R27540 n_32_27_7 n_32_27_8 1.1979380647699687
R27541 n_32_27_8 n_33_27_8 62.271881456558965
R27542 n_32_27_8 n_32_27_9 1.1979380647699687
R27543 n_32_27_9 n_33_27_9 62.271881456558965
R27544 n_32_27_9 n_32_27_10 1.1979380647699687
R27545 n_32_27_10 n_33_27_10 62.271881456558965
R27546 n_32_27_10 n_32_27_11 1.1979380647699611
R27547 n_32_27_11 n_33_27_11 62.271881456559754
R27548 n_32_27_11 n_32_27_12 1.1979380647699571
R27549 n_32_27_12 n_33_27_12 62.27188145655936
R27550 n_32_27_12 n_32_27_13 1.1979380647699687
R27551 n_32_27_13 n_33_27_13 62.271881456558575
R27552 n_32_27_13 n_32_27_14 5.9896903238498584
R27553 n_32_27_14 n_33_27_14 6.9190979396176475
R27554 n_32_27_14 n_32_27_15 185.08143100696236
R27555 n_32_27_15 n_33_27_15 2288.4916435285145
R27556 n_33_0_0 n_34_0_0 32.69273494919985
R27557 n_33_0_0 n_33_1_0 624.2415416457984
R27558 n_33_0_0 n_33_0_1 148.2448227484626
R27559 n_33_0_1 n_34_0_1 45.76982892887978
R27560 n_33_0_1 n_33_1_1 873.9381583041177
R27561 n_33_0_1 n_33_0_2 336.92005170105136
R27562 n_33_0_2 n_34_0_2 81.73183737299962
R27563 n_33_0_2 n_33_1_2 1560.6038541144958
R27564 n_33_0_2 n_33_0_3 315.35716839218406
R27565 n_33_0_3 n_34_0_3 1144.2457232219936
R27566 n_33_0_3 n_33_1_3 21848.453957602924
R27567 n_33_0_3 n_33_0_4 4.192782865613087
R27568 n_33_0_4 n_34_0_4 34.674112824908896
R27569 n_33_0_4 n_33_1_4 662.0743623516037
R27570 n_33_0_4 n_33_0_5 3.465463388925103
R27571 n_33_0_5 n_34_0_5 217.95156632799876
R27572 n_33_0_5 n_33_1_5 4161.610277638652
R27573 n_33_0_5 n_33_0_6 1.197937961603739
R27574 n_33_0_6 n_34_0_6 36.32526105466647
R27575 n_33_0_6 n_33_1_6 693.6017129397753
R27576 n_33_0_6 n_33_0_7 1.6257729478907872
R27577 n_33_0_7 n_34_0_7 62.27187609371413
R27578 n_33_0_7 n_33_1_7 1189.0315078967615
R27579 n_33_0_7 n_33_0_8 1.1979379616037356
R27580 n_33_0_8 n_34_0_8 62.27187609371413
R27581 n_33_0_8 n_33_1_8 1189.0315078967615
R27582 n_33_0_8 n_33_0_9 1.1979379616037356
R27583 n_33_0_9 n_34_0_9 62.27187609371413
R27584 n_33_0_9 n_33_1_9 1189.0315078967615
R27585 n_33_0_9 n_33_0_10 1.1979379616037356
R27586 n_33_0_10 n_34_0_10 62.27187609371413
R27587 n_33_0_10 n_33_1_10 1189.0315078967615
R27588 n_33_0_10 n_33_0_11 1.1979379616037278
R27589 n_33_0_11 n_34_0_11 62.27187609371492
R27590 n_33_0_11 n_33_1_11 1189.0315078967762
R27591 n_33_0_11 n_33_0_12 1.197937961603724
R27592 n_33_0_12 n_34_0_12 62.271876093714546
R27593 n_33_0_12 n_33_1_12 1189.031507896769
R27594 n_33_0_12 n_33_0_13 1.1979379616037353
R27595 n_33_0_13 n_34_0_13 62.271876093713736
R27596 n_33_0_13 n_33_1_13 1189.031507896754
R27597 n_33_0_13 n_33_0_14 5.989689808018693
R27598 n_33_0_14 n_34_0_14 6.9190973437459995
R27599 n_33_0_14 n_33_1_14 132.1146119885288
R27600 n_33_0_14 n_33_0_15 185.0814150677793
R27601 n_33_0_15 n_34_0_15 2288.4914464439667
R27602 n_33_0_15 n_33_1_15 43696.907915205455
R27603 n_33_1_0 n_34_1_0 32.69273494919985
R27604 n_33_1_0 n_33_2_0 624.2415416457984
R27605 n_33_1_0 n_33_1_1 148.2448227484626
R27606 n_33_1_1 n_34_1_1 45.76982892887978
R27607 n_33_1_1 n_33_2_1 873.9381583041177
R27608 n_33_1_1 n_33_1_2 336.92005170105136
R27609 n_33_1_2 n_34_1_2 81.73183737299962
R27610 n_33_1_2 n_33_2_2 1560.6038541144958
R27611 n_33_1_2 n_33_1_3 315.35716839218406
R27612 n_33_1_3 n_34_1_3 1144.2457232219936
R27613 n_33_1_3 n_33_2_3 21848.453957602924
R27614 n_33_1_3 n_33_1_4 4.192782865613087
R27615 n_33_1_4 n_34_1_4 34.674112824908896
R27616 n_33_1_4 n_33_2_4 662.0743623516037
R27617 n_33_1_4 n_33_1_5 3.465463388925103
R27618 n_33_1_5 n_34_1_5 217.95156632799876
R27619 n_33_1_5 n_33_2_5 4161.610277638652
R27620 n_33_1_5 n_33_1_6 1.197937961603739
R27621 n_33_1_6 n_34_1_6 36.32526105466647
R27622 n_33_1_6 n_33_2_6 693.6017129397753
R27623 n_33_1_6 n_33_1_7 1.6257729478907872
R27624 n_33_1_7 n_34_1_7 62.27187609371413
R27625 n_33_1_7 n_33_2_7 1189.0315078967615
R27626 n_33_1_7 n_33_1_8 1.1979379616037356
R27627 n_33_1_8 n_34_1_8 62.27187609371413
R27628 n_33_1_8 n_33_2_8 1189.0315078967615
R27629 n_33_1_8 n_33_1_9 1.1979379616037356
R27630 n_33_1_9 n_34_1_9 62.27187609371413
R27631 n_33_1_9 n_33_2_9 1189.0315078967615
R27632 n_33_1_9 n_33_1_10 1.1979379616037356
R27633 n_33_1_10 n_34_1_10 62.27187609371413
R27634 n_33_1_10 n_33_2_10 1189.0315078967615
R27635 n_33_1_10 n_33_1_11 1.1979379616037278
R27636 n_33_1_11 n_34_1_11 62.27187609371492
R27637 n_33_1_11 n_33_2_11 1189.0315078967762
R27638 n_33_1_11 n_33_1_12 1.197937961603724
R27639 n_33_1_12 n_34_1_12 62.271876093714546
R27640 n_33_1_12 n_33_2_12 1189.031507896769
R27641 n_33_1_12 n_33_1_13 1.1979379616037353
R27642 n_33_1_13 n_34_1_13 62.271876093713736
R27643 n_33_1_13 n_33_2_13 1189.031507896754
R27644 n_33_1_13 n_33_1_14 5.989689808018693
R27645 n_33_1_14 n_34_1_14 6.9190973437459995
R27646 n_33_1_14 n_33_2_14 132.1146119885288
R27647 n_33_1_14 n_33_1_15 185.0814150677793
R27648 n_33_1_15 n_34_1_15 2288.4914464439667
R27649 n_33_1_15 n_33_2_15 43696.907915205455
R27650 n_33_2_0 n_34_2_0 32.69273494919985
R27651 n_33_2_0 n_33_3_0 624.2415416457984
R27652 n_33_2_0 n_33_2_1 148.2448227484626
R27653 n_33_2_1 n_34_2_1 45.76982892887978
R27654 n_33_2_1 n_33_3_1 873.9381583041177
R27655 n_33_2_1 n_33_2_2 336.92005170105136
R27656 n_33_2_2 n_34_2_2 81.73183737299962
R27657 n_33_2_2 n_33_3_2 1560.6038541144958
R27658 n_33_2_2 n_33_2_3 315.35716839218406
R27659 n_33_2_3 n_34_2_3 1144.2457232219936
R27660 n_33_2_3 n_33_3_3 21848.453957602924
R27661 n_33_2_3 n_33_2_4 4.192782865613087
R27662 n_33_2_4 n_34_2_4 34.674112824908896
R27663 n_33_2_4 n_33_3_4 662.0743623516037
R27664 n_33_2_4 n_33_2_5 3.465463388925103
R27665 n_33_2_5 n_34_2_5 217.95156632799876
R27666 n_33_2_5 n_33_3_5 4161.610277638652
R27667 n_33_2_5 n_33_2_6 1.197937961603739
R27668 n_33_2_6 n_34_2_6 36.32526105466647
R27669 n_33_2_6 n_33_3_6 693.6017129397753
R27670 n_33_2_6 n_33_2_7 1.6257729478907872
R27671 n_33_2_7 n_34_2_7 62.27187609371413
R27672 n_33_2_7 n_33_3_7 1189.0315078967615
R27673 n_33_2_7 n_33_2_8 1.1979379616037356
R27674 n_33_2_8 n_34_2_8 62.27187609371413
R27675 n_33_2_8 n_33_3_8 1189.0315078967615
R27676 n_33_2_8 n_33_2_9 1.1979379616037356
R27677 n_33_2_9 n_34_2_9 62.27187609371413
R27678 n_33_2_9 n_33_3_9 1189.0315078967615
R27679 n_33_2_9 n_33_2_10 1.1979379616037356
R27680 n_33_2_10 n_34_2_10 62.27187609371413
R27681 n_33_2_10 n_33_3_10 1189.0315078967615
R27682 n_33_2_10 n_33_2_11 1.1979379616037278
R27683 n_33_2_11 n_34_2_11 62.27187609371492
R27684 n_33_2_11 n_33_3_11 1189.0315078967762
R27685 n_33_2_11 n_33_2_12 1.197937961603724
R27686 n_33_2_12 n_34_2_12 62.271876093714546
R27687 n_33_2_12 n_33_3_12 1189.031507896769
R27688 n_33_2_12 n_33_2_13 1.1979379616037353
R27689 n_33_2_13 n_34_2_13 62.271876093713736
R27690 n_33_2_13 n_33_3_13 1189.031507896754
R27691 n_33_2_13 n_33_2_14 5.989689808018693
R27692 n_33_2_14 n_34_2_14 6.9190973437459995
R27693 n_33_2_14 n_33_3_14 132.1146119885288
R27694 n_33_2_14 n_33_2_15 185.0814150677793
R27695 n_33_2_15 n_34_2_15 2288.4914464439667
R27696 n_33_2_15 n_33_3_15 43696.907915205455
R27697 n_33_3_0 n_34_3_0 32.69273494919985
R27698 n_33_3_0 n_33_4_0 326.27363593662244
R27699 n_33_3_0 n_33_3_1 148.2448227484626
R27700 n_33_3_1 n_34_3_1 45.76982892887978
R27701 n_33_3_1 n_33_4_1 456.78309031127134
R27702 n_33_3_1 n_33_3_2 336.92005170105136
R27703 n_33_3_2 n_34_3_2 81.73183737299962
R27704 n_33_3_2 n_33_4_2 815.684089841556
R27705 n_33_3_2 n_33_3_3 315.35716839218406
R27706 n_33_3_3 n_34_3_3 1144.2457232219936
R27707 n_33_3_3 n_33_4_3 11419.577257781775
R27708 n_33_3_3 n_33_3_4 4.192782865613087
R27709 n_33_3_4 n_34_3_4 34.674112824908896
R27710 n_33_3_4 n_33_4_4 346.04779569035674
R27711 n_33_3_4 n_33_3_5 3.465463388925103
R27712 n_33_3_5 n_34_3_5 217.95156632799876
R27713 n_33_3_5 n_33_4_5 2175.1575729108145
R27714 n_33_3_5 n_33_3_6 1.197937961603739
R27715 n_33_3_6 n_34_3_6 36.32526105466647
R27716 n_33_3_6 n_33_4_6 362.52626215180237
R27717 n_33_3_6 n_33_3_7 1.6257729478907872
R27718 n_33_3_7 n_34_3_7 62.27187609371413
R27719 n_33_3_7 n_33_4_7 621.4735922602346
R27720 n_33_3_7 n_33_3_8 1.1979379616037356
R27721 n_33_3_8 n_34_3_8 62.27187609371413
R27722 n_33_3_8 n_33_4_8 621.4735922602346
R27723 n_33_3_8 n_33_3_9 1.1979379616037356
R27724 n_33_3_9 n_34_3_9 62.27187609371413
R27725 n_33_3_9 n_33_4_9 621.4735922602346
R27726 n_33_3_9 n_33_3_10 1.1979379616037356
R27727 n_33_3_10 n_34_3_10 62.27187609371413
R27728 n_33_3_10 n_33_4_10 621.4735922602346
R27729 n_33_3_10 n_33_3_11 1.1979379616037278
R27730 n_33_3_11 n_34_3_11 62.27187609371492
R27731 n_33_3_11 n_33_4_11 621.4735922602423
R27732 n_33_3_11 n_33_3_12 1.197937961603724
R27733 n_33_3_12 n_34_3_12 62.271876093714546
R27734 n_33_3_12 n_33_4_12 621.4735922602384
R27735 n_33_3_12 n_33_3_13 1.1979379616037353
R27736 n_33_3_13 n_34_3_13 62.271876093713736
R27737 n_33_3_13 n_33_4_13 621.4735922602306
R27738 n_33_3_13 n_33_3_14 5.989689808018693
R27739 n_33_3_14 n_34_3_14 6.9190973437459995
R27740 n_33_3_14 n_33_4_14 69.05262136224815
R27741 n_33_3_14 n_33_3_15 185.0814150677793
R27742 n_33_3_15 n_34_3_15 2288.4914464439667
R27743 n_33_3_15 n_33_4_15 22839.154515563343
R27744 n_33_4_0 n_34_4_0 720.990523873408
R27745 n_33_4_0 n_33_5_0 28.305730227446706
R27746 n_33_4_0 n_33_4_1 3269.323064620219
R27747 n_33_4_1 n_34_4_1 1009.3867334227713
R27748 n_33_4_1 n_33_5_1 39.628022318425394
R27749 n_33_4_1 n_33_4_2 7430.27969231868
R27750 n_33_4_2 n_34_4_2 1802.4763096835204
R27751 n_33_4_2 n_33_5_2 70.76432556861675
R27752 n_33_4_2 n_33_4_3 6954.741792010284
R27753 n_33_4_3 n_34_4_3 25234.668335569266
R27754 n_33_4_3 n_33_5_3 990.7005579606339
R27755 n_33_4_3 n_33_4_4 92.46570283774365
R27756 n_33_4_4 n_34_4_4 764.6869192596746
R27757 n_33_4_4 n_33_5_4 30.021229029110113
R27758 n_33_4_4 n_33_4_5 76.42573397813506
R27759 n_33_4_5 n_34_4_5 4806.603492489383
R27760 n_33_4_5 n_33_5_5 188.7048681829779
R27761 n_33_4_5 n_33_4_6 26.41877223935533
R27762 n_33_4_6 n_34_4_6 801.1005820815639
R27763 n_33_4_6 n_33_5_6 31.450811363829644
R27764 n_33_4_6 n_33_4_7 35.85404803912505
R27765 n_33_4_7 n_34_4_7 1373.3152835683995
R27766 n_33_4_7 n_33_5_7 53.91567662370813
R27767 n_33_4_7 n_33_4_8 26.41877223935525
R27768 n_33_4_8 n_34_4_8 1373.3152835683995
R27769 n_33_4_8 n_33_5_8 53.91567662370813
R27770 n_33_4_8 n_33_4_9 26.41877223935525
R27771 n_33_4_9 n_34_4_9 1373.3152835683995
R27772 n_33_4_9 n_33_5_9 53.91567662370813
R27773 n_33_4_9 n_33_4_10 26.41877223935525
R27774 n_33_4_10 n_34_4_10 1373.3152835683995
R27775 n_33_4_10 n_33_5_10 53.91567662370813
R27776 n_33_4_10 n_33_4_11 26.41877223935508
R27777 n_33_4_11 n_34_4_11 1373.3152835684168
R27778 n_33_4_11 n_33_5_11 53.915676623708805
R27779 n_33_4_11 n_33_4_12 26.418772239354993
R27780 n_33_4_12 n_34_4_12 1373.3152835684082
R27781 n_33_4_12 n_33_5_12 53.91567662370848
R27782 n_33_4_12 n_33_4_13 26.41877223935525
R27783 n_33_4_13 n_34_4_13 1373.315283568391
R27784 n_33_4_13 n_33_5_13 53.915676623707796
R27785 n_33_4_13 n_33_4_14 132.09386119677657
R27786 n_33_4_14 n_34_4_14 152.59058706315517
R27787 n_33_4_14 n_33_5_14 5.990630735967558
R27788 n_33_4_14 n_33_4_15 4081.7003109804336
R27789 n_33_4_15 n_34_4_15 50469.33667113808
R27790 n_33_4_15 n_33_5_15 1981.40111592125
R27791 n_33_5_0 n_34_5_0 720.9905238733954
R27792 n_33_5_0 n_33_6_0 28.305730227446958
R27793 n_33_5_0 n_33_5_1 3269.3230646201605
R27794 n_33_5_1 n_34_5_1 1009.3867334227533
R27795 n_33_5_1 n_33_6_1 39.62802231842574
R27796 n_33_5_1 n_33_5_2 7430.279692318547
R27797 n_33_5_2 n_34_5_2 1802.4763096834881
R27798 n_33_5_2 n_33_6_2 70.76432556861738
R27799 n_33_5_2 n_33_5_3 6954.74179201016
R27800 n_33_5_3 n_34_5_3 25234.668335568815
R27801 n_33_5_3 n_33_6_3 990.7005579606426
R27802 n_33_5_3 n_33_5_4 92.46570283774201
R27803 n_33_5_4 n_34_5_4 764.686919259661
R27804 n_33_5_4 n_33_6_4 30.02122902911038
R27805 n_33_5_4 n_33_5_5 76.4257339781337
R27806 n_33_5_5 n_34_5_5 4806.603492489298
R27807 n_33_5_5 n_33_6_5 188.70486818297957
R27808 n_33_5_5 n_33_5_6 26.418772239354862
R27809 n_33_5_6 n_34_5_6 801.1005820815496
R27810 n_33_5_6 n_33_6_6 31.45081136382992
R27811 n_33_5_6 n_33_5_7 35.854048039124415
R27812 n_33_5_7 n_34_5_7 1373.3152835683752
R27813 n_33_5_7 n_33_6_7 53.915676623708606
R27814 n_33_5_7 n_33_5_8 26.41877223935478
R27815 n_33_5_8 n_34_5_8 1373.3152835683752
R27816 n_33_5_8 n_33_6_8 53.915676623708606
R27817 n_33_5_8 n_33_5_9 26.41877223935478
R27818 n_33_5_9 n_34_5_9 1373.3152835683752
R27819 n_33_5_9 n_33_6_9 53.915676623708606
R27820 n_33_5_9 n_33_5_10 26.41877223935478
R27821 n_33_5_10 n_34_5_10 1373.3152835683752
R27822 n_33_5_10 n_33_6_10 53.915676623708606
R27823 n_33_5_10 n_33_5_11 26.41877223935461
R27824 n_33_5_11 n_34_5_11 1373.3152835683923
R27825 n_33_5_11 n_33_6_11 53.91567662370929
R27826 n_33_5_11 n_33_5_12 26.418772239354524
R27827 n_33_5_12 n_34_5_12 1373.3152835683836
R27828 n_33_5_12 n_33_6_12 53.915676623708954
R27829 n_33_5_12 n_33_5_13 26.41877223935478
R27830 n_33_5_13 n_34_5_13 1373.3152835683663
R27831 n_33_5_13 n_33_6_13 53.91567662370827
R27832 n_33_5_13 n_33_5_14 132.0938611967742
R27833 n_33_5_14 n_34_5_14 152.59058706315244
R27834 n_33_5_14 n_33_6_14 5.990630735967612
R27835 n_33_5_14 n_33_5_15 4081.700310980361
R27836 n_33_5_15 n_34_5_15 50469.33667113718
R27837 n_33_5_15 n_33_6_15 1981.4011159212675
R27838 n_33_6_0 n_34_6_0 720.9905238733954
R27839 n_33_6_0 n_33_7_0 28.305730227446706
R27840 n_33_6_0 n_33_6_1 3269.3230646201605
R27841 n_33_6_1 n_34_6_1 1009.3867334227533
R27842 n_33_6_1 n_33_7_1 39.628022318425394
R27843 n_33_6_1 n_33_6_2 7430.279692318547
R27844 n_33_6_2 n_34_6_2 1802.4763096834881
R27845 n_33_6_2 n_33_7_2 70.76432556861675
R27846 n_33_6_2 n_33_6_3 6954.74179201016
R27847 n_33_6_3 n_34_6_3 25234.668335568815
R27848 n_33_6_3 n_33_7_3 990.7005579606339
R27849 n_33_6_3 n_33_6_4 92.46570283774201
R27850 n_33_6_4 n_34_6_4 764.686919259661
R27851 n_33_6_4 n_33_7_4 30.021229029110113
R27852 n_33_6_4 n_33_6_5 76.4257339781337
R27853 n_33_6_5 n_34_6_5 4806.603492489298
R27854 n_33_6_5 n_33_7_5 188.7048681829779
R27855 n_33_6_5 n_33_6_6 26.418772239354862
R27856 n_33_6_6 n_34_6_6 801.1005820815496
R27857 n_33_6_6 n_33_7_6 31.450811363829644
R27858 n_33_6_6 n_33_6_7 35.854048039124415
R27859 n_33_6_7 n_34_6_7 1373.3152835683752
R27860 n_33_6_7 n_33_7_7 53.91567662370813
R27861 n_33_6_7 n_33_6_8 26.41877223935478
R27862 n_33_6_8 n_34_6_8 1373.3152835683752
R27863 n_33_6_8 n_33_7_8 53.91567662370813
R27864 n_33_6_8 n_33_6_9 26.41877223935478
R27865 n_33_6_9 n_34_6_9 1373.3152835683752
R27866 n_33_6_9 n_33_7_9 53.91567662370813
R27867 n_33_6_9 n_33_6_10 26.41877223935478
R27868 n_33_6_10 n_34_6_10 1373.3152835683752
R27869 n_33_6_10 n_33_7_10 53.91567662370813
R27870 n_33_6_10 n_33_6_11 26.41877223935461
R27871 n_33_6_11 n_34_6_11 1373.3152835683923
R27872 n_33_6_11 n_33_7_11 53.915676623708805
R27873 n_33_6_11 n_33_6_12 26.418772239354524
R27874 n_33_6_12 n_34_6_12 1373.3152835683836
R27875 n_33_6_12 n_33_7_12 53.91567662370848
R27876 n_33_6_12 n_33_6_13 26.41877223935478
R27877 n_33_6_13 n_34_6_13 1373.3152835683663
R27878 n_33_6_13 n_33_7_13 53.915676623707796
R27879 n_33_6_13 n_33_6_14 132.0938611967742
R27880 n_33_6_14 n_34_6_14 152.59058706315244
R27881 n_33_6_14 n_33_7_14 5.990630735967558
R27882 n_33_6_14 n_33_6_15 4081.700310980361
R27883 n_33_6_15 n_34_6_15 50469.33667113718
R27884 n_33_6_15 n_33_7_15 1981.40111592125
R27885 n_33_7_0 n_34_7_0 720.990523873408
R27886 n_33_7_0 n_33_8_0 827.2137876682006
R27887 n_33_7_0 n_33_7_1 3269.323064620219
R27888 n_33_7_1 n_34_7_1 1009.3867334227713
R27889 n_33_7_1 n_33_8_1 1158.0993027354807
R27890 n_33_7_1 n_33_7_2 7430.27969231868
R27891 n_33_7_2 n_34_7_2 1802.4763096835204
R27892 n_33_7_2 n_33_8_2 2068.0344691705013
R27893 n_33_7_2 n_33_7_3 6954.741792010284
R27894 n_33_7_3 n_34_7_3 25234.668335569266
R27895 n_33_7_3 n_33_8_3 28952.482568386997
R27896 n_33_7_3 n_33_7_4 92.46570283774365
R27897 n_33_7_4 n_34_7_4 764.6869192596746
R27898 n_33_7_4 n_33_8_4 877.3479566177876
R27899 n_33_7_4 n_33_7_5 76.42573397813506
R27900 n_33_7_5 n_34_7_5 4806.603492489383
R27901 n_33_7_5 n_33_8_5 5514.758584454666
R27902 n_33_7_5 n_33_7_6 26.41877223935533
R27903 n_33_7_6 n_34_7_6 801.1005820815639
R27904 n_33_7_6 n_33_8_6 919.1264307424442
R27905 n_33_7_6 n_33_7_7 35.85404803912505
R27906 n_33_7_7 n_34_7_7 1373.3152835683995
R27907 n_33_7_7 n_33_8_7 1575.6453098441948
R27908 n_33_7_7 n_33_7_8 26.41877223935525
R27909 n_33_7_8 n_34_7_8 1373.3152835683995
R27910 n_33_7_8 n_33_8_8 1575.6453098441948
R27911 n_33_7_8 n_33_7_9 26.41877223935525
R27912 n_33_7_9 n_34_7_9 1373.3152835683995
R27913 n_33_7_9 n_33_8_9 1575.6453098441948
R27914 n_33_7_9 n_33_7_10 26.41877223935525
R27915 n_33_7_10 n_34_7_10 1373.3152835683995
R27916 n_33_7_10 n_33_8_10 1575.6453098441948
R27917 n_33_7_10 n_33_7_11 26.41877223935508
R27918 n_33_7_11 n_34_7_11 1373.3152835684168
R27919 n_33_7_11 n_33_8_11 1575.6453098442148
R27920 n_33_7_11 n_33_7_12 26.418772239354993
R27921 n_33_7_12 n_34_7_12 1373.3152835684082
R27922 n_33_7_12 n_33_8_12 1575.645309844205
R27923 n_33_7_12 n_33_7_13 26.41877223935525
R27924 n_33_7_13 n_34_7_13 1373.315283568391
R27925 n_33_7_13 n_33_8_13 1575.6453098441852
R27926 n_33_7_13 n_33_7_14 132.09386119677657
R27927 n_33_7_14 n_34_7_14 152.59058706315517
R27928 n_33_7_14 n_33_8_14 175.0717010937991
R27929 n_33_7_14 n_33_7_15 4081.7003109804336
R27930 n_33_7_15 n_34_7_15 50469.33667113808
R27931 n_33_7_15 n_33_8_15 57904.96513677348
R27932 n_33_8_0 n_34_8_0 12.550205463809252
R27933 n_33_8_0 n_33_9_0 1626.121845108955
R27934 n_33_8_0 n_33_8_1 56.90875931090387
R27935 n_33_8_1 n_34_8_1 17.570287649332954
R27936 n_33_8_1 n_33_9_1 2276.5705831525374
R27937 n_33_8_1 n_33_8_2 129.33808934296334
R27938 n_33_8_2 n_34_8_2 31.37551365952313
R27939 n_33_8_2 n_33_9_2 4065.3046127723874
R27940 n_33_8_2 n_33_8_3 121.06045162501368
R27941 n_33_8_3 n_34_8_3 439.2571912333234
R27942 n_33_8_3 n_33_9_3 56914.26457881338
R27943 n_33_8_3 n_33_8_4 1.6095406673791008
R27944 n_33_8_4 n_34_8_4 13.310823976767377
R27945 n_33_8_4 n_33_9_4 1724.6746842064658
R27946 n_33_8_4 n_33_8_5 1.3303346332419097
R27947 n_33_8_5 n_34_8_5 83.66803642539494
R27948 n_33_8_5 n_33_9_5 10840.812300726358
R27949 n_33_8_5 n_33_8_6 0.4598687621083145
R27950 n_33_8_6 n_34_8_6 13.944672737565824
R27951 n_33_8_6 n_33_9_6 1806.8020501210594
R27952 n_33_8_6 n_33_8_7 0.624107605718426
R27953 n_33_8_7 n_34_8_7 23.905153264398628
R27954 n_33_8_7 n_33_9_7 3097.374943064683
R27955 n_33_8_7 n_33_8_8 0.45986876210831307
R27956 n_33_8_8 n_34_8_8 23.905153264398628
R27957 n_33_8_8 n_33_9_8 3097.374943064683
R27958 n_33_8_8 n_33_8_9 0.45986876210831307
R27959 n_33_8_9 n_34_8_9 23.905153264398628
R27960 n_33_8_9 n_33_9_9 3097.374943064683
R27961 n_33_8_9 n_33_8_10 0.45986876210831307
R27962 n_33_8_10 n_34_8_10 23.905153264398628
R27963 n_33_8_10 n_33_9_10 3097.374943064683
R27964 n_33_8_10 n_33_8_11 0.4598687621083101
R27965 n_33_8_11 n_34_8_11 23.905153264398933
R27966 n_33_8_11 n_33_9_11 3097.374943064722
R27967 n_33_8_11 n_33_8_12 0.4598687621083086
R27968 n_33_8_12 n_34_8_12 23.90515326439878
R27969 n_33_8_12 n_33_9_12 3097.374943064703
R27970 n_33_8_12 n_33_8_13 0.45986876210831307
R27971 n_33_8_13 n_34_8_13 23.905153264398475
R27972 n_33_8_13 n_33_9_13 3097.374943064664
R27973 n_33_8_13 n_33_8_14 2.299343810541571
R27974 n_33_8_14 n_34_8_14 2.6561281404887307
R27975 n_33_8_14 n_33_9_14 344.15277145163077
R27976 n_33_8_14 n_33_8_15 71.04972374573519
R27977 n_33_8_15 n_34_8_15 878.5143824666391
R27978 n_33_8_15 n_33_9_15 113828.52915762574
R27979 n_33_9_0 n_34_9_0 12.550205463809242
R27980 n_33_9_0 n_33_10_0 1626.121845108955
R27981 n_33_9_0 n_33_9_1 56.90875931090384
R27982 n_33_9_1 n_34_9_1 17.57028764933294
R27983 n_33_9_1 n_33_10_1 2276.5705831525374
R27984 n_33_9_1 n_33_9_2 129.33808934296326
R27985 n_33_9_2 n_34_9_2 31.375513659523108
R27986 n_33_9_2 n_33_10_2 4065.3046127723874
R27987 n_33_9_2 n_33_9_3 121.06045162501361
R27988 n_33_9_3 n_34_9_3 439.25719123332317
R27989 n_33_9_3 n_33_10_3 56914.26457881338
R27990 n_33_9_3 n_33_9_4 1.6095406673791
R27991 n_33_9_4 n_34_9_4 13.310823976767367
R27992 n_33_9_4 n_33_10_4 1724.6746842064658
R27993 n_33_9_4 n_33_9_5 1.330334633241909
R27994 n_33_9_5 n_34_9_5 83.66803642539489
R27995 n_33_9_5 n_33_10_5 10840.812300726358
R27996 n_33_9_5 n_33_9_6 0.45986876210831423
R27997 n_33_9_6 n_34_9_6 13.944672737565813
R27998 n_33_9_6 n_33_10_6 1806.8020501210594
R27999 n_33_9_6 n_33_9_7 0.6241076057184257
R28000 n_33_9_7 n_34_9_7 23.905153264398614
R28001 n_33_9_7 n_33_10_7 3097.374943064683
R28002 n_33_9_7 n_33_9_8 0.4598687621083128
R28003 n_33_9_8 n_34_9_8 23.905153264398614
R28004 n_33_9_8 n_33_10_8 3097.374943064683
R28005 n_33_9_8 n_33_9_9 0.4598687621083128
R28006 n_33_9_9 n_34_9_9 23.905153264398614
R28007 n_33_9_9 n_33_10_9 3097.374943064683
R28008 n_33_9_9 n_33_9_10 0.4598687621083128
R28009 n_33_9_10 n_34_9_10 23.905153264398614
R28010 n_33_9_10 n_33_10_10 3097.374943064683
R28011 n_33_9_10 n_33_9_11 0.45986876210830985
R28012 n_33_9_11 n_34_9_11 23.905153264398916
R28013 n_33_9_11 n_33_10_11 3097.374943064722
R28014 n_33_9_11 n_33_9_12 0.4598687621083084
R28015 n_33_9_12 n_34_9_12 23.905153264398766
R28016 n_33_9_12 n_33_10_12 3097.374943064703
R28017 n_33_9_12 n_33_9_13 0.45986876210831285
R28018 n_33_9_13 n_34_9_13 23.905153264398457
R28019 n_33_9_13 n_33_10_13 3097.374943064664
R28020 n_33_9_13 n_33_9_14 2.29934381054157
R28021 n_33_9_14 n_34_9_14 2.656128140488729
R28022 n_33_9_14 n_33_10_14 344.15277145163077
R28023 n_33_9_14 n_33_9_15 71.04972374573515
R28024 n_33_9_15 n_34_9_15 878.5143824666385
R28025 n_33_9_15 n_33_10_15 113828.52915762574
R28026 n_33_10_0 n_34_10_0 12.550205463809252
R28027 n_33_10_0 n_33_11_0 1626.1218451089546
R28028 n_33_10_0 n_33_10_1 56.90875931090387
R28029 n_33_10_1 n_34_10_1 17.570287649332954
R28030 n_33_10_1 n_33_11_1 2276.5705831525365
R28031 n_33_10_1 n_33_10_2 129.33808934296334
R28032 n_33_10_2 n_34_10_2 31.37551365952313
R28033 n_33_10_2 n_33_11_2 4065.3046127723865
R28034 n_33_10_2 n_33_10_3 121.06045162501368
R28035 n_33_10_3 n_34_10_3 439.2571912333234
R28036 n_33_10_3 n_33_11_3 56914.26457881337
R28037 n_33_10_3 n_33_10_4 1.6095406673791008
R28038 n_33_10_4 n_34_10_4 13.310823976767377
R28039 n_33_10_4 n_33_11_4 1724.6746842064654
R28040 n_33_10_4 n_33_10_5 1.3303346332419097
R28041 n_33_10_5 n_34_10_5 83.66803642539494
R28042 n_33_10_5 n_33_11_5 10840.812300726355
R28043 n_33_10_5 n_33_10_6 0.4598687621083145
R28044 n_33_10_6 n_34_10_6 13.944672737565824
R28045 n_33_10_6 n_33_11_6 1806.802050121059
R28046 n_33_10_6 n_33_10_7 0.624107605718426
R28047 n_33_10_7 n_34_10_7 23.905153264398628
R28048 n_33_10_7 n_33_11_7 3097.374943064682
R28049 n_33_10_7 n_33_10_8 0.45986876210831307
R28050 n_33_10_8 n_34_10_8 23.905153264398628
R28051 n_33_10_8 n_33_11_8 3097.374943064682
R28052 n_33_10_8 n_33_10_9 0.45986876210831307
R28053 n_33_10_9 n_34_10_9 23.905153264398628
R28054 n_33_10_9 n_33_11_9 3097.374943064682
R28055 n_33_10_9 n_33_10_10 0.45986876210831307
R28056 n_33_10_10 n_34_10_10 23.905153264398628
R28057 n_33_10_10 n_33_11_10 3097.374943064682
R28058 n_33_10_10 n_33_10_11 0.4598687621083101
R28059 n_33_10_11 n_34_10_11 23.905153264398933
R28060 n_33_10_11 n_33_11_11 3097.3749430647213
R28061 n_33_10_11 n_33_10_12 0.4598687621083086
R28062 n_33_10_12 n_34_10_12 23.90515326439878
R28063 n_33_10_12 n_33_11_12 3097.374943064702
R28064 n_33_10_12 n_33_10_13 0.45986876210831307
R28065 n_33_10_13 n_34_10_13 23.905153264398475
R28066 n_33_10_13 n_33_11_13 3097.374943064663
R28067 n_33_10_13 n_33_10_14 2.299343810541571
R28068 n_33_10_14 n_34_10_14 2.6561281404887307
R28069 n_33_10_14 n_33_11_14 344.1527714516307
R28070 n_33_10_14 n_33_10_15 71.04972374573519
R28071 n_33_10_15 n_34_10_15 878.5143824666391
R28072 n_33_10_15 n_33_11_15 113828.52915762572
R28073 n_33_11_0 n_34_11_0 12.550205463809252
R28074 n_33_11_0 n_33_12_0 827.2138119611456
R28075 n_33_11_0 n_33_11_1 56.90875931090387
R28076 n_33_11_1 n_34_11_1 17.570287649332954
R28077 n_33_11_1 n_33_12_1 1158.0993367456038
R28078 n_33_11_1 n_33_11_2 129.33808934296334
R28079 n_33_11_2 n_34_11_2 31.37551365952313
R28080 n_33_11_2 n_33_12_2 2068.034529902864
R28081 n_33_11_2 n_33_11_3 121.06045162501368
R28082 n_33_11_3 n_34_11_3 439.2571912333234
R28083 n_33_11_3 n_33_12_3 28952.483418640073
R28084 n_33_11_3 n_33_11_4 1.6095406673791008
R28085 n_33_11_4 n_34_11_4 13.310823976767377
R28086 n_33_11_4 n_33_12_4 877.3479823830323
R28087 n_33_11_4 n_33_11_5 1.3303346332419097
R28088 n_33_11_5 n_34_11_5 83.66803642539494
R28089 n_33_11_5 n_33_12_5 5514.758746407632
R28090 n_33_11_5 n_33_11_6 0.4598687621083145
R28091 n_33_11_6 n_34_11_6 13.944672737565824
R28092 n_33_11_6 n_33_12_6 919.1264577346053
R28093 n_33_11_6 n_33_11_7 0.624107605718426
R28094 n_33_11_7 n_34_11_7 23.905153264398628
R28095 n_33_11_7 n_33_12_7 1575.6453561164712
R28096 n_33_11_7 n_33_11_8 0.45986876210831307
R28097 n_33_11_8 n_34_11_8 23.905153264398628
R28098 n_33_11_8 n_33_12_8 1575.6453561164712
R28099 n_33_11_8 n_33_11_9 0.45986876210831307
R28100 n_33_11_9 n_34_11_9 23.905153264398628
R28101 n_33_11_9 n_33_12_9 1575.6453561164712
R28102 n_33_11_9 n_33_11_10 0.45986876210831307
R28103 n_33_11_10 n_34_11_10 23.905153264398628
R28104 n_33_11_10 n_33_12_10 1575.6453561164712
R28105 n_33_11_10 n_33_11_11 0.4598687621083101
R28106 n_33_11_11 n_34_11_11 23.905153264398933
R28107 n_33_11_11 n_33_12_11 1575.645356116491
R28108 n_33_11_11 n_33_11_12 0.4598687621083086
R28109 n_33_11_12 n_34_11_12 23.90515326439878
R28110 n_33_11_12 n_33_12_12 1575.6453561164815
R28111 n_33_11_12 n_33_11_13 0.45986876210831307
R28112 n_33_11_13 n_34_11_13 23.905153264398475
R28113 n_33_11_13 n_33_12_13 1575.6453561164615
R28114 n_33_11_13 n_33_11_14 2.299343810541571
R28115 n_33_11_14 n_34_11_14 2.6561281404887307
R28116 n_33_11_14 n_33_12_14 175.07170623516313
R28117 n_33_11_14 n_33_11_15 71.04972374573519
R28118 n_33_11_15 n_34_11_15 878.5143824666391
R28119 n_33_11_15 n_33_12_15 57904.96683727963
R28120 n_33_12_0 n_34_12_0 720.9892863181162
R28121 n_33_12_0 n_33_13_0 28.305778813336563
R28122 n_33_12_0 n_33_12_1 3269.3174529402795
R28123 n_33_12_1 n_34_12_1 1009.3850008453628
R28124 n_33_12_1 n_33_13_1 39.628090338671186
R28125 n_33_12_1 n_33_12_2 7430.266938500636
R28126 n_33_12_2 n_34_12_2 1802.4732157952908
R28127 n_33_12_2 n_33_13_2 70.7644470333414
R28128 n_33_12_2 n_33_12_3 6954.729854436595
R28129 n_33_12_3 n_34_12_3 25234.625021134045
R28130 n_33_12_3 n_33_13_3 990.7022584667787
R28131 n_33_12_3 n_33_12_4 92.46554412356353
R28132 n_33_12_4 n_34_12_4 764.6856067010318
R28133 n_33_12_4 n_33_13_4 30.02128055959935
R28134 n_33_12_4 n_33_12_5 76.42560279600659
R28135 n_33_12_5 n_34_12_5 4806.59524212077
R28136 n_33_12_5 n_33_13_5 188.70519208891025
R28137 n_33_12_5 n_33_12_6 26.418726892446728
R28138 n_33_12_6 n_34_12_6 801.0992070201285
R28139 n_33_12_6 n_33_13_6 31.450865348151705
R28140 n_33_12_6 n_33_12_7 35.85398649689195
R28141 n_33_12_7 n_34_12_7 1373.3129263202245
R28142 n_33_12_7 n_33_13_7 53.91576916826023
R28143 n_33_12_7 n_33_12_8 26.418726892446646
R28144 n_33_12_8 n_34_12_8 1373.3129263202245
R28145 n_33_12_8 n_33_13_8 53.91576916826023
R28146 n_33_12_8 n_33_12_9 26.418726892446646
R28147 n_33_12_9 n_34_12_9 1373.3129263202245
R28148 n_33_12_9 n_33_13_9 53.91576916826023
R28149 n_33_12_9 n_33_12_10 26.418726892446646
R28150 n_33_12_10 n_34_12_10 1373.3129263202245
R28151 n_33_12_10 n_33_13_10 53.91576916826023
R28152 n_33_12_10 n_33_12_11 26.41872689244648
R28153 n_33_12_11 n_34_12_11 1373.312926320242
R28154 n_33_12_11 n_33_13_11 53.91576916826091
R28155 n_33_12_11 n_33_12_12 26.418726892446394
R28156 n_33_12_12 n_34_12_12 1373.3129263202331
R28157 n_33_12_12 n_33_13_12 53.91576916826058
R28158 n_33_12_12 n_33_12_13 26.41872689244665
R28159 n_33_12_13 n_34_12_13 1373.3129263202159
R28160 n_33_12_13 n_33_13_13 53.9157691682599
R28161 n_33_12_13 n_33_12_14 132.09363446223358
R28162 n_33_12_14 n_34_12_14 152.59032514669127
R28163 n_33_12_14 n_33_13_14 5.99064101869557
R28164 n_33_12_14 n_33_12_15 4081.6933048830547
R28165 n_33_12_15 n_34_12_15 50469.25004226765
R28166 n_33_12_15 n_33_13_15 1981.40451693354
R28167 n_33_13_0 n_34_13_0 720.9892863181162
R28168 n_33_13_0 n_33_14_0 28.305778813336563
R28169 n_33_13_0 n_33_13_1 3269.3174529402795
R28170 n_33_13_1 n_34_13_1 1009.3850008453628
R28171 n_33_13_1 n_33_14_1 39.628090338671186
R28172 n_33_13_1 n_33_13_2 7430.266938500636
R28173 n_33_13_2 n_34_13_2 1802.4732157952908
R28174 n_33_13_2 n_33_14_2 70.7644470333414
R28175 n_33_13_2 n_33_13_3 6954.729854436595
R28176 n_33_13_3 n_34_13_3 25234.625021134045
R28177 n_33_13_3 n_33_14_3 990.7022584667787
R28178 n_33_13_3 n_33_13_4 92.46554412356353
R28179 n_33_13_4 n_34_13_4 764.6856067010318
R28180 n_33_13_4 n_33_14_4 30.02128055959935
R28181 n_33_13_4 n_33_13_5 76.42560279600659
R28182 n_33_13_5 n_34_13_5 4806.59524212077
R28183 n_33_13_5 n_33_14_5 188.70519208891025
R28184 n_33_13_5 n_33_13_6 26.418726892446728
R28185 n_33_13_6 n_34_13_6 801.0992070201285
R28186 n_33_13_6 n_33_14_6 31.450865348151705
R28187 n_33_13_6 n_33_13_7 35.85398649689195
R28188 n_33_13_7 n_34_13_7 1373.3129263202245
R28189 n_33_13_7 n_33_14_7 53.91576916826023
R28190 n_33_13_7 n_33_13_8 26.418726892446646
R28191 n_33_13_8 n_34_13_8 1373.3129263202245
R28192 n_33_13_8 n_33_14_8 53.91576916826023
R28193 n_33_13_8 n_33_13_9 26.418726892446646
R28194 n_33_13_9 n_34_13_9 1373.3129263202245
R28195 n_33_13_9 n_33_14_9 53.91576916826023
R28196 n_33_13_9 n_33_13_10 26.418726892446646
R28197 n_33_13_10 n_34_13_10 1373.3129263202245
R28198 n_33_13_10 n_33_14_10 53.91576916826023
R28199 n_33_13_10 n_33_13_11 26.41872689244648
R28200 n_33_13_11 n_34_13_11 1373.312926320242
R28201 n_33_13_11 n_33_14_11 53.91576916826091
R28202 n_33_13_11 n_33_13_12 26.418726892446394
R28203 n_33_13_12 n_34_13_12 1373.3129263202331
R28204 n_33_13_12 n_33_14_12 53.91576916826058
R28205 n_33_13_12 n_33_13_13 26.41872689244665
R28206 n_33_13_13 n_34_13_13 1373.3129263202159
R28207 n_33_13_13 n_33_14_13 53.9157691682599
R28208 n_33_13_13 n_33_13_14 132.09363446223358
R28209 n_33_13_14 n_34_13_14 152.59032514669127
R28210 n_33_13_14 n_33_14_14 5.99064101869557
R28211 n_33_13_14 n_33_13_15 4081.6933048830547
R28212 n_33_13_15 n_34_13_15 50469.25004226765
R28213 n_33_13_15 n_33_14_15 1981.40451693354
R28214 n_33_14_0 n_34_14_0 720.9892863181162
R28215 n_33_14_0 n_33_15_0 28.305778813336563
R28216 n_33_14_0 n_33_14_1 3269.3174529402795
R28217 n_33_14_1 n_34_14_1 1009.3850008453628
R28218 n_33_14_1 n_33_15_1 39.628090338671186
R28219 n_33_14_1 n_33_14_2 7430.266938500636
R28220 n_33_14_2 n_34_14_2 1802.4732157952908
R28221 n_33_14_2 n_33_15_2 70.7644470333414
R28222 n_33_14_2 n_33_14_3 6954.729854436595
R28223 n_33_14_3 n_34_14_3 25234.625021134045
R28224 n_33_14_3 n_33_15_3 990.7022584667787
R28225 n_33_14_3 n_33_14_4 92.46554412356353
R28226 n_33_14_4 n_34_14_4 764.6856067010318
R28227 n_33_14_4 n_33_15_4 30.02128055959935
R28228 n_33_14_4 n_33_14_5 76.42560279600659
R28229 n_33_14_5 n_34_14_5 4806.59524212077
R28230 n_33_14_5 n_33_15_5 188.70519208891025
R28231 n_33_14_5 n_33_14_6 26.418726892446728
R28232 n_33_14_6 n_34_14_6 801.0992070201285
R28233 n_33_14_6 n_33_15_6 31.450865348151705
R28234 n_33_14_6 n_33_14_7 35.85398649689195
R28235 n_33_14_7 n_34_14_7 1373.3129263202245
R28236 n_33_14_7 n_33_15_7 53.91576916826023
R28237 n_33_14_7 n_33_14_8 26.418726892446646
R28238 n_33_14_8 n_34_14_8 1373.3129263202245
R28239 n_33_14_8 n_33_15_8 53.91576916826023
R28240 n_33_14_8 n_33_14_9 26.418726892446646
R28241 n_33_14_9 n_34_14_9 1373.3129263202245
R28242 n_33_14_9 n_33_15_9 53.91576916826023
R28243 n_33_14_9 n_33_14_10 26.418726892446646
R28244 n_33_14_10 n_34_14_10 1373.3129263202245
R28245 n_33_14_10 n_33_15_10 53.91576916826023
R28246 n_33_14_10 n_33_14_11 26.41872689244648
R28247 n_33_14_11 n_34_14_11 1373.312926320242
R28248 n_33_14_11 n_33_15_11 53.91576916826091
R28249 n_33_14_11 n_33_14_12 26.418726892446394
R28250 n_33_14_12 n_34_14_12 1373.3129263202331
R28251 n_33_14_12 n_33_15_12 53.91576916826058
R28252 n_33_14_12 n_33_14_13 26.41872689244665
R28253 n_33_14_13 n_34_14_13 1373.3129263202159
R28254 n_33_14_13 n_33_15_13 53.9157691682599
R28255 n_33_14_13 n_33_14_14 132.09363446223358
R28256 n_33_14_14 n_34_14_14 152.59032514669127
R28257 n_33_14_14 n_33_15_14 5.99064101869557
R28258 n_33_14_14 n_33_14_15 4081.6933048830547
R28259 n_33_14_15 n_34_14_15 50469.25004226765
R28260 n_33_14_15 n_33_15_15 1981.40451693354
R28261 n_33_15_0 n_34_15_0 720.9892863181162
R28262 n_33_15_0 n_33_16_0 827.2138119611451
R28263 n_33_15_0 n_33_15_1 3269.3174529402795
R28264 n_33_15_1 n_34_15_1 1009.3850008453628
R28265 n_33_15_1 n_33_16_1 1158.099336745603
R28266 n_33_15_1 n_33_15_2 7430.266938500636
R28267 n_33_15_2 n_34_15_2 1802.4732157952908
R28268 n_33_15_2 n_33_16_2 2068.0345299028627
R28269 n_33_15_2 n_33_15_3 6954.729854436595
R28270 n_33_15_3 n_34_15_3 25234.625021134045
R28271 n_33_15_3 n_33_16_3 28952.483418640055
R28272 n_33_15_3 n_33_15_4 92.46554412356353
R28273 n_33_15_4 n_34_15_4 764.6856067010318
R28274 n_33_15_4 n_33_16_4 877.3479823830318
R28275 n_33_15_4 n_33_15_5 76.42560279600659
R28276 n_33_15_5 n_34_15_5 4806.59524212077
R28277 n_33_15_5 n_33_16_5 5514.75874640763
R28278 n_33_15_5 n_33_15_6 26.418726892446728
R28279 n_33_15_6 n_34_15_6 801.0992070201285
R28280 n_33_15_6 n_33_16_6 919.1264577346047
R28281 n_33_15_6 n_33_15_7 35.85398649689195
R28282 n_33_15_7 n_34_15_7 1373.3129263202245
R28283 n_33_15_7 n_33_16_7 1575.6453561164703
R28284 n_33_15_7 n_33_15_8 26.418726892446646
R28285 n_33_15_8 n_34_15_8 1373.3129263202245
R28286 n_33_15_8 n_33_16_8 1575.6453561164703
R28287 n_33_15_8 n_33_15_9 26.418726892446646
R28288 n_33_15_9 n_34_15_9 1373.3129263202245
R28289 n_33_15_9 n_33_16_9 1575.6453561164703
R28290 n_33_15_9 n_33_15_10 26.418726892446646
R28291 n_33_15_10 n_34_15_10 1373.3129263202245
R28292 n_33_15_10 n_33_16_10 1575.6453561164703
R28293 n_33_15_10 n_33_15_11 26.41872689244648
R28294 n_33_15_11 n_34_15_11 1373.312926320242
R28295 n_33_15_11 n_33_16_11 1575.6453561164901
R28296 n_33_15_11 n_33_15_12 26.418726892446394
R28297 n_33_15_12 n_34_15_12 1373.3129263202331
R28298 n_33_15_12 n_33_16_12 1575.6453561164806
R28299 n_33_15_12 n_33_15_13 26.41872689244665
R28300 n_33_15_13 n_34_15_13 1373.3129263202159
R28301 n_33_15_13 n_33_16_13 1575.6453561164606
R28302 n_33_15_13 n_33_15_14 132.09363446223358
R28303 n_33_15_14 n_34_15_14 152.59032514669127
R28304 n_33_15_14 n_33_16_14 175.07170623516302
R28305 n_33_15_14 n_33_15_15 4081.6933048830547
R28306 n_33_15_15 n_34_15_15 50469.25004226765
R28307 n_33_15_15 n_33_16_15 57904.96683727959
R28308 n_33_16_0 n_34_16_0 12.550205463809261
R28309 n_33_16_0 n_33_17_0 1626.1218451089546
R28310 n_33_16_0 n_33_16_1 56.9087593109039
R28311 n_33_16_1 n_34_16_1 17.57028764933296
R28312 n_33_16_1 n_33_17_1 2276.5705831525365
R28313 n_33_16_1 n_33_16_2 129.33808934296343
R28314 n_33_16_2 n_34_16_2 31.375513659523147
R28315 n_33_16_2 n_33_17_2 4065.3046127723865
R28316 n_33_16_2 n_33_16_3 121.06045162501377
R28317 n_33_16_3 n_34_16_3 439.2571912333236
R28318 n_33_16_3 n_33_17_3 56914.26457881337
R28319 n_33_16_3 n_33_16_4 1.6095406673791017
R28320 n_33_16_4 n_34_16_4 13.31082397676738
R28321 n_33_16_4 n_33_17_4 1724.6746842064654
R28322 n_33_16_4 n_33_16_5 1.3303346332419106
R28323 n_33_16_5 n_34_16_5 83.66803642539499
R28324 n_33_16_5 n_33_17_5 10840.812300726357
R28325 n_33_16_5 n_33_16_6 0.45986876210831473
R28326 n_33_16_6 n_34_16_6 13.944672737565831
R28327 n_33_16_6 n_33_17_6 1806.802050121059
R28328 n_33_16_6 n_33_16_7 0.6241076057184265
R28329 n_33_16_7 n_34_16_7 23.90515326439864
R28330 n_33_16_7 n_33_17_7 3097.374943064682
R28331 n_33_16_7 n_33_16_8 0.4598687621083133
R28332 n_33_16_8 n_34_16_8 23.90515326439864
R28333 n_33_16_8 n_33_17_8 3097.374943064682
R28334 n_33_16_8 n_33_16_9 0.4598687621083133
R28335 n_33_16_9 n_34_16_9 23.90515326439864
R28336 n_33_16_9 n_33_17_9 3097.374943064682
R28337 n_33_16_9 n_33_16_10 0.4598687621083133
R28338 n_33_16_10 n_34_16_10 23.90515326439864
R28339 n_33_16_10 n_33_17_10 3097.374943064682
R28340 n_33_16_10 n_33_16_11 0.45986876210831035
R28341 n_33_16_11 n_34_16_11 23.905153264398947
R28342 n_33_16_11 n_33_17_11 3097.3749430647213
R28343 n_33_16_11 n_33_16_12 0.45986876210830885
R28344 n_33_16_12 n_34_16_12 23.90515326439879
R28345 n_33_16_12 n_33_17_12 3097.374943064702
R28346 n_33_16_12 n_33_16_13 0.4598687621083133
R28347 n_33_16_13 n_34_16_13 23.90515326439849
R28348 n_33_16_13 n_33_17_13 3097.374943064663
R28349 n_33_16_13 n_33_16_14 2.2993438105415724
R28350 n_33_16_14 n_34_16_14 2.6561281404887325
R28351 n_33_16_14 n_33_17_14 344.15277145163066
R28352 n_33_16_14 n_33_16_15 71.04972374573525
R28353 n_33_16_15 n_34_16_15 878.5143824666395
R28354 n_33_16_15 n_33_17_15 113828.52915762572
R28355 n_33_17_0 n_34_17_0 12.550205463809242
R28356 n_33_17_0 n_33_18_0 1626.1218451089555
R28357 n_33_17_0 n_33_17_1 56.90875931090384
R28358 n_33_17_1 n_34_17_1 17.57028764933294
R28359 n_33_17_1 n_33_18_1 2276.570583152538
R28360 n_33_17_1 n_33_17_2 129.33808934296326
R28361 n_33_17_2 n_34_17_2 31.375513659523108
R28362 n_33_17_2 n_33_18_2 4065.3046127723887
R28363 n_33_17_2 n_33_17_3 121.06045162501361
R28364 n_33_17_3 n_34_17_3 439.25719123332317
R28365 n_33_17_3 n_33_18_3 56914.264578813396
R28366 n_33_17_3 n_33_17_4 1.6095406673791
R28367 n_33_17_4 n_34_17_4 13.310823976767367
R28368 n_33_17_4 n_33_18_4 1724.6746842064663
R28369 n_33_17_4 n_33_17_5 1.330334633241909
R28370 n_33_17_5 n_34_17_5 83.66803642539489
R28371 n_33_17_5 n_33_18_5 10840.812300726362
R28372 n_33_17_5 n_33_17_6 0.45986876210831423
R28373 n_33_17_6 n_34_17_6 13.944672737565813
R28374 n_33_17_6 n_33_18_6 1806.8020501210601
R28375 n_33_17_6 n_33_17_7 0.6241076057184257
R28376 n_33_17_7 n_34_17_7 23.905153264398614
R28377 n_33_17_7 n_33_18_7 3097.374943064684
R28378 n_33_17_7 n_33_17_8 0.4598687621083128
R28379 n_33_17_8 n_34_17_8 23.905153264398614
R28380 n_33_17_8 n_33_18_8 3097.374943064684
R28381 n_33_17_8 n_33_17_9 0.4598687621083128
R28382 n_33_17_9 n_34_17_9 23.905153264398614
R28383 n_33_17_9 n_33_18_9 3097.374943064684
R28384 n_33_17_9 n_33_17_10 0.4598687621083128
R28385 n_33_17_10 n_34_17_10 23.905153264398614
R28386 n_33_17_10 n_33_18_10 3097.374943064684
R28387 n_33_17_10 n_33_17_11 0.45986876210830985
R28388 n_33_17_11 n_34_17_11 23.905153264398916
R28389 n_33_17_11 n_33_18_11 3097.374943064723
R28390 n_33_17_11 n_33_17_12 0.4598687621083084
R28391 n_33_17_12 n_34_17_12 23.905153264398766
R28392 n_33_17_12 n_33_18_12 3097.374943064704
R28393 n_33_17_12 n_33_17_13 0.45986876210831285
R28394 n_33_17_13 n_34_17_13 23.905153264398457
R28395 n_33_17_13 n_33_18_13 3097.3749430646653
R28396 n_33_17_13 n_33_17_14 2.29934381054157
R28397 n_33_17_14 n_34_17_14 2.656128140488729
R28398 n_33_17_14 n_33_18_14 344.1527714516309
R28399 n_33_17_14 n_33_17_15 71.04972374573515
R28400 n_33_17_15 n_34_17_15 878.5143824666385
R28401 n_33_17_15 n_33_18_15 113828.52915762579
R28402 n_33_18_0 n_34_18_0 12.550205463809242
R28403 n_33_18_0 n_33_19_0 1626.1218451089546
R28404 n_33_18_0 n_33_18_1 56.90875931090384
R28405 n_33_18_1 n_34_18_1 17.57028764933294
R28406 n_33_18_1 n_33_19_1 2276.5705831525365
R28407 n_33_18_1 n_33_18_2 129.33808934296326
R28408 n_33_18_2 n_34_18_2 31.375513659523108
R28409 n_33_18_2 n_33_19_2 4065.3046127723865
R28410 n_33_18_2 n_33_18_3 121.06045162501361
R28411 n_33_18_3 n_34_18_3 439.25719123332317
R28412 n_33_18_3 n_33_19_3 56914.26457881337
R28413 n_33_18_3 n_33_18_4 1.6095406673791
R28414 n_33_18_4 n_34_18_4 13.310823976767367
R28415 n_33_18_4 n_33_19_4 1724.6746842064654
R28416 n_33_18_4 n_33_18_5 1.330334633241909
R28417 n_33_18_5 n_34_18_5 83.66803642539489
R28418 n_33_18_5 n_33_19_5 10840.812300726357
R28419 n_33_18_5 n_33_18_6 0.45986876210831423
R28420 n_33_18_6 n_34_18_6 13.944672737565813
R28421 n_33_18_6 n_33_19_6 1806.802050121059
R28422 n_33_18_6 n_33_18_7 0.6241076057184257
R28423 n_33_18_7 n_34_18_7 23.905153264398614
R28424 n_33_18_7 n_33_19_7 3097.374943064682
R28425 n_33_18_7 n_33_18_8 0.4598687621083128
R28426 n_33_18_8 n_34_18_8 23.905153264398614
R28427 n_33_18_8 n_33_19_8 3097.374943064682
R28428 n_33_18_8 n_33_18_9 0.4598687621083128
R28429 n_33_18_9 n_34_18_9 23.905153264398614
R28430 n_33_18_9 n_33_19_9 3097.374943064682
R28431 n_33_18_9 n_33_18_10 0.4598687621083128
R28432 n_33_18_10 n_34_18_10 23.905153264398614
R28433 n_33_18_10 n_33_19_10 3097.374943064682
R28434 n_33_18_10 n_33_18_11 0.45986876210830985
R28435 n_33_18_11 n_34_18_11 23.905153264398916
R28436 n_33_18_11 n_33_19_11 3097.3749430647213
R28437 n_33_18_11 n_33_18_12 0.4598687621083084
R28438 n_33_18_12 n_34_18_12 23.905153264398766
R28439 n_33_18_12 n_33_19_12 3097.374943064702
R28440 n_33_18_12 n_33_18_13 0.45986876210831285
R28441 n_33_18_13 n_34_18_13 23.905153264398457
R28442 n_33_18_13 n_33_19_13 3097.374943064663
R28443 n_33_18_13 n_33_18_14 2.29934381054157
R28444 n_33_18_14 n_34_18_14 2.656128140488729
R28445 n_33_18_14 n_33_19_14 344.15277145163066
R28446 n_33_18_14 n_33_18_15 71.04972374573515
R28447 n_33_18_15 n_34_18_15 878.5143824666385
R28448 n_33_18_15 n_33_19_15 113828.52915762572
R28449 n_33_19_0 n_34_19_0 12.550205463809261
R28450 n_33_19_0 n_33_20_0 827.2138145479913
R28451 n_33_19_0 n_33_19_1 56.9087593109039
R28452 n_33_19_1 n_34_19_1 17.57028764933296
R28453 n_33_19_1 n_33_20_1 1158.0993403671878
R28454 n_33_19_1 n_33_19_2 129.33808934296343
R28455 n_33_19_2 n_34_19_2 31.375513659523147
R28456 n_33_19_2 n_33_20_2 2068.034536369978
R28457 n_33_19_2 n_33_19_3 121.06045162501377
R28458 n_33_19_3 n_34_19_3 439.2571912333236
R28459 n_33_19_3 n_33_20_3 28952.48350917967
R28460 n_33_19_3 n_33_19_4 1.6095406673791017
R28461 n_33_19_4 n_34_19_4 13.31082397676738
R28462 n_33_19_4 n_33_20_4 877.3479851266566
R28463 n_33_19_4 n_33_19_5 1.3303346332419106
R28464 n_33_19_5 n_34_19_5 83.66803642539499
R28465 n_33_19_5 n_33_20_5 5514.758763653271
R28466 n_33_19_5 n_33_19_6 0.45986876210831473
R28467 n_33_19_6 n_34_19_6 13.944672737565831
R28468 n_33_19_6 n_33_20_6 919.1264606088783
R28469 n_33_19_6 n_33_19_7 0.6241076057184265
R28470 n_33_19_7 n_34_19_7 23.90515326439864
R28471 n_33_19_7 n_33_20_7 1575.6453610437964
R28472 n_33_19_7 n_33_19_8 0.4598687621083133
R28473 n_33_19_8 n_34_19_8 23.90515326439864
R28474 n_33_19_8 n_33_20_8 1575.6453610437964
R28475 n_33_19_8 n_33_19_9 0.4598687621083133
R28476 n_33_19_9 n_34_19_9 23.90515326439864
R28477 n_33_19_9 n_33_20_9 1575.6453610437964
R28478 n_33_19_9 n_33_19_10 0.4598687621083133
R28479 n_33_19_10 n_34_19_10 23.90515326439864
R28480 n_33_19_10 n_33_20_10 1575.6453610437964
R28481 n_33_19_10 n_33_19_11 0.45986876210831035
R28482 n_33_19_11 n_34_19_11 23.905153264398947
R28483 n_33_19_11 n_33_20_11 1575.6453610438164
R28484 n_33_19_11 n_33_19_12 0.45986876210830885
R28485 n_33_19_12 n_34_19_12 23.90515326439879
R28486 n_33_19_12 n_33_20_12 1575.6453610438066
R28487 n_33_19_12 n_33_19_13 0.4598687621083133
R28488 n_33_19_13 n_34_19_13 23.90515326439849
R28489 n_33_19_13 n_33_20_13 1575.6453610437866
R28490 n_33_19_13 n_33_19_14 2.2993438105415724
R28491 n_33_19_14 n_34_19_14 2.6561281404887325
R28492 n_33_19_14 n_33_20_14 175.0717067826437
R28493 n_33_19_14 n_33_19_15 71.04972374573525
R28494 n_33_19_15 n_34_19_15 878.5143824666395
R28495 n_33_19_15 n_33_20_15 57904.967018358824
R28496 n_33_20_0 n_34_20_0 720.9891545366825
R28497 n_33_20_0 n_33_21_0 28.305783987028974
R28498 n_33_20_0 n_33_20_1 3269.3168553789146
R28499 n_33_20_1 n_34_20_1 1009.3848163513552
R28500 n_33_20_1 n_33_21_1 39.628097581840564
R28501 n_33_20_1 n_33_20_2 7430.265580406624
R28502 n_33_20_2 n_34_20_2 1802.4728863417063
R28503 n_33_20_2 n_33_21_2 70.76445996757244
R28504 n_33_20_2 n_33_20_3 6954.7285832606
R28505 n_33_20_3 n_34_20_3 25234.620408783856
R28506 n_33_20_3 n_33_21_3 990.7024395460132
R28507 n_33_20_3 n_33_20_4 92.46552722283808
R28508 n_33_20_4 n_34_20_4 764.6854669328443
R28509 n_33_20_4 n_33_21_4 30.021286046848882
R28510 n_33_20_4 n_33_20_5 76.42558882703963
R28511 n_33_20_5 n_34_20_5 4806.594363577878
R28512 n_33_20_5 n_33_21_5 188.705226580193
R28513 n_33_20_5 n_33_20_6 26.41872206366802
R28514 n_33_20_6 n_34_20_6 801.099060596313
R28515 n_33_20_6 n_33_21_6 31.45087109669883
R28516 n_33_20_6 n_33_20_7 35.85397994354942
R28517 n_33_20_7 n_34_20_7 1373.3126753079694
R28518 n_33_20_7 n_33_21_7 53.915779022912446
R28519 n_33_20_7 n_33_20_8 26.41872206366794
R28520 n_33_20_8 n_34_20_8 1373.3126753079694
R28521 n_33_20_8 n_33_21_8 53.915779022912446
R28522 n_33_20_8 n_33_20_9 26.41872206366794
R28523 n_33_20_9 n_34_20_9 1373.3126753079694
R28524 n_33_20_9 n_33_21_9 53.915779022912446
R28525 n_33_20_9 n_33_20_10 26.41872206366794
R28526 n_33_20_10 n_34_20_10 1373.3126753079694
R28527 n_33_20_10 n_33_21_10 53.915779022912446
R28528 n_33_20_10 n_33_20_11 26.418722063667772
R28529 n_33_20_11 n_34_20_11 1373.312675307987
R28530 n_33_20_11 n_33_21_11 53.91577902291313
R28531 n_33_20_11 n_33_20_12 26.418722063667687
R28532 n_33_20_12 n_34_20_12 1373.312675307978
R28533 n_33_20_12 n_33_21_12 53.915779022912794
R28534 n_33_20_12 n_33_20_13 26.418722063667936
R28535 n_33_20_13 n_34_20_13 1373.3126753079605
R28536 n_33_20_13 n_33_21_13 53.91577902291212
R28537 n_33_20_13 n_33_20_14 132.09361031834004
R28538 n_33_20_14 n_34_20_14 152.59029725644075
R28539 n_33_20_14 n_33_21_14 5.990642113656927
R28540 n_33_20_14 n_33_20_15 4081.6925588367444
R28541 n_33_20_15 n_34_20_15 50469.24081756726
R28542 n_33_20_15 n_33_21_15 1981.4048790920087
R28543 n_33_21_0 n_34_21_0 720.9891545366825
R28544 n_33_21_0 n_33_22_0 28.30578398702797
R28545 n_33_21_0 n_33_21_1 3269.3168553789146
R28546 n_33_21_1 n_34_21_1 1009.3848163513552
R28547 n_33_21_1 n_33_22_1 39.62809758183916
R28548 n_33_21_1 n_33_21_2 7430.265580406624
R28549 n_33_21_2 n_34_21_2 1802.4728863417063
R28550 n_33_21_2 n_33_22_2 70.76445996756992
R28551 n_33_21_2 n_33_21_3 6954.7285832606
R28552 n_33_21_3 n_34_21_3 25234.620408783856
R28553 n_33_21_3 n_33_22_3 990.702439545978
R28554 n_33_21_3 n_33_21_4 92.46552722283808
R28555 n_33_21_4 n_34_21_4 764.6854669328443
R28556 n_33_21_4 n_33_22_4 30.021286046847816
R28557 n_33_21_4 n_33_21_5 76.42558882703963
R28558 n_33_21_5 n_34_21_5 4806.594363577878
R28559 n_33_21_5 n_33_22_5 188.70522658018632
R28560 n_33_21_5 n_33_21_6 26.41872206366802
R28561 n_33_21_6 n_34_21_6 801.099060596313
R28562 n_33_21_6 n_33_22_6 31.45087109669771
R28563 n_33_21_6 n_33_21_7 35.85397994354942
R28564 n_33_21_7 n_34_21_7 1373.3126753079694
R28565 n_33_21_7 n_33_22_7 53.915779022910534
R28566 n_33_21_7 n_33_21_8 26.41872206366794
R28567 n_33_21_8 n_34_21_8 1373.3126753079694
R28568 n_33_21_8 n_33_22_8 53.915779022910534
R28569 n_33_21_8 n_33_21_9 26.41872206366794
R28570 n_33_21_9 n_34_21_9 1373.3126753079694
R28571 n_33_21_9 n_33_22_9 53.915779022910534
R28572 n_33_21_9 n_33_21_10 26.41872206366794
R28573 n_33_21_10 n_34_21_10 1373.3126753079694
R28574 n_33_21_10 n_33_22_10 53.915779022910534
R28575 n_33_21_10 n_33_21_11 26.418722063667772
R28576 n_33_21_11 n_34_21_11 1373.312675307987
R28577 n_33_21_11 n_33_22_11 53.91577902291121
R28578 n_33_21_11 n_33_21_12 26.418722063667687
R28579 n_33_21_12 n_34_21_12 1373.312675307978
R28580 n_33_21_12 n_33_22_12 53.91577902291088
R28581 n_33_21_12 n_33_21_13 26.418722063667936
R28582 n_33_21_13 n_34_21_13 1373.3126753079605
R28583 n_33_21_13 n_33_22_13 53.9157790229102
R28584 n_33_21_13 n_33_21_14 132.09361031834004
R28585 n_33_21_14 n_34_21_14 152.59029725644075
R28586 n_33_21_14 n_33_22_14 5.990642113656714
R28587 n_33_21_14 n_33_21_15 4081.6925588367444
R28588 n_33_21_15 n_34_21_15 50469.24081756726
R28589 n_33_21_15 n_33_22_15 1981.4048790919383
R28590 n_33_22_0 n_34_22_0 720.9891545367336
R28591 n_33_22_0 n_33_23_0 28.30578398702797
R28592 n_33_22_0 n_33_22_1 3269.316855379147
R28593 n_33_22_1 n_34_22_1 1009.3848163514269
R28594 n_33_22_1 n_33_23_1 39.62809758183916
R28595 n_33_22_1 n_33_22_2 7430.265580407153
R28596 n_33_22_2 n_34_22_2 1802.472886341834
R28597 n_33_22_2 n_33_23_2 70.76445996756992
R28598 n_33_22_2 n_33_22_3 6954.728583261095
R28599 n_33_22_3 n_34_22_3 25234.620408785653
R28600 n_33_22_3 n_33_23_3 990.702439545978
R28601 n_33_22_3 n_33_22_4 92.46552722284464
R28602 n_33_22_4 n_34_22_4 764.6854669328985
R28603 n_33_22_4 n_33_23_4 30.021286046847816
R28604 n_33_22_4 n_33_22_5 76.42558882704506
R28605 n_33_22_5 n_34_22_5 4806.59436357822
R28606 n_33_22_5 n_33_23_5 188.70522658018632
R28607 n_33_22_5 n_33_22_6 26.418722063669897
R28608 n_33_22_6 n_34_22_6 801.0990605963699
R28609 n_33_22_6 n_33_23_6 31.45087109669771
R28610 n_33_22_6 n_33_22_7 35.85397994355196
R28611 n_33_22_7 n_34_22_7 1373.312675308067
R28612 n_33_22_7 n_33_23_7 53.915779022910534
R28613 n_33_22_7 n_33_22_8 26.418722063669815
R28614 n_33_22_8 n_34_22_8 1373.312675308067
R28615 n_33_22_8 n_33_23_8 53.915779022910534
R28616 n_33_22_8 n_33_22_9 26.418722063669815
R28617 n_33_22_9 n_34_22_9 1373.312675308067
R28618 n_33_22_9 n_33_23_9 53.915779022910534
R28619 n_33_22_9 n_33_22_10 26.418722063669815
R28620 n_33_22_10 n_34_22_10 1373.312675308067
R28621 n_33_22_10 n_33_23_10 53.915779022910534
R28622 n_33_22_10 n_33_22_11 26.418722063669648
R28623 n_33_22_11 n_34_22_11 1373.3126753080844
R28624 n_33_22_11 n_33_23_11 53.91577902291121
R28625 n_33_22_11 n_33_22_12 26.418722063669563
R28626 n_33_22_12 n_34_22_12 1373.3126753080758
R28627 n_33_22_12 n_33_23_12 53.91577902291088
R28628 n_33_22_12 n_33_22_13 26.41872206366981
R28629 n_33_22_13 n_34_22_13 1373.3126753080583
R28630 n_33_22_13 n_33_23_13 53.9157790229102
R28631 n_33_22_13 n_33_22_14 132.0936103183494
R28632 n_33_22_14 n_34_22_14 152.59029725645155
R28633 n_33_22_14 n_33_23_14 5.990642113656714
R28634 n_33_22_14 n_33_22_15 4081.692558837034
R28635 n_33_22_15 n_34_22_15 50469.240817570855
R28636 n_33_22_15 n_33_23_15 1981.4048790919383
R28637 n_33_23_0 n_34_23_0 720.9891545366825
R28638 n_33_23_0 n_33_24_0 326.2736359366231
R28639 n_33_23_0 n_33_23_1 3269.3168553789146
R28640 n_33_23_1 n_34_23_1 1009.3848163513552
R28641 n_33_23_1 n_33_24_1 456.7830903112724
R28642 n_33_23_1 n_33_23_2 7430.265580406624
R28643 n_33_23_2 n_34_23_2 1802.4728863417063
R28644 n_33_23_2 n_33_24_2 815.6840898415578
R28645 n_33_23_2 n_33_23_3 6954.7285832606
R28646 n_33_23_3 n_34_23_3 25234.620408783856
R28647 n_33_23_3 n_33_24_3 11419.5772577818
R28648 n_33_23_3 n_33_23_4 92.46552722283808
R28649 n_33_23_4 n_34_23_4 764.6854669328443
R28650 n_33_23_4 n_33_24_4 346.04779569035753
R28651 n_33_23_4 n_33_23_5 76.42558882703963
R28652 n_33_23_5 n_34_23_5 4806.594363577878
R28653 n_33_23_5 n_33_24_5 2175.157572910819
R28654 n_33_23_5 n_33_23_6 26.41872206366802
R28655 n_33_23_6 n_34_23_6 801.099060596313
R28656 n_33_23_6 n_33_24_6 362.52626215180317
R28657 n_33_23_6 n_33_23_7 35.85397994354942
R28658 n_33_23_7 n_34_23_7 1373.3126753079694
R28659 n_33_23_7 n_33_24_7 621.4735922602358
R28660 n_33_23_7 n_33_23_8 26.41872206366794
R28661 n_33_23_8 n_34_23_8 1373.3126753079694
R28662 n_33_23_8 n_33_24_8 621.4735922602358
R28663 n_33_23_8 n_33_23_9 26.41872206366794
R28664 n_33_23_9 n_34_23_9 1373.3126753079694
R28665 n_33_23_9 n_33_24_9 621.4735922602358
R28666 n_33_23_9 n_33_23_10 26.41872206366794
R28667 n_33_23_10 n_34_23_10 1373.3126753079694
R28668 n_33_23_10 n_33_24_10 621.4735922602358
R28669 n_33_23_10 n_33_23_11 26.418722063667772
R28670 n_33_23_11 n_34_23_11 1373.312675307987
R28671 n_33_23_11 n_33_24_11 621.4735922602437
R28672 n_33_23_11 n_33_23_12 26.418722063667687
R28673 n_33_23_12 n_34_23_12 1373.312675307978
R28674 n_33_23_12 n_33_24_12 621.4735922602399
R28675 n_33_23_12 n_33_23_13 26.418722063667936
R28676 n_33_23_13 n_34_23_13 1373.3126753079605
R28677 n_33_23_13 n_33_24_13 621.4735922602321
R28678 n_33_23_13 n_33_23_14 132.09361031834004
R28679 n_33_23_14 n_34_23_14 152.59029725644075
R28680 n_33_23_14 n_33_24_14 69.05262136224829
R28681 n_33_23_14 n_33_23_15 4081.6925588367444
R28682 n_33_23_15 n_34_23_15 50469.24081756726
R28683 n_33_23_15 n_33_24_15 22839.154515563394
R28684 n_33_24_0 n_34_24_0 32.692737764693156
R28685 n_33_24_0 n_33_25_0 624.2414878862163
R28686 n_33_24_0 n_33_24_1 148.24483551528397
R28687 n_33_24_1 n_34_24_1 45.76983287057042
R28688 n_33_24_1 n_33_25_1 873.9380830407028
R28689 n_33_24_1 n_33_24_2 336.9200807165545
R28690 n_33_24_2 n_34_24_2 81.73184441173291
R28691 n_33_24_2 n_33_25_2 1560.6037197155406
R28692 n_33_24_2 n_33_24_3 315.357195550695
R28693 n_33_24_3 n_34_24_3 1144.2458217642595
R28694 n_33_24_3 n_33_25_3 21848.45207601755
R28695 n_33_24_3 n_33_24_4 4.192783226694903
R28696 n_33_24_4 n_34_24_4 34.67411581103816
R28697 n_33_24_4 n_33_25_4 662.0743053338651
R28698 n_33_24_4 n_33_24_5 3.4654636873702773
R28699 n_33_24_5 n_34_24_5 217.9515850979542
R28700 n_33_24_5 n_33_25_5 4161.609919241439
R28701 n_33_24_5 n_33_24_6 1.1979380647699724
R28702 n_33_24_6 n_34_24_6 36.32526418299236
R28703 n_33_24_6 n_33_25_6 693.6016532069063
R28704 n_33_24_6 n_33_24_7 1.6257730879021035
R28705 n_33_24_7 n_34_24_7 62.27188145655853
R28706 n_33_24_7 n_33_25_7 1189.0314054975574
R28707 n_33_24_7 n_33_24_8 1.1979380647699687
R28708 n_33_24_8 n_34_24_8 62.27188145655853
R28709 n_33_24_8 n_33_25_8 1189.0314054975574
R28710 n_33_24_8 n_33_24_9 1.1979380647699687
R28711 n_33_24_9 n_34_24_9 62.27188145655853
R28712 n_33_24_9 n_33_25_9 1189.0314054975574
R28713 n_33_24_9 n_33_24_10 1.1979380647699687
R28714 n_33_24_10 n_34_24_10 62.27188145655853
R28715 n_33_24_10 n_33_25_10 1189.0314054975574
R28716 n_33_24_10 n_33_24_11 1.1979380647699611
R28717 n_33_24_11 n_34_24_11 62.27188145655932
R28718 n_33_24_11 n_33_25_11 1189.0314054975725
R28719 n_33_24_11 n_33_24_12 1.1979380647699571
R28720 n_33_24_12 n_34_24_12 62.27188145655893
R28721 n_33_24_12 n_33_25_12 1189.0314054975652
R28722 n_33_24_12 n_33_24_13 1.1979380647699687
R28723 n_33_24_13 n_34_24_13 62.271881456558134
R28724 n_33_24_13 n_33_25_13 1189.0314054975502
R28725 n_33_24_13 n_33_24_14 5.9896903238498584
R28726 n_33_24_14 n_34_24_14 6.919097939617599
R28727 n_33_24_14 n_33_25_14 132.11460061083946
R28728 n_33_24_14 n_33_24_15 185.08143100696236
R28729 n_33_24_15 n_34_24_15 2288.4916435284986
R28730 n_33_24_15 n_33_25_15 43696.90415203471
R28731 n_33_25_0 n_34_25_0 32.69273776469326
R28732 n_33_25_0 n_33_26_0 624.2414878862163
R28733 n_33_25_0 n_33_25_1 148.24483551528445
R28734 n_33_25_1 n_34_25_1 45.76983287057057
R28735 n_33_25_1 n_33_26_1 873.9380830407028
R28736 n_33_25_1 n_33_25_2 336.92008071655556
R28737 n_33_25_2 n_34_25_2 81.73184441173316
R28738 n_33_25_2 n_33_26_2 1560.6037197155406
R28739 n_33_25_2 n_33_25_3 315.357195550696
R28740 n_33_25_3 n_34_25_3 1144.2458217642632
R28741 n_33_25_3 n_33_26_3 21848.45207601755
R28742 n_33_25_3 n_33_25_4 4.1927832266949165
R28743 n_33_25_4 n_34_25_4 34.67411581103828
R28744 n_33_25_4 n_33_26_4 662.0743053338651
R28745 n_33_25_4 n_33_25_5 3.4654636873702884
R28746 n_33_25_5 n_34_25_5 217.95158509795488
R28747 n_33_25_5 n_33_26_5 4161.609919241439
R28748 n_33_25_5 n_33_25_6 1.1979380647699762
R28749 n_33_25_6 n_34_25_6 36.325264182992484
R28750 n_33_25_6 n_33_26_6 693.6016532069063
R28751 n_33_25_6 n_33_25_7 1.6257730879021088
R28752 n_33_25_7 n_34_25_7 62.27188145655874
R28753 n_33_25_7 n_33_26_7 1189.0314054975574
R28754 n_33_25_7 n_33_25_8 1.1979380647699727
R28755 n_33_25_8 n_34_25_8 62.27188145655874
R28756 n_33_25_8 n_33_26_8 1189.0314054975574
R28757 n_33_25_8 n_33_25_9 1.1979380647699727
R28758 n_33_25_9 n_34_25_9 62.27188145655874
R28759 n_33_25_9 n_33_26_9 1189.0314054975574
R28760 n_33_25_9 n_33_25_10 1.1979380647699727
R28761 n_33_25_10 n_34_25_10 62.27188145655874
R28762 n_33_25_10 n_33_26_10 1189.0314054975574
R28763 n_33_25_10 n_33_25_11 1.1979380647699651
R28764 n_33_25_11 n_34_25_11 62.27188145655953
R28765 n_33_25_11 n_33_26_11 1189.0314054975725
R28766 n_33_25_11 n_33_25_12 1.1979380647699611
R28767 n_33_25_12 n_34_25_12 62.271881456559115
R28768 n_33_25_12 n_33_26_12 1189.0314054975652
R28769 n_33_25_12 n_33_25_13 1.1979380647699727
R28770 n_33_25_13 n_34_25_13 62.27188145655835
R28771 n_33_25_13 n_33_26_13 1189.0314054975502
R28772 n_33_25_13 n_33_25_14 5.989690323849878
R28773 n_33_25_14 n_34_25_14 6.919097939617622
R28774 n_33_25_14 n_33_26_14 132.11460061083946
R28775 n_33_25_14 n_33_25_15 185.08143100696296
R28776 n_33_25_15 n_34_25_15 2288.491643528506
R28777 n_33_25_15 n_33_26_15 43696.90415203471
R28778 n_33_26_0 n_34_26_0 32.692737764693156
R28779 n_33_26_0 n_33_27_0 624.2414878862173
R28780 n_33_26_0 n_33_26_1 148.24483551528397
R28781 n_33_26_1 n_34_26_1 45.76983287057042
R28782 n_33_26_1 n_33_27_1 873.9380830407042
R28783 n_33_26_1 n_33_26_2 336.9200807165545
R28784 n_33_26_2 n_34_26_2 81.73184441173291
R28785 n_33_26_2 n_33_27_2 1560.603719715543
R28786 n_33_26_2 n_33_26_3 315.357195550695
R28787 n_33_26_3 n_34_26_3 1144.2458217642595
R28788 n_33_26_3 n_33_27_3 21848.452076017587
R28789 n_33_26_3 n_33_26_4 4.192783226694903
R28790 n_33_26_4 n_34_26_4 34.67411581103816
R28791 n_33_26_4 n_33_27_4 662.0743053338662
R28792 n_33_26_4 n_33_26_5 3.4654636873702773
R28793 n_33_26_5 n_34_26_5 217.9515850979542
R28794 n_33_26_5 n_33_27_5 4161.609919241445
R28795 n_33_26_5 n_33_26_6 1.1979380647699724
R28796 n_33_26_6 n_34_26_6 36.32526418299236
R28797 n_33_26_6 n_33_27_6 693.6016532069075
R28798 n_33_26_6 n_33_26_7 1.6257730879021035
R28799 n_33_26_7 n_34_26_7 62.27188145655853
R28800 n_33_26_7 n_33_27_7 1189.0314054975593
R28801 n_33_26_7 n_33_26_8 1.1979380647699687
R28802 n_33_26_8 n_34_26_8 62.27188145655853
R28803 n_33_26_8 n_33_27_8 1189.0314054975593
R28804 n_33_26_8 n_33_26_9 1.1979380647699687
R28805 n_33_26_9 n_34_26_9 62.27188145655853
R28806 n_33_26_9 n_33_27_9 1189.0314054975593
R28807 n_33_26_9 n_33_26_10 1.1979380647699687
R28808 n_33_26_10 n_34_26_10 62.27188145655853
R28809 n_33_26_10 n_33_27_10 1189.0314054975593
R28810 n_33_26_10 n_33_26_11 1.1979380647699611
R28811 n_33_26_11 n_34_26_11 62.27188145655932
R28812 n_33_26_11 n_33_27_11 1189.0314054975743
R28813 n_33_26_11 n_33_26_12 1.1979380647699571
R28814 n_33_26_12 n_34_26_12 62.27188145655893
R28815 n_33_26_12 n_33_27_12 1189.031405497567
R28816 n_33_26_12 n_33_26_13 1.1979380647699687
R28817 n_33_26_13 n_34_26_13 62.271881456558134
R28818 n_33_26_13 n_33_27_13 1189.031405497552
R28819 n_33_26_13 n_33_26_14 5.9896903238498584
R28820 n_33_26_14 n_34_26_14 6.919097939617599
R28821 n_33_26_14 n_33_27_14 132.11460061083966
R28822 n_33_26_14 n_33_26_15 185.08143100696236
R28823 n_33_26_15 n_34_26_15 2288.4916435284986
R28824 n_33_26_15 n_33_27_15 43696.90415203478
R28825 n_33_27_0 n_34_27_0 32.692737764693156
R28826 n_33_27_0 n_33_27_1 148.24483551528397
R28827 n_33_27_1 n_34_27_1 45.76983287057042
R28828 n_33_27_1 n_33_27_2 336.9200807165545
R28829 n_33_27_2 n_34_27_2 81.73184441173291
R28830 n_33_27_2 n_33_27_3 315.357195550695
R28831 n_33_27_3 n_34_27_3 1144.2458217642595
R28832 n_33_27_3 n_33_27_4 4.192783226694903
R28833 n_33_27_4 n_34_27_4 34.67411581103816
R28834 n_33_27_4 n_33_27_5 3.4654636873702773
R28835 n_33_27_5 n_34_27_5 217.9515850979542
R28836 n_33_27_5 n_33_27_6 1.1979380647699724
R28837 n_33_27_6 n_34_27_6 36.32526418299236
R28838 n_33_27_6 n_33_27_7 1.6257730879021035
R28839 n_33_27_7 n_34_27_7 62.27188145655853
R28840 n_33_27_7 n_33_27_8 1.1979380647699687
R28841 n_33_27_8 n_34_27_8 62.27188145655853
R28842 n_33_27_8 n_33_27_9 1.1979380647699687
R28843 n_33_27_9 n_34_27_9 62.27188145655853
R28844 n_33_27_9 n_33_27_10 1.1979380647699687
R28845 n_33_27_10 n_34_27_10 62.27188145655853
R28846 n_33_27_10 n_33_27_11 1.1979380647699611
R28847 n_33_27_11 n_34_27_11 62.27188145655932
R28848 n_33_27_11 n_33_27_12 1.1979380647699571
R28849 n_33_27_12 n_34_27_12 62.27188145655893
R28850 n_33_27_12 n_33_27_13 1.1979380647699687
R28851 n_33_27_13 n_34_27_13 62.271881456558134
R28852 n_33_27_13 n_33_27_14 5.9896903238498584
R28853 n_33_27_14 n_34_27_14 6.919097939617599
R28854 n_33_27_14 n_33_27_15 185.08143100696236
R28855 n_33_27_15 n_34_27_15 2288.4916435284986
R28856 n_34_0_0 n_35_0_0 32.69273494919985
R28857 n_34_0_0 n_34_1_0 624.2415416458072
R28858 n_34_0_0 n_34_0_1 148.2448227484647
R28859 n_34_0_1 n_35_0_1 45.76982892887978
R28860 n_34_0_1 n_34_1_1 873.93815830413
R28861 n_34_0_1 n_34_0_2 336.9200517010562
R28862 n_34_0_2 n_35_0_2 81.73183737299962
R28863 n_34_0_2 n_34_1_2 1560.603854114518
R28864 n_34_0_2 n_34_0_3 315.35716839218856
R28865 n_34_0_3 n_35_0_3 1144.2457232219936
R28866 n_34_0_3 n_34_1_3 21848.45395760323
R28867 n_34_0_3 n_34_0_4 4.192782865613147
R28868 n_34_0_4 n_35_0_4 34.674112824908896
R28869 n_34_0_4 n_34_1_4 662.074362351613
R28870 n_34_0_4 n_34_0_5 3.4654633889251514
R28871 n_34_0_5 n_35_0_5 217.95156632799876
R28872 n_34_0_5 n_34_1_5 4161.610277638711
R28873 n_34_0_5 n_34_0_6 1.1979379616037562
R28874 n_34_0_6 n_35_0_6 36.32526105466647
R28875 n_34_0_6 n_34_1_6 693.601712939785
R28876 n_34_0_6 n_34_0_7 1.6257729478908103
R28877 n_34_0_7 n_35_0_7 62.27187609371413
R28878 n_34_0_7 n_34_1_7 1189.0315078967783
R28879 n_34_0_7 n_34_0_8 1.1979379616037524
R28880 n_34_0_8 n_35_0_8 62.27187609371413
R28881 n_34_0_8 n_34_1_8 1189.0315078967783
R28882 n_34_0_8 n_34_0_9 1.1979379616037524
R28883 n_34_0_9 n_35_0_9 62.27187609371413
R28884 n_34_0_9 n_34_1_9 1189.0315078967783
R28885 n_34_0_9 n_34_0_10 1.1979379616037524
R28886 n_34_0_10 n_35_0_10 62.27187609371413
R28887 n_34_0_10 n_34_1_10 1189.0315078967783
R28888 n_34_0_10 n_34_0_11 1.1979379616037447
R28889 n_34_0_11 n_35_0_11 62.27187609371492
R28890 n_34_0_11 n_34_1_11 1189.031507896793
R28891 n_34_0_11 n_34_0_12 1.197937961603741
R28892 n_34_0_12 n_35_0_12 62.271876093714546
R28893 n_34_0_12 n_34_1_12 1189.0315078967858
R28894 n_34_0_12 n_34_0_13 1.1979379616037524
R28895 n_34_0_13 n_35_0_13 62.271876093713736
R28896 n_34_0_13 n_34_1_13 1189.0315078967706
R28897 n_34_0_13 n_34_0_14 5.9896898080187775
R28898 n_34_0_14 n_35_0_14 6.9190973437459995
R28899 n_34_0_14 n_34_1_14 132.11461198853064
R28900 n_34_0_14 n_34_0_15 185.08141506778196
R28901 n_34_0_15 n_35_0_15 2288.4914464439667
R28902 n_34_0_15 n_34_1_15 43696.90791520607
R28903 n_34_1_0 n_35_1_0 32.69273494919985
R28904 n_34_1_0 n_34_2_0 624.2415416458072
R28905 n_34_1_0 n_34_1_1 148.2448227484647
R28906 n_34_1_1 n_35_1_1 45.76982892887978
R28907 n_34_1_1 n_34_2_1 873.93815830413
R28908 n_34_1_1 n_34_1_2 336.9200517010562
R28909 n_34_1_2 n_35_1_2 81.73183737299962
R28910 n_34_1_2 n_34_2_2 1560.603854114518
R28911 n_34_1_2 n_34_1_3 315.35716839218856
R28912 n_34_1_3 n_35_1_3 1144.2457232219936
R28913 n_34_1_3 n_34_2_3 21848.45395760323
R28914 n_34_1_3 n_34_1_4 4.192782865613147
R28915 n_34_1_4 n_35_1_4 34.674112824908896
R28916 n_34_1_4 n_34_2_4 662.074362351613
R28917 n_34_1_4 n_34_1_5 3.4654633889251514
R28918 n_34_1_5 n_35_1_5 217.95156632799876
R28919 n_34_1_5 n_34_2_5 4161.610277638711
R28920 n_34_1_5 n_34_1_6 1.1979379616037562
R28921 n_34_1_6 n_35_1_6 36.32526105466647
R28922 n_34_1_6 n_34_2_6 693.601712939785
R28923 n_34_1_6 n_34_1_7 1.6257729478908103
R28924 n_34_1_7 n_35_1_7 62.27187609371413
R28925 n_34_1_7 n_34_2_7 1189.0315078967783
R28926 n_34_1_7 n_34_1_8 1.1979379616037524
R28927 n_34_1_8 n_35_1_8 62.27187609371413
R28928 n_34_1_8 n_34_2_8 1189.0315078967783
R28929 n_34_1_8 n_34_1_9 1.1979379616037524
R28930 n_34_1_9 n_35_1_9 62.27187609371413
R28931 n_34_1_9 n_34_2_9 1189.0315078967783
R28932 n_34_1_9 n_34_1_10 1.1979379616037524
R28933 n_34_1_10 n_35_1_10 62.27187609371413
R28934 n_34_1_10 n_34_2_10 1189.0315078967783
R28935 n_34_1_10 n_34_1_11 1.1979379616037447
R28936 n_34_1_11 n_35_1_11 62.27187609371492
R28937 n_34_1_11 n_34_2_11 1189.031507896793
R28938 n_34_1_11 n_34_1_12 1.197937961603741
R28939 n_34_1_12 n_35_1_12 62.271876093714546
R28940 n_34_1_12 n_34_2_12 1189.0315078967858
R28941 n_34_1_12 n_34_1_13 1.1979379616037524
R28942 n_34_1_13 n_35_1_13 62.271876093713736
R28943 n_34_1_13 n_34_2_13 1189.0315078967706
R28944 n_34_1_13 n_34_1_14 5.9896898080187775
R28945 n_34_1_14 n_35_1_14 6.9190973437459995
R28946 n_34_1_14 n_34_2_14 132.11461198853064
R28947 n_34_1_14 n_34_1_15 185.08141506778196
R28948 n_34_1_15 n_35_1_15 2288.4914464439667
R28949 n_34_1_15 n_34_2_15 43696.90791520607
R28950 n_34_2_0 n_35_2_0 32.69273494919985
R28951 n_34_2_0 n_34_3_0 624.2415416458072
R28952 n_34_2_0 n_34_2_1 148.2448227484647
R28953 n_34_2_1 n_35_2_1 45.76982892887978
R28954 n_34_2_1 n_34_3_1 873.93815830413
R28955 n_34_2_1 n_34_2_2 336.9200517010562
R28956 n_34_2_2 n_35_2_2 81.73183737299962
R28957 n_34_2_2 n_34_3_2 1560.603854114518
R28958 n_34_2_2 n_34_2_3 315.35716839218856
R28959 n_34_2_3 n_35_2_3 1144.2457232219936
R28960 n_34_2_3 n_34_3_3 21848.45395760323
R28961 n_34_2_3 n_34_2_4 4.192782865613147
R28962 n_34_2_4 n_35_2_4 34.674112824908896
R28963 n_34_2_4 n_34_3_4 662.074362351613
R28964 n_34_2_4 n_34_2_5 3.4654633889251514
R28965 n_34_2_5 n_35_2_5 217.95156632799876
R28966 n_34_2_5 n_34_3_5 4161.610277638711
R28967 n_34_2_5 n_34_2_6 1.1979379616037562
R28968 n_34_2_6 n_35_2_6 36.32526105466647
R28969 n_34_2_6 n_34_3_6 693.601712939785
R28970 n_34_2_6 n_34_2_7 1.6257729478908103
R28971 n_34_2_7 n_35_2_7 62.27187609371413
R28972 n_34_2_7 n_34_3_7 1189.0315078967783
R28973 n_34_2_7 n_34_2_8 1.1979379616037524
R28974 n_34_2_8 n_35_2_8 62.27187609371413
R28975 n_34_2_8 n_34_3_8 1189.0315078967783
R28976 n_34_2_8 n_34_2_9 1.1979379616037524
R28977 n_34_2_9 n_35_2_9 62.27187609371413
R28978 n_34_2_9 n_34_3_9 1189.0315078967783
R28979 n_34_2_9 n_34_2_10 1.1979379616037524
R28980 n_34_2_10 n_35_2_10 62.27187609371413
R28981 n_34_2_10 n_34_3_10 1189.0315078967783
R28982 n_34_2_10 n_34_2_11 1.1979379616037447
R28983 n_34_2_11 n_35_2_11 62.27187609371492
R28984 n_34_2_11 n_34_3_11 1189.031507896793
R28985 n_34_2_11 n_34_2_12 1.197937961603741
R28986 n_34_2_12 n_35_2_12 62.271876093714546
R28987 n_34_2_12 n_34_3_12 1189.0315078967858
R28988 n_34_2_12 n_34_2_13 1.1979379616037524
R28989 n_34_2_13 n_35_2_13 62.271876093713736
R28990 n_34_2_13 n_34_3_13 1189.0315078967706
R28991 n_34_2_13 n_34_2_14 5.9896898080187775
R28992 n_34_2_14 n_35_2_14 6.9190973437459995
R28993 n_34_2_14 n_34_3_14 132.11461198853064
R28994 n_34_2_14 n_34_2_15 185.08141506778196
R28995 n_34_2_15 n_35_2_15 2288.4914464439667
R28996 n_34_2_15 n_34_3_15 43696.90791520607
R28997 n_34_3_0 n_35_3_0 32.69273494919985
R28998 n_34_3_0 n_34_4_0 326.273635936627
R28999 n_34_3_0 n_34_3_1 148.2448227484647
R29000 n_34_3_1 n_35_3_1 45.76982892887978
R29001 n_34_3_1 n_34_4_1 456.78309031127776
R29002 n_34_3_1 n_34_3_2 336.9200517010562
R29003 n_34_3_2 n_35_3_2 81.73183737299962
R29004 n_34_3_2 n_34_4_2 815.6840898415676
R29005 n_34_3_2 n_34_3_3 315.35716839218856
R29006 n_34_3_3 n_35_3_3 1144.2457232219936
R29007 n_34_3_3 n_34_4_3 11419.577257781933
R29008 n_34_3_3 n_34_3_4 4.192782865613147
R29009 n_34_3_4 n_35_3_4 34.674112824908896
R29010 n_34_3_4 n_34_4_4 346.0477956903616
R29011 n_34_3_4 n_34_3_5 3.4654633889251514
R29012 n_34_3_5 n_35_3_5 217.95156632799876
R29013 n_34_3_5 n_34_4_5 2175.157572910845
R29014 n_34_3_5 n_34_3_6 1.1979379616037562
R29015 n_34_3_6 n_35_3_6 36.32526105466647
R29016 n_34_3_6 n_34_4_6 362.5262621518074
R29017 n_34_3_6 n_34_3_7 1.6257729478908103
R29018 n_34_3_7 n_35_3_7 62.27187609371413
R29019 n_34_3_7 n_34_4_7 621.4735922602433
R29020 n_34_3_7 n_34_3_8 1.1979379616037524
R29021 n_34_3_8 n_35_3_8 62.27187609371413
R29022 n_34_3_8 n_34_4_8 621.4735922602433
R29023 n_34_3_8 n_34_3_9 1.1979379616037524
R29024 n_34_3_9 n_35_3_9 62.27187609371413
R29025 n_34_3_9 n_34_4_9 621.4735922602433
R29026 n_34_3_9 n_34_3_10 1.1979379616037524
R29027 n_34_3_10 n_35_3_10 62.27187609371413
R29028 n_34_3_10 n_34_4_10 621.4735922602433
R29029 n_34_3_10 n_34_3_11 1.1979379616037447
R29030 n_34_3_11 n_35_3_11 62.27187609371492
R29031 n_34_3_11 n_34_4_11 621.473592260251
R29032 n_34_3_11 n_34_3_12 1.197937961603741
R29033 n_34_3_12 n_35_3_12 62.271876093714546
R29034 n_34_3_12 n_34_4_12 621.4735922602473
R29035 n_34_3_12 n_34_3_13 1.1979379616037524
R29036 n_34_3_13 n_35_3_13 62.271876093713736
R29037 n_34_3_13 n_34_4_13 621.4735922602393
R29038 n_34_3_13 n_34_3_14 5.9896898080187775
R29039 n_34_3_14 n_35_3_14 6.9190973437459995
R29040 n_34_3_14 n_34_4_14 69.05262136224911
R29041 n_34_3_14 n_34_3_15 185.08141506778196
R29042 n_34_3_15 n_35_3_15 2288.4914464439667
R29043 n_34_3_15 n_34_4_15 22839.154515563667
R29044 n_34_4_0 n_35_4_0 720.990523873408
R29045 n_34_4_0 n_34_5_0 28.305730227447103
R29046 n_34_4_0 n_34_4_1 3269.3230646202646
R29047 n_34_4_1 n_35_4_1 1009.3867334227713
R29048 n_34_4_1 n_34_5_1 39.62802231842595
R29049 n_34_4_1 n_34_4_2 7430.279692318783
R29050 n_34_4_2 n_35_4_2 1802.4763096835204
R29051 n_34_4_2 n_34_5_2 70.76432556861776
R29052 n_34_4_2 n_34_4_3 6954.741792010382
R29053 n_34_4_3 n_35_4_3 25234.668335569266
R29054 n_34_4_3 n_34_5_3 990.7005579606478
R29055 n_34_4_3 n_34_4_4 92.46570283774494
R29056 n_34_4_4 n_35_4_4 764.6869192596746
R29057 n_34_4_4 n_34_5_4 30.021229029110536
R29058 n_34_4_4 n_34_4_5 76.42573397813614
R29059 n_34_4_5 n_35_4_5 4806.603492489383
R29060 n_34_4_5 n_34_5_5 188.70486818298053
R29061 n_34_4_5 n_34_4_6 26.4187722393557
R29062 n_34_4_6 n_35_4_6 801.1005820815639
R29063 n_34_4_6 n_34_5_6 31.450811363830084
R29064 n_34_4_6 n_34_4_7 35.85404803912555
R29065 n_34_4_7 n_35_4_7 1373.3152835683995
R29066 n_34_4_7 n_34_5_7 53.91567662370889
R29067 n_34_4_7 n_34_4_8 26.418772239355615
R29068 n_34_4_8 n_35_4_8 1373.3152835683995
R29069 n_34_4_8 n_34_5_8 53.91567662370889
R29070 n_34_4_8 n_34_4_9 26.418772239355615
R29071 n_34_4_9 n_35_4_9 1373.3152835683995
R29072 n_34_4_9 n_34_5_9 53.91567662370889
R29073 n_34_4_9 n_34_4_10 26.418772239355615
R29074 n_34_4_10 n_35_4_10 1373.3152835683995
R29075 n_34_4_10 n_34_5_10 53.91567662370889
R29076 n_34_4_10 n_34_4_11 26.418772239355448
R29077 n_34_4_11 n_35_4_11 1373.3152835684168
R29078 n_34_4_11 n_34_5_11 53.91567662370957
R29079 n_34_4_11 n_34_4_12 26.418772239355363
R29080 n_34_4_12 n_35_4_12 1373.3152835684082
R29081 n_34_4_12 n_34_5_12 53.91567662370923
R29082 n_34_4_12 n_34_4_13 26.41877223935561
R29083 n_34_4_13 n_35_4_13 1373.315283568391
R29084 n_34_4_13 n_34_5_13 53.91567662370854
R29085 n_34_4_13 n_34_4_14 132.09386119677842
R29086 n_34_4_14 n_35_4_14 152.59058706315517
R29087 n_34_4_14 n_34_5_14 5.990630735967642
R29088 n_34_4_14 n_34_4_15 4081.7003109804905
R29089 n_34_4_15 n_35_4_15 50469.33667113808
R29090 n_34_4_15 n_34_5_15 1981.4011159212778
R29091 n_34_5_0 n_35_5_0 720.9905238733954
R29092 n_34_5_0 n_34_6_0 28.305730227447356
R29093 n_34_5_0 n_34_5_1 3269.323064620207
R29094 n_34_5_1 n_35_5_1 1009.3867334227533
R29095 n_34_5_1 n_34_6_1 39.6280223184263
R29096 n_34_5_1 n_34_5_2 7430.2796923186515
R29097 n_34_5_2 n_35_5_2 1802.4763096834881
R29098 n_34_5_2 n_34_6_2 70.76432556861839
R29099 n_34_5_2 n_34_5_3 6954.741792010258
R29100 n_34_5_3 n_35_5_3 25234.668335568815
R29101 n_34_5_3 n_34_6_3 990.7005579606565
R29102 n_34_5_3 n_34_5_4 92.46570283774331
R29103 n_34_5_4 n_35_5_4 764.686919259661
R29104 n_34_5_4 n_34_6_4 30.021229029110803
R29105 n_34_5_4 n_34_5_5 76.42573397813477
R29106 n_34_5_5 n_35_5_5 4806.603492489298
R29107 n_34_5_5 n_34_6_5 188.70486818298218
R29108 n_34_5_5 n_34_5_6 26.418772239355235
R29109 n_34_5_6 n_35_5_6 801.1005820815496
R29110 n_34_5_6 n_34_6_6 31.45081136383036
R29111 n_34_5_6 n_34_5_7 35.85404803912492
R29112 n_34_5_7 n_35_5_7 1373.3152835683752
R29113 n_34_5_7 n_34_6_7 53.91567662370937
R29114 n_34_5_7 n_34_5_8 26.41877223935515
R29115 n_34_5_8 n_35_5_8 1373.3152835683752
R29116 n_34_5_8 n_34_6_8 53.91567662370937
R29117 n_34_5_8 n_34_5_9 26.41877223935515
R29118 n_34_5_9 n_35_5_9 1373.3152835683752
R29119 n_34_5_9 n_34_6_9 53.91567662370937
R29120 n_34_5_9 n_34_5_10 26.41877223935515
R29121 n_34_5_10 n_35_5_10 1373.3152835683752
R29122 n_34_5_10 n_34_6_10 53.91567662370937
R29123 n_34_5_10 n_34_5_11 26.41877223935498
R29124 n_34_5_11 n_35_5_11 1373.3152835683923
R29125 n_34_5_11 n_34_6_11 53.91567662371005
R29126 n_34_5_11 n_34_5_12 26.418772239354897
R29127 n_34_5_12 n_35_5_12 1373.3152835683836
R29128 n_34_5_12 n_34_6_12 53.915676623709714
R29129 n_34_5_12 n_34_5_13 26.41877223935515
R29130 n_34_5_13 n_35_5_13 1373.3152835683663
R29131 n_34_5_13 n_34_6_13 53.91567662370902
R29132 n_34_5_13 n_34_5_14 132.0938611967761
R29133 n_34_5_14 n_35_5_14 152.59058706315244
R29134 n_34_5_14 n_34_6_14 5.990630735967695
R29135 n_34_5_14 n_34_5_15 4081.700310980418
R29136 n_34_5_15 n_35_5_15 50469.33667113718
R29137 n_34_5_15 n_34_6_15 1981.4011159212955
R29138 n_34_6_0 n_35_6_0 720.9905238733954
R29139 n_34_6_0 n_34_7_0 28.305730227447103
R29140 n_34_6_0 n_34_6_1 3269.323064620207
R29141 n_34_6_1 n_35_6_1 1009.3867334227533
R29142 n_34_6_1 n_34_7_1 39.62802231842595
R29143 n_34_6_1 n_34_6_2 7430.2796923186515
R29144 n_34_6_2 n_35_6_2 1802.4763096834881
R29145 n_34_6_2 n_34_7_2 70.76432556861776
R29146 n_34_6_2 n_34_6_3 6954.741792010258
R29147 n_34_6_3 n_35_6_3 25234.668335568815
R29148 n_34_6_3 n_34_7_3 990.7005579606478
R29149 n_34_6_3 n_34_6_4 92.46570283774331
R29150 n_34_6_4 n_35_6_4 764.686919259661
R29151 n_34_6_4 n_34_7_4 30.021229029110536
R29152 n_34_6_4 n_34_6_5 76.42573397813477
R29153 n_34_6_5 n_35_6_5 4806.603492489298
R29154 n_34_6_5 n_34_7_5 188.70486818298053
R29155 n_34_6_5 n_34_6_6 26.418772239355235
R29156 n_34_6_6 n_35_6_6 801.1005820815496
R29157 n_34_6_6 n_34_7_6 31.450811363830084
R29158 n_34_6_6 n_34_6_7 35.85404803912492
R29159 n_34_6_7 n_35_6_7 1373.3152835683752
R29160 n_34_6_7 n_34_7_7 53.91567662370889
R29161 n_34_6_7 n_34_6_8 26.41877223935515
R29162 n_34_6_8 n_35_6_8 1373.3152835683752
R29163 n_34_6_8 n_34_7_8 53.91567662370889
R29164 n_34_6_8 n_34_6_9 26.41877223935515
R29165 n_34_6_9 n_35_6_9 1373.3152835683752
R29166 n_34_6_9 n_34_7_9 53.91567662370889
R29167 n_34_6_9 n_34_6_10 26.41877223935515
R29168 n_34_6_10 n_35_6_10 1373.3152835683752
R29169 n_34_6_10 n_34_7_10 53.91567662370889
R29170 n_34_6_10 n_34_6_11 26.41877223935498
R29171 n_34_6_11 n_35_6_11 1373.3152835683923
R29172 n_34_6_11 n_34_7_11 53.91567662370957
R29173 n_34_6_11 n_34_6_12 26.418772239354897
R29174 n_34_6_12 n_35_6_12 1373.3152835683836
R29175 n_34_6_12 n_34_7_12 53.91567662370923
R29176 n_34_6_12 n_34_6_13 26.41877223935515
R29177 n_34_6_13 n_35_6_13 1373.3152835683663
R29178 n_34_6_13 n_34_7_13 53.91567662370854
R29179 n_34_6_13 n_34_6_14 132.0938611967761
R29180 n_34_6_14 n_35_6_14 152.59058706315244
R29181 n_34_6_14 n_34_7_14 5.990630735967642
R29182 n_34_6_14 n_34_6_15 4081.700310980418
R29183 n_34_6_15 n_35_6_15 50469.33667113718
R29184 n_34_6_15 n_34_7_15 1981.4011159212778
R29185 n_34_7_0 n_35_7_0 720.990523873408
R29186 n_34_7_0 n_34_8_0 827.2137876682121
R29187 n_34_7_0 n_34_7_1 3269.3230646202646
R29188 n_34_7_1 n_35_7_1 1009.3867334227713
R29189 n_34_7_1 n_34_8_1 1158.099302735497
R29190 n_34_7_1 n_34_7_2 7430.279692318783
R29191 n_34_7_2 n_35_7_2 1802.4763096835204
R29192 n_34_7_2 n_34_8_2 2068.034469170531
R29193 n_34_7_2 n_34_7_3 6954.741792010382
R29194 n_34_7_3 n_35_7_3 25234.668335569266
R29195 n_34_7_3 n_34_8_3 28952.4825683874
R29196 n_34_7_3 n_34_7_4 92.46570283774494
R29197 n_34_7_4 n_35_7_4 764.6869192596746
R29198 n_34_7_4 n_34_8_4 877.3479566178
R29199 n_34_7_4 n_34_7_5 76.42573397813614
R29200 n_34_7_5 n_35_7_5 4806.603492489383
R29201 n_34_7_5 n_34_8_5 5514.758584454743
R29202 n_34_7_5 n_34_7_6 26.4187722393557
R29203 n_34_7_6 n_35_7_6 801.1005820815639
R29204 n_34_7_6 n_34_8_6 919.126430742457
R29205 n_34_7_6 n_34_7_7 35.85404803912555
R29206 n_34_7_7 n_35_7_7 1373.3152835683995
R29207 n_34_7_7 n_34_8_7 1575.6453098442173
R29208 n_34_7_7 n_34_7_8 26.418772239355615
R29209 n_34_7_8 n_35_7_8 1373.3152835683995
R29210 n_34_7_8 n_34_8_8 1575.6453098442173
R29211 n_34_7_8 n_34_7_9 26.418772239355615
R29212 n_34_7_9 n_35_7_9 1373.3152835683995
R29213 n_34_7_9 n_34_8_9 1575.6453098442173
R29214 n_34_7_9 n_34_7_10 26.418772239355615
R29215 n_34_7_10 n_35_7_10 1373.3152835683995
R29216 n_34_7_10 n_34_8_10 1575.6453098442173
R29217 n_34_7_10 n_34_7_11 26.418772239355448
R29218 n_34_7_11 n_35_7_11 1373.3152835684168
R29219 n_34_7_11 n_34_8_11 1575.645309844237
R29220 n_34_7_11 n_34_7_12 26.418772239355363
R29221 n_34_7_12 n_35_7_12 1373.3152835684082
R29222 n_34_7_12 n_34_8_12 1575.6453098442273
R29223 n_34_7_12 n_34_7_13 26.41877223935561
R29224 n_34_7_13 n_35_7_13 1373.315283568391
R29225 n_34_7_13 n_34_8_13 1575.6453098442068
R29226 n_34_7_13 n_34_7_14 132.09386119677842
R29227 n_34_7_14 n_35_7_14 152.59058706315517
R29228 n_34_7_14 n_34_8_14 175.07170109380155
R29229 n_34_7_14 n_34_7_15 4081.7003109804905
R29230 n_34_7_15 n_35_7_15 50469.33667113808
R29231 n_34_7_15 n_34_8_15 57904.965136774284
R29232 n_34_8_0 n_35_8_0 12.550205463809252
R29233 n_34_8_0 n_34_9_0 1626.121845108978
R29234 n_34_8_0 n_34_8_1 56.90875931090468
R29235 n_34_8_1 n_35_8_1 17.570287649332954
R29236 n_34_8_1 n_34_9_1 2276.5705831525693
R29237 n_34_8_1 n_34_8_2 129.33808934296516
R29238 n_34_8_2 n_35_8_2 31.37551365952313
R29239 n_34_8_2 n_34_9_2 4065.3046127724456
R29240 n_34_8_2 n_34_8_3 121.0604516250154
R29241 n_34_8_3 n_35_8_3 439.2571912333234
R29242 n_34_8_3 n_34_9_3 56914.26457881418
R29243 n_34_8_3 n_34_8_4 1.6095406673791235
R29244 n_34_8_4 n_35_8_4 13.310823976767377
R29245 n_34_8_4 n_34_9_4 1724.6746842064902
R29246 n_34_8_4 n_34_8_5 1.3303346332419284
R29247 n_34_8_5 n_35_8_5 83.66803642539494
R29248 n_34_8_5 n_34_9_5 10840.81230072651
R29249 n_34_8_5 n_34_8_6 0.45986876210832106
R29250 n_34_8_6 n_35_8_6 13.944672737565824
R29251 n_34_8_6 n_34_9_6 1806.802050121085
R29252 n_34_8_6 n_34_8_7 0.6241076057184349
R29253 n_34_8_7 n_35_8_7 23.905153264398628
R29254 n_34_8_7 n_34_9_7 3097.374943064727
R29255 n_34_8_7 n_34_8_8 0.4598687621083196
R29256 n_34_8_8 n_35_8_8 23.905153264398628
R29257 n_34_8_8 n_34_9_8 3097.374943064727
R29258 n_34_8_8 n_34_8_9 0.4598687621083196
R29259 n_34_8_9 n_35_8_9 23.905153264398628
R29260 n_34_8_9 n_34_9_9 3097.374943064727
R29261 n_34_8_9 n_34_8_10 0.4598687621083196
R29262 n_34_8_10 n_35_8_10 23.905153264398628
R29263 n_34_8_10 n_34_9_10 3097.374943064727
R29264 n_34_8_10 n_34_8_11 0.4598687621083167
R29265 n_34_8_11 n_35_8_11 23.905153264398933
R29266 n_34_8_11 n_34_9_11 3097.374943064766
R29267 n_34_8_11 n_34_8_12 0.4598687621083152
R29268 n_34_8_12 n_35_8_12 23.90515326439878
R29269 n_34_8_12 n_34_9_12 3097.3749430647467
R29270 n_34_8_12 n_34_8_13 0.4598687621083196
R29271 n_34_8_13 n_35_8_13 23.905153264398475
R29272 n_34_8_13 n_34_9_13 3097.3749430647067
R29273 n_34_8_13 n_34_8_14 2.299343810541604
R29274 n_34_8_14 n_35_8_14 2.6561281404887307
R29275 n_34_8_14 n_34_9_14 344.1527714516356
R29276 n_34_8_14 n_34_8_15 71.0497237457362
R29277 n_34_8_15 n_35_8_15 878.5143824666391
R29278 n_34_8_15 n_34_9_15 113828.52915762734
R29279 n_34_9_0 n_35_9_0 12.550205463809242
R29280 n_34_9_0 n_34_10_0 1626.121845108978
R29281 n_34_9_0 n_34_9_1 56.908759310904635
R29282 n_34_9_1 n_35_9_1 17.57028764933294
R29283 n_34_9_1 n_34_10_1 2276.5705831525693
R29284 n_34_9_1 n_34_9_2 129.33808934296508
R29285 n_34_9_2 n_35_9_2 31.375513659523108
R29286 n_34_9_2 n_34_10_2 4065.3046127724456
R29287 n_34_9_2 n_34_9_3 121.06045162501533
R29288 n_34_9_3 n_35_9_3 439.25719123332317
R29289 n_34_9_3 n_34_10_3 56914.26457881418
R29290 n_34_9_3 n_34_9_4 1.6095406673791224
R29291 n_34_9_4 n_35_9_4 13.310823976767367
R29292 n_34_9_4 n_34_10_4 1724.6746842064902
R29293 n_34_9_4 n_34_9_5 1.3303346332419277
R29294 n_34_9_5 n_35_9_5 83.66803642539489
R29295 n_34_9_5 n_34_10_5 10840.81230072651
R29296 n_34_9_5 n_34_9_6 0.4598687621083207
R29297 n_34_9_6 n_35_9_6 13.944672737565813
R29298 n_34_9_6 n_34_10_6 1806.802050121085
R29299 n_34_9_6 n_34_9_7 0.6241076057184345
R29300 n_34_9_7 n_35_9_7 23.905153264398614
R29301 n_34_9_7 n_34_10_7 3097.374943064727
R29302 n_34_9_7 n_34_9_8 0.4598687621083193
R29303 n_34_9_8 n_35_9_8 23.905153264398614
R29304 n_34_9_8 n_34_10_8 3097.374943064727
R29305 n_34_9_8 n_34_9_9 0.4598687621083193
R29306 n_34_9_9 n_35_9_9 23.905153264398614
R29307 n_34_9_9 n_34_10_9 3097.374943064727
R29308 n_34_9_9 n_34_9_10 0.4598687621083193
R29309 n_34_9_10 n_35_9_10 23.905153264398614
R29310 n_34_9_10 n_34_10_10 3097.374943064727
R29311 n_34_9_10 n_34_9_11 0.45986876210831634
R29312 n_34_9_11 n_35_9_11 23.905153264398916
R29313 n_34_9_11 n_34_10_11 3097.374943064766
R29314 n_34_9_11 n_34_9_12 0.45986876210831484
R29315 n_34_9_12 n_35_9_12 23.905153264398766
R29316 n_34_9_12 n_34_10_12 3097.3749430647467
R29317 n_34_9_12 n_34_9_13 0.4598687621083193
R29318 n_34_9_13 n_35_9_13 23.905153264398457
R29319 n_34_9_13 n_34_10_13 3097.3749430647067
R29320 n_34_9_13 n_34_9_14 2.299343810541602
R29321 n_34_9_14 n_35_9_14 2.656128140488729
R29322 n_34_9_14 n_34_10_14 344.1527714516356
R29323 n_34_9_14 n_34_9_15 71.04972374573616
R29324 n_34_9_15 n_35_9_15 878.5143824666385
R29325 n_34_9_15 n_34_10_15 113828.52915762734
R29326 n_34_10_0 n_35_10_0 12.550205463809252
R29327 n_34_10_0 n_34_11_0 1626.1218451089774
R29328 n_34_10_0 n_34_10_1 56.90875931090468
R29329 n_34_10_1 n_35_10_1 17.570287649332954
R29330 n_34_10_1 n_34_11_1 2276.5705831525684
R29331 n_34_10_1 n_34_10_2 129.33808934296516
R29332 n_34_10_2 n_35_10_2 31.37551365952313
R29333 n_34_10_2 n_34_11_2 4065.304612772444
R29334 n_34_10_2 n_34_10_3 121.0604516250154
R29335 n_34_10_3 n_35_10_3 439.2571912333234
R29336 n_34_10_3 n_34_11_3 56914.26457881416
R29337 n_34_10_3 n_34_10_4 1.6095406673791235
R29338 n_34_10_4 n_35_10_4 13.310823976767377
R29339 n_34_10_4 n_34_11_4 1724.6746842064897
R29340 n_34_10_4 n_34_10_5 1.3303346332419284
R29341 n_34_10_5 n_35_10_5 83.66803642539494
R29342 n_34_10_5 n_34_11_5 10840.812300726508
R29343 n_34_10_5 n_34_10_6 0.45986876210832106
R29344 n_34_10_6 n_35_10_6 13.944672737565824
R29345 n_34_10_6 n_34_11_6 1806.8020501210842
R29346 n_34_10_6 n_34_10_7 0.6241076057184349
R29347 n_34_10_7 n_35_10_7 23.905153264398628
R29348 n_34_10_7 n_34_11_7 3097.3749430647263
R29349 n_34_10_7 n_34_10_8 0.4598687621083196
R29350 n_34_10_8 n_35_10_8 23.905153264398628
R29351 n_34_10_8 n_34_11_8 3097.3749430647263
R29352 n_34_10_8 n_34_10_9 0.4598687621083196
R29353 n_34_10_9 n_35_10_9 23.905153264398628
R29354 n_34_10_9 n_34_11_9 3097.3749430647263
R29355 n_34_10_9 n_34_10_10 0.4598687621083196
R29356 n_34_10_10 n_35_10_10 23.905153264398628
R29357 n_34_10_10 n_34_11_10 3097.3749430647263
R29358 n_34_10_10 n_34_10_11 0.4598687621083167
R29359 n_34_10_11 n_35_10_11 23.905153264398933
R29360 n_34_10_11 n_34_11_11 3097.374943064765
R29361 n_34_10_11 n_34_10_12 0.4598687621083152
R29362 n_34_10_12 n_35_10_12 23.90515326439878
R29363 n_34_10_12 n_34_11_12 3097.374943064746
R29364 n_34_10_12 n_34_10_13 0.4598687621083196
R29365 n_34_10_13 n_35_10_13 23.905153264398475
R29366 n_34_10_13 n_34_11_13 3097.374943064706
R29367 n_34_10_13 n_34_10_14 2.299343810541604
R29368 n_34_10_14 n_35_10_14 2.6561281404887307
R29369 n_34_10_14 n_34_11_14 344.1527714516355
R29370 n_34_10_14 n_34_10_15 71.0497237457362
R29371 n_34_10_15 n_35_10_15 878.5143824666391
R29372 n_34_10_15 n_34_11_15 113828.52915762732
R29373 n_34_11_0 n_35_11_0 12.550205463809252
R29374 n_34_11_0 n_34_12_0 827.2138119611571
R29375 n_34_11_0 n_34_11_1 56.90875931090468
R29376 n_34_11_1 n_35_11_1 17.570287649332954
R29377 n_34_11_1 n_34_12_1 1158.0993367456201
R29378 n_34_11_1 n_34_11_2 129.33808934296516
R29379 n_34_11_2 n_35_11_2 31.37551365952313
R29380 n_34_11_2 n_34_12_2 2068.034529902893
R29381 n_34_11_2 n_34_11_3 121.0604516250154
R29382 n_34_11_3 n_35_11_3 439.2571912333234
R29383 n_34_11_3 n_34_12_3 28952.483418640477
R29384 n_34_11_3 n_34_11_4 1.6095406673791235
R29385 n_34_11_4 n_35_11_4 13.310823976767377
R29386 n_34_11_4 n_34_12_4 877.3479823830447
R29387 n_34_11_4 n_34_11_5 1.3303346332419284
R29388 n_34_11_5 n_35_11_5 83.66803642539494
R29389 n_34_11_5 n_34_12_5 5514.7587464077105
R29390 n_34_11_5 n_34_11_6 0.45986876210832106
R29391 n_34_11_6 n_35_11_6 13.944672737565824
R29392 n_34_11_6 n_34_12_6 919.1264577346182
R29393 n_34_11_6 n_34_11_7 0.6241076057184349
R29394 n_34_11_7 n_35_11_7 23.905153264398628
R29395 n_34_11_7 n_34_12_7 1575.6453561164935
R29396 n_34_11_7 n_34_11_8 0.4598687621083196
R29397 n_34_11_8 n_35_11_8 23.905153264398628
R29398 n_34_11_8 n_34_12_8 1575.6453561164935
R29399 n_34_11_8 n_34_11_9 0.4598687621083196
R29400 n_34_11_9 n_35_11_9 23.905153264398628
R29401 n_34_11_9 n_34_12_9 1575.6453561164935
R29402 n_34_11_9 n_34_11_10 0.4598687621083196
R29403 n_34_11_10 n_35_11_10 23.905153264398628
R29404 n_34_11_10 n_34_12_10 1575.6453561164935
R29405 n_34_11_10 n_34_11_11 0.4598687621083167
R29406 n_34_11_11 n_35_11_11 23.905153264398933
R29407 n_34_11_11 n_34_12_11 1575.6453561165133
R29408 n_34_11_11 n_34_11_12 0.4598687621083152
R29409 n_34_11_12 n_35_11_12 23.90515326439878
R29410 n_34_11_12 n_34_12_12 1575.6453561165035
R29411 n_34_11_12 n_34_11_13 0.4598687621083196
R29412 n_34_11_13 n_35_11_13 23.905153264398475
R29413 n_34_11_13 n_34_12_13 1575.6453561164833
R29414 n_34_11_13 n_34_11_14 2.299343810541604
R29415 n_34_11_14 n_35_11_14 2.6561281404887307
R29416 n_34_11_14 n_34_12_14 175.07170623516558
R29417 n_34_11_14 n_34_11_15 71.0497237457362
R29418 n_34_11_15 n_35_11_15 878.5143824666391
R29419 n_34_11_15 n_34_12_15 57904.966837280444
R29420 n_34_12_0 n_35_12_0 720.9892863181162
R29421 n_34_12_0 n_34_13_0 28.305778813336957
R29422 n_34_12_0 n_34_12_1 3269.3174529403245
R29423 n_34_12_1 n_35_12_1 1009.3850008453628
R29424 n_34_12_1 n_34_13_1 39.62809033867174
R29425 n_34_12_1 n_34_12_2 7430.266938500739
R29426 n_34_12_2 n_35_12_2 1802.4732157952908
R29427 n_34_12_2 n_34_13_2 70.7644470333424
R29428 n_34_12_2 n_34_12_3 6954.729854436692
R29429 n_34_12_3 n_35_12_3 25234.625021134045
R29430 n_34_12_3 n_34_13_3 990.7022584667927
R29431 n_34_12_3 n_34_12_4 92.46554412356485
R29432 n_34_12_4 n_35_12_4 764.6856067010318
R29433 n_34_12_4 n_34_13_4 30.021280559599777
R29434 n_34_12_4 n_34_12_5 76.42560279600768
R29435 n_34_12_5 n_35_12_5 4806.59524212077
R29436 n_34_12_5 n_34_13_5 188.7051920889129
R29437 n_34_12_5 n_34_12_6 26.418726892447097
R29438 n_34_12_6 n_35_12_6 801.0992070201285
R29439 n_34_12_6 n_34_13_6 31.450865348152142
R29440 n_34_12_6 n_34_12_7 35.853986496892446
R29441 n_34_12_7 n_35_12_7 1373.3129263202245
R29442 n_34_12_7 n_34_13_7 53.915769168261
R29443 n_34_12_7 n_34_12_8 26.418726892447015
R29444 n_34_12_8 n_35_12_8 1373.3129263202245
R29445 n_34_12_8 n_34_13_8 53.915769168261
R29446 n_34_12_8 n_34_12_9 26.418726892447015
R29447 n_34_12_9 n_35_12_9 1373.3129263202245
R29448 n_34_12_9 n_34_13_9 53.915769168261
R29449 n_34_12_9 n_34_12_10 26.418726892447015
R29450 n_34_12_10 n_35_12_10 1373.3129263202245
R29451 n_34_12_10 n_34_13_10 53.915769168261
R29452 n_34_12_10 n_34_12_11 26.41872689244685
R29453 n_34_12_11 n_35_12_11 1373.312926320242
R29454 n_34_12_11 n_34_13_11 53.915769168261676
R29455 n_34_12_11 n_34_12_12 26.418726892446763
R29456 n_34_12_12 n_35_12_12 1373.3129263202331
R29457 n_34_12_12 n_34_13_12 53.91576916826134
R29458 n_34_12_12 n_34_12_13 26.418726892447012
R29459 n_34_12_13 n_35_12_13 1373.3129263202159
R29460 n_34_12_13 n_34_13_13 53.915769168260645
R29461 n_34_12_13 n_34_12_14 132.0936344622354
R29462 n_34_12_14 n_35_12_14 152.59032514669127
R29463 n_34_12_14 n_34_13_14 5.990641018695654
R29464 n_34_12_14 n_34_12_15 4081.693304883112
R29465 n_34_12_15 n_35_12_15 50469.25004226765
R29466 n_34_12_15 n_34_13_15 1981.4045169335677
R29467 n_34_13_0 n_35_13_0 720.9892863181162
R29468 n_34_13_0 n_34_14_0 28.305778813336957
R29469 n_34_13_0 n_34_13_1 3269.3174529403245
R29470 n_34_13_1 n_35_13_1 1009.3850008453628
R29471 n_34_13_1 n_34_14_1 39.62809033867174
R29472 n_34_13_1 n_34_13_2 7430.266938500739
R29473 n_34_13_2 n_35_13_2 1802.4732157952908
R29474 n_34_13_2 n_34_14_2 70.7644470333424
R29475 n_34_13_2 n_34_13_3 6954.729854436692
R29476 n_34_13_3 n_35_13_3 25234.625021134045
R29477 n_34_13_3 n_34_14_3 990.7022584667927
R29478 n_34_13_3 n_34_13_4 92.46554412356485
R29479 n_34_13_4 n_35_13_4 764.6856067010318
R29480 n_34_13_4 n_34_14_4 30.021280559599777
R29481 n_34_13_4 n_34_13_5 76.42560279600768
R29482 n_34_13_5 n_35_13_5 4806.59524212077
R29483 n_34_13_5 n_34_14_5 188.7051920889129
R29484 n_34_13_5 n_34_13_6 26.418726892447097
R29485 n_34_13_6 n_35_13_6 801.0992070201285
R29486 n_34_13_6 n_34_14_6 31.450865348152142
R29487 n_34_13_6 n_34_13_7 35.853986496892446
R29488 n_34_13_7 n_35_13_7 1373.3129263202245
R29489 n_34_13_7 n_34_14_7 53.915769168261
R29490 n_34_13_7 n_34_13_8 26.418726892447015
R29491 n_34_13_8 n_35_13_8 1373.3129263202245
R29492 n_34_13_8 n_34_14_8 53.915769168261
R29493 n_34_13_8 n_34_13_9 26.418726892447015
R29494 n_34_13_9 n_35_13_9 1373.3129263202245
R29495 n_34_13_9 n_34_14_9 53.915769168261
R29496 n_34_13_9 n_34_13_10 26.418726892447015
R29497 n_34_13_10 n_35_13_10 1373.3129263202245
R29498 n_34_13_10 n_34_14_10 53.915769168261
R29499 n_34_13_10 n_34_13_11 26.41872689244685
R29500 n_34_13_11 n_35_13_11 1373.312926320242
R29501 n_34_13_11 n_34_14_11 53.915769168261676
R29502 n_34_13_11 n_34_13_12 26.418726892446763
R29503 n_34_13_12 n_35_13_12 1373.3129263202331
R29504 n_34_13_12 n_34_14_12 53.91576916826134
R29505 n_34_13_12 n_34_13_13 26.418726892447012
R29506 n_34_13_13 n_35_13_13 1373.3129263202159
R29507 n_34_13_13 n_34_14_13 53.915769168260645
R29508 n_34_13_13 n_34_13_14 132.0936344622354
R29509 n_34_13_14 n_35_13_14 152.59032514669127
R29510 n_34_13_14 n_34_14_14 5.990641018695654
R29511 n_34_13_14 n_34_13_15 4081.693304883112
R29512 n_34_13_15 n_35_13_15 50469.25004226765
R29513 n_34_13_15 n_34_14_15 1981.4045169335677
R29514 n_34_14_0 n_35_14_0 720.9892863181162
R29515 n_34_14_0 n_34_15_0 28.305778813336957
R29516 n_34_14_0 n_34_14_1 3269.3174529403245
R29517 n_34_14_1 n_35_14_1 1009.3850008453628
R29518 n_34_14_1 n_34_15_1 39.62809033867174
R29519 n_34_14_1 n_34_14_2 7430.266938500739
R29520 n_34_14_2 n_35_14_2 1802.4732157952908
R29521 n_34_14_2 n_34_15_2 70.7644470333424
R29522 n_34_14_2 n_34_14_3 6954.729854436692
R29523 n_34_14_3 n_35_14_3 25234.625021134045
R29524 n_34_14_3 n_34_15_3 990.7022584667927
R29525 n_34_14_3 n_34_14_4 92.46554412356485
R29526 n_34_14_4 n_35_14_4 764.6856067010318
R29527 n_34_14_4 n_34_15_4 30.021280559599777
R29528 n_34_14_4 n_34_14_5 76.42560279600768
R29529 n_34_14_5 n_35_14_5 4806.59524212077
R29530 n_34_14_5 n_34_15_5 188.7051920889129
R29531 n_34_14_5 n_34_14_6 26.418726892447097
R29532 n_34_14_6 n_35_14_6 801.0992070201285
R29533 n_34_14_6 n_34_15_6 31.450865348152142
R29534 n_34_14_6 n_34_14_7 35.853986496892446
R29535 n_34_14_7 n_35_14_7 1373.3129263202245
R29536 n_34_14_7 n_34_15_7 53.915769168261
R29537 n_34_14_7 n_34_14_8 26.418726892447015
R29538 n_34_14_8 n_35_14_8 1373.3129263202245
R29539 n_34_14_8 n_34_15_8 53.915769168261
R29540 n_34_14_8 n_34_14_9 26.418726892447015
R29541 n_34_14_9 n_35_14_9 1373.3129263202245
R29542 n_34_14_9 n_34_15_9 53.915769168261
R29543 n_34_14_9 n_34_14_10 26.418726892447015
R29544 n_34_14_10 n_35_14_10 1373.3129263202245
R29545 n_34_14_10 n_34_15_10 53.915769168261
R29546 n_34_14_10 n_34_14_11 26.41872689244685
R29547 n_34_14_11 n_35_14_11 1373.312926320242
R29548 n_34_14_11 n_34_15_11 53.915769168261676
R29549 n_34_14_11 n_34_14_12 26.418726892446763
R29550 n_34_14_12 n_35_14_12 1373.3129263202331
R29551 n_34_14_12 n_34_15_12 53.91576916826134
R29552 n_34_14_12 n_34_14_13 26.418726892447012
R29553 n_34_14_13 n_35_14_13 1373.3129263202159
R29554 n_34_14_13 n_34_15_13 53.915769168260645
R29555 n_34_14_13 n_34_14_14 132.0936344622354
R29556 n_34_14_14 n_35_14_14 152.59032514669127
R29557 n_34_14_14 n_34_15_14 5.990641018695654
R29558 n_34_14_14 n_34_14_15 4081.693304883112
R29559 n_34_14_15 n_35_14_15 50469.25004226765
R29560 n_34_14_15 n_34_15_15 1981.4045169335677
R29561 n_34_15_0 n_35_15_0 720.9892863181162
R29562 n_34_15_0 n_34_16_0 827.2138119611567
R29563 n_34_15_0 n_34_15_1 3269.3174529403245
R29564 n_34_15_1 n_35_15_1 1009.3850008453628
R29565 n_34_15_1 n_34_16_1 1158.0993367456194
R29566 n_34_15_1 n_34_15_2 7430.266938500739
R29567 n_34_15_2 n_35_15_2 1802.4732157952908
R29568 n_34_15_2 n_34_16_2 2068.0345299028922
R29569 n_34_15_2 n_34_15_3 6954.729854436692
R29570 n_34_15_3 n_35_15_3 25234.625021134045
R29571 n_34_15_3 n_34_16_3 28952.483418640462
R29572 n_34_15_3 n_34_15_4 92.46554412356485
R29573 n_34_15_4 n_35_15_4 764.6856067010318
R29574 n_34_15_4 n_34_16_4 877.3479823830442
R29575 n_34_15_4 n_34_15_5 76.42560279600768
R29576 n_34_15_5 n_35_15_5 4806.59524212077
R29577 n_34_15_5 n_34_16_5 5514.758746407707
R29578 n_34_15_5 n_34_15_6 26.418726892447097
R29579 n_34_15_6 n_35_15_6 801.0992070201285
R29580 n_34_15_6 n_34_16_6 919.1264577346176
R29581 n_34_15_6 n_34_15_7 35.853986496892446
R29582 n_34_15_7 n_35_15_7 1373.3129263202245
R29583 n_34_15_7 n_34_16_7 1575.6453561164926
R29584 n_34_15_7 n_34_15_8 26.418726892447015
R29585 n_34_15_8 n_35_15_8 1373.3129263202245
R29586 n_34_15_8 n_34_16_8 1575.6453561164926
R29587 n_34_15_8 n_34_15_9 26.418726892447015
R29588 n_34_15_9 n_35_15_9 1373.3129263202245
R29589 n_34_15_9 n_34_16_9 1575.6453561164926
R29590 n_34_15_9 n_34_15_10 26.418726892447015
R29591 n_34_15_10 n_35_15_10 1373.3129263202245
R29592 n_34_15_10 n_34_16_10 1575.6453561164926
R29593 n_34_15_10 n_34_15_11 26.41872689244685
R29594 n_34_15_11 n_35_15_11 1373.312926320242
R29595 n_34_15_11 n_34_16_11 1575.6453561165124
R29596 n_34_15_11 n_34_15_12 26.418726892446763
R29597 n_34_15_12 n_35_15_12 1373.3129263202331
R29598 n_34_15_12 n_34_16_12 1575.6453561165026
R29599 n_34_15_12 n_34_15_13 26.418726892447012
R29600 n_34_15_13 n_35_15_13 1373.3129263202159
R29601 n_34_15_13 n_34_16_13 1575.6453561164824
R29602 n_34_15_13 n_34_15_14 132.0936344622354
R29603 n_34_15_14 n_35_15_14 152.59032514669127
R29604 n_34_15_14 n_34_16_14 175.0717062351655
R29605 n_34_15_14 n_34_15_15 4081.693304883112
R29606 n_34_15_15 n_35_15_15 50469.25004226765
R29607 n_34_15_15 n_34_16_15 57904.96683728041
R29608 n_34_16_0 n_35_16_0 12.550205463809261
R29609 n_34_16_0 n_34_17_0 1626.1218451089776
R29610 n_34_16_0 n_34_16_1 56.9087593109047
R29611 n_34_16_1 n_35_16_1 17.57028764933296
R29612 n_34_16_1 n_34_17_1 2276.5705831525684
R29613 n_34_16_1 n_34_16_2 129.33808934296525
R29614 n_34_16_2 n_35_16_2 31.375513659523147
R29615 n_34_16_2 n_34_17_2 4065.304612772444
R29616 n_34_16_2 n_34_16_3 121.06045162501547
R29617 n_34_16_3 n_35_16_3 439.2571912333236
R29618 n_34_16_3 n_34_17_3 56914.26457881417
R29619 n_34_16_3 n_34_16_4 1.6095406673791246
R29620 n_34_16_4 n_35_16_4 13.31082397676738
R29621 n_34_16_4 n_34_17_4 1724.6746842064895
R29622 n_34_16_4 n_34_16_5 1.3303346332419297
R29623 n_34_16_5 n_35_16_5 83.66803642539499
R29624 n_34_16_5 n_34_17_5 10840.812300726506
R29625 n_34_16_5 n_34_16_6 0.4598687621083213
R29626 n_34_16_6 n_35_16_6 13.944672737565831
R29627 n_34_16_6 n_34_17_6 1806.8020501210842
R29628 n_34_16_6 n_34_16_7 0.6241076057184354
R29629 n_34_16_7 n_35_16_7 23.90515326439864
R29630 n_34_16_7 n_34_17_7 3097.3749430647263
R29631 n_34_16_7 n_34_16_8 0.45986876210831984
R29632 n_34_16_8 n_35_16_8 23.90515326439864
R29633 n_34_16_8 n_34_17_8 3097.3749430647263
R29634 n_34_16_8 n_34_16_9 0.45986876210831984
R29635 n_34_16_9 n_35_16_9 23.90515326439864
R29636 n_34_16_9 n_34_17_9 3097.3749430647263
R29637 n_34_16_9 n_34_16_10 0.45986876210831984
R29638 n_34_16_10 n_35_16_10 23.90515326439864
R29639 n_34_16_10 n_34_17_10 3097.3749430647263
R29640 n_34_16_10 n_34_16_11 0.4598687621083169
R29641 n_34_16_11 n_35_16_11 23.905153264398947
R29642 n_34_16_11 n_34_17_11 3097.374943064765
R29643 n_34_16_11 n_34_16_12 0.4598687621083154
R29644 n_34_16_12 n_35_16_12 23.90515326439879
R29645 n_34_16_12 n_34_17_12 3097.374943064746
R29646 n_34_16_12 n_34_16_13 0.45986876210831984
R29647 n_34_16_13 n_35_16_13 23.90515326439849
R29648 n_34_16_13 n_34_17_13 3097.374943064706
R29649 n_34_16_13 n_34_16_14 2.299343810541605
R29650 n_34_16_14 n_35_16_14 2.6561281404887325
R29651 n_34_16_14 n_34_17_14 344.15277145163554
R29652 n_34_16_14 n_34_16_15 71.04972374573626
R29653 n_34_16_15 n_35_16_15 878.5143824666395
R29654 n_34_16_15 n_34_17_15 113828.52915762732
R29655 n_34_17_0 n_35_17_0 12.550205463809242
R29656 n_34_17_0 n_34_18_0 1626.1218451089785
R29657 n_34_17_0 n_34_17_1 56.908759310904635
R29658 n_34_17_1 n_35_17_1 17.57028764933294
R29659 n_34_17_1 n_34_18_1 2276.5705831525697
R29660 n_34_17_1 n_34_17_2 129.33808934296508
R29661 n_34_17_2 n_35_17_2 31.375513659523108
R29662 n_34_17_2 n_34_18_2 4065.3046127724465
R29663 n_34_17_2 n_34_17_3 121.06045162501533
R29664 n_34_17_3 n_35_17_3 439.25719123332317
R29665 n_34_17_3 n_34_18_3 56914.264578814196
R29666 n_34_17_3 n_34_17_4 1.6095406673791224
R29667 n_34_17_4 n_35_17_4 13.310823976767367
R29668 n_34_17_4 n_34_18_4 1724.6746842064906
R29669 n_34_17_4 n_34_17_5 1.3303346332419277
R29670 n_34_17_5 n_35_17_5 83.66803642539489
R29671 n_34_17_5 n_34_18_5 10840.812300726513
R29672 n_34_17_5 n_34_17_6 0.4598687621083207
R29673 n_34_17_6 n_35_17_6 13.944672737565813
R29674 n_34_17_6 n_34_18_6 1806.8020501210854
R29675 n_34_17_6 n_34_17_7 0.6241076057184345
R29676 n_34_17_7 n_35_17_7 23.905153264398614
R29677 n_34_17_7 n_34_18_7 3097.374943064728
R29678 n_34_17_7 n_34_17_8 0.4598687621083193
R29679 n_34_17_8 n_35_17_8 23.905153264398614
R29680 n_34_17_8 n_34_18_8 3097.374943064728
R29681 n_34_17_8 n_34_17_9 0.4598687621083193
R29682 n_34_17_9 n_35_17_9 23.905153264398614
R29683 n_34_17_9 n_34_18_9 3097.374943064728
R29684 n_34_17_9 n_34_17_10 0.4598687621083193
R29685 n_34_17_10 n_35_17_10 23.905153264398614
R29686 n_34_17_10 n_34_18_10 3097.374943064728
R29687 n_34_17_10 n_34_17_11 0.45986876210831634
R29688 n_34_17_11 n_35_17_11 23.905153264398916
R29689 n_34_17_11 n_34_18_11 3097.3749430647667
R29690 n_34_17_11 n_34_17_12 0.45986876210831484
R29691 n_34_17_12 n_35_17_12 23.905153264398766
R29692 n_34_17_12 n_34_18_12 3097.3749430647476
R29693 n_34_17_12 n_34_17_13 0.4598687621083193
R29694 n_34_17_13 n_35_17_13 23.905153264398457
R29695 n_34_17_13 n_34_18_13 3097.374943064708
R29696 n_34_17_13 n_34_17_14 2.299343810541602
R29697 n_34_17_14 n_35_17_14 2.656128140488729
R29698 n_34_17_14 n_34_18_14 344.1527714516357
R29699 n_34_17_14 n_34_17_15 71.04972374573616
R29700 n_34_17_15 n_35_17_15 878.5143824666385
R29701 n_34_17_15 n_34_18_15 113828.52915762737
R29702 n_34_18_0 n_35_18_0 12.550205463809242
R29703 n_34_18_0 n_34_19_0 1626.1218451089776
R29704 n_34_18_0 n_34_18_1 56.908759310904635
R29705 n_34_18_1 n_35_18_1 17.57028764933294
R29706 n_34_18_1 n_34_19_1 2276.5705831525684
R29707 n_34_18_1 n_34_18_2 129.33808934296508
R29708 n_34_18_2 n_35_18_2 31.375513659523108
R29709 n_34_18_2 n_34_19_2 4065.304612772444
R29710 n_34_18_2 n_34_18_3 121.06045162501533
R29711 n_34_18_3 n_35_18_3 439.25719123332317
R29712 n_34_18_3 n_34_19_3 56914.26457881417
R29713 n_34_18_3 n_34_18_4 1.6095406673791224
R29714 n_34_18_4 n_35_18_4 13.310823976767367
R29715 n_34_18_4 n_34_19_4 1724.6746842064895
R29716 n_34_18_4 n_34_18_5 1.3303346332419277
R29717 n_34_18_5 n_35_18_5 83.66803642539489
R29718 n_34_18_5 n_34_19_5 10840.812300726506
R29719 n_34_18_5 n_34_18_6 0.4598687621083207
R29720 n_34_18_6 n_35_18_6 13.944672737565813
R29721 n_34_18_6 n_34_19_6 1806.8020501210842
R29722 n_34_18_6 n_34_18_7 0.6241076057184345
R29723 n_34_18_7 n_35_18_7 23.905153264398614
R29724 n_34_18_7 n_34_19_7 3097.3749430647263
R29725 n_34_18_7 n_34_18_8 0.4598687621083193
R29726 n_34_18_8 n_35_18_8 23.905153264398614
R29727 n_34_18_8 n_34_19_8 3097.3749430647263
R29728 n_34_18_8 n_34_18_9 0.4598687621083193
R29729 n_34_18_9 n_35_18_9 23.905153264398614
R29730 n_34_18_9 n_34_19_9 3097.3749430647263
R29731 n_34_18_9 n_34_18_10 0.4598687621083193
R29732 n_34_18_10 n_35_18_10 23.905153264398614
R29733 n_34_18_10 n_34_19_10 3097.3749430647263
R29734 n_34_18_10 n_34_18_11 0.45986876210831634
R29735 n_34_18_11 n_35_18_11 23.905153264398916
R29736 n_34_18_11 n_34_19_11 3097.374943064765
R29737 n_34_18_11 n_34_18_12 0.45986876210831484
R29738 n_34_18_12 n_35_18_12 23.905153264398766
R29739 n_34_18_12 n_34_19_12 3097.374943064746
R29740 n_34_18_12 n_34_18_13 0.4598687621083193
R29741 n_34_18_13 n_35_18_13 23.905153264398457
R29742 n_34_18_13 n_34_19_13 3097.374943064706
R29743 n_34_18_13 n_34_18_14 2.299343810541602
R29744 n_34_18_14 n_35_18_14 2.656128140488729
R29745 n_34_18_14 n_34_19_14 344.15277145163554
R29746 n_34_18_14 n_34_18_15 71.04972374573616
R29747 n_34_18_15 n_35_18_15 878.5143824666385
R29748 n_34_18_15 n_34_19_15 113828.52915762732
R29749 n_34_19_0 n_35_19_0 12.550205463809261
R29750 n_34_19_0 n_34_20_0 827.2138145480029
R29751 n_34_19_0 n_34_19_1 56.9087593109047
R29752 n_34_19_1 n_35_19_1 17.57028764933296
R29753 n_34_19_1 n_34_20_1 1158.0993403672041
R29754 n_34_19_1 n_34_19_2 129.33808934296525
R29755 n_34_19_2 n_35_19_2 31.375513659523147
R29756 n_34_19_2 n_34_20_2 2068.0345363700076
R29757 n_34_19_2 n_34_19_3 121.06045162501547
R29758 n_34_19_3 n_35_19_3 439.2571912333236
R29759 n_34_19_3 n_34_20_3 28952.483509180078
R29760 n_34_19_3 n_34_19_4 1.6095406673791246
R29761 n_34_19_4 n_35_19_4 13.31082397676738
R29762 n_34_19_4 n_34_20_4 877.347985126669
R29763 n_34_19_4 n_34_19_5 1.3303346332419297
R29764 n_34_19_5 n_35_19_5 83.66803642539499
R29765 n_34_19_5 n_34_20_5 5514.758763653348
R29766 n_34_19_5 n_34_19_6 0.4598687621083213
R29767 n_34_19_6 n_35_19_6 13.944672737565831
R29768 n_34_19_6 n_34_20_6 919.1264606088912
R29769 n_34_19_6 n_34_19_7 0.6241076057184354
R29770 n_34_19_7 n_35_19_7 23.90515326439864
R29771 n_34_19_7 n_34_20_7 1575.6453610438189
R29772 n_34_19_7 n_34_19_8 0.45986876210831984
R29773 n_34_19_8 n_35_19_8 23.90515326439864
R29774 n_34_19_8 n_34_20_8 1575.6453610438189
R29775 n_34_19_8 n_34_19_9 0.45986876210831984
R29776 n_34_19_9 n_35_19_9 23.90515326439864
R29777 n_34_19_9 n_34_20_9 1575.6453610438189
R29778 n_34_19_9 n_34_19_10 0.45986876210831984
R29779 n_34_19_10 n_35_19_10 23.90515326439864
R29780 n_34_19_10 n_34_20_10 1575.6453610438189
R29781 n_34_19_10 n_34_19_11 0.4598687621083169
R29782 n_34_19_11 n_35_19_11 23.905153264398947
R29783 n_34_19_11 n_34_20_11 1575.6453610438384
R29784 n_34_19_11 n_34_19_12 0.4598687621083154
R29785 n_34_19_12 n_35_19_12 23.90515326439879
R29786 n_34_19_12 n_34_20_12 1575.6453610438289
R29787 n_34_19_12 n_34_19_13 0.45986876210831984
R29788 n_34_19_13 n_35_19_13 23.90515326439849
R29789 n_34_19_13 n_34_20_13 1575.6453610438084
R29790 n_34_19_13 n_34_19_14 2.299343810541605
R29791 n_34_19_14 n_35_19_14 2.6561281404887325
R29792 n_34_19_14 n_34_20_14 175.07170678264617
R29793 n_34_19_14 n_34_19_15 71.04972374573626
R29794 n_34_19_15 n_35_19_15 878.5143824666395
R29795 n_34_19_15 n_34_20_15 57904.96701835964
R29796 n_34_20_0 n_35_20_0 720.9891545366825
R29797 n_34_20_0 n_34_21_0 28.305783987029372
R29798 n_34_20_0 n_34_20_1 3269.3168553789606
R29799 n_34_20_1 n_35_20_1 1009.3848163513552
R29800 n_34_20_1 n_34_21_1 39.62809758184112
R29801 n_34_20_1 n_34_20_2 7430.265580406729
R29802 n_34_20_2 n_35_20_2 1802.4728863417063
R29803 n_34_20_2 n_34_21_2 70.76445996757343
R29804 n_34_20_2 n_34_20_3 6954.7285832606985
R29805 n_34_20_3 n_35_20_3 25234.620408783856
R29806 n_34_20_3 n_34_21_3 990.7024395460271
R29807 n_34_20_3 n_34_20_4 92.46552722283937
R29808 n_34_20_4 n_35_20_4 764.6854669328443
R29809 n_34_20_4 n_34_21_4 30.021286046849305
R29810 n_34_20_4 n_34_20_5 76.42558882704071
R29811 n_34_20_5 n_35_20_5 4806.594363577878
R29812 n_34_20_5 n_34_21_5 188.70522658019564
R29813 n_34_20_5 n_34_20_6 26.418722063668394
R29814 n_34_20_6 n_35_20_6 801.099060596313
R29815 n_34_20_6 n_34_21_6 31.45087109669927
R29816 n_34_20_6 n_34_20_7 35.85397994354992
R29817 n_34_20_7 n_35_20_7 1373.3126753079694
R29818 n_34_20_7 n_34_21_7 53.91577902291321
R29819 n_34_20_7 n_34_20_8 26.418722063668312
R29820 n_34_20_8 n_35_20_8 1373.3126753079694
R29821 n_34_20_8 n_34_21_8 53.91577902291321
R29822 n_34_20_8 n_34_20_9 26.418722063668312
R29823 n_34_20_9 n_35_20_9 1373.3126753079694
R29824 n_34_20_9 n_34_21_9 53.91577902291321
R29825 n_34_20_9 n_34_20_10 26.418722063668312
R29826 n_34_20_10 n_35_20_10 1373.3126753079694
R29827 n_34_20_10 n_34_21_10 53.91577902291321
R29828 n_34_20_10 n_34_20_11 26.41872206366814
R29829 n_34_20_11 n_35_20_11 1373.312675307987
R29830 n_34_20_11 n_34_21_11 53.91577902291389
R29831 n_34_20_11 n_34_20_12 26.418722063668056
R29832 n_34_20_12 n_35_20_12 1373.312675307978
R29833 n_34_20_12 n_34_21_12 53.915779022913554
R29834 n_34_20_12 n_34_20_13 26.418722063668312
R29835 n_34_20_13 n_35_20_13 1373.3126753079605
R29836 n_34_20_13 n_34_21_13 53.91577902291286
R29837 n_34_20_13 n_34_20_14 132.0936103183419
R29838 n_34_20_14 n_35_20_14 152.59029725644075
R29839 n_34_20_14 n_34_21_14 5.990642113657011
R29840 n_34_20_14 n_34_20_15 4081.692558836802
R29841 n_34_20_15 n_35_20_15 50469.24081756726
R29842 n_34_20_15 n_34_21_15 1981.4048790920365
R29843 n_34_21_0 n_35_21_0 720.9891545366825
R29844 n_34_21_0 n_34_22_0 28.305783987028367
R29845 n_34_21_0 n_34_21_1 3269.3168553789606
R29846 n_34_21_1 n_35_21_1 1009.3848163513552
R29847 n_34_21_1 n_34_22_1 39.62809758183971
R29848 n_34_21_1 n_34_21_2 7430.265580406729
R29849 n_34_21_2 n_35_21_2 1802.4728863417063
R29850 n_34_21_2 n_34_22_2 70.76445996757093
R29851 n_34_21_2 n_34_21_3 6954.7285832606985
R29852 n_34_21_3 n_35_21_3 25234.620408783856
R29853 n_34_21_3 n_34_22_3 990.7024395459919
R29854 n_34_21_3 n_34_21_4 92.46552722283937
R29855 n_34_21_4 n_35_21_4 764.6854669328443
R29856 n_34_21_4 n_34_22_4 30.02128604684824
R29857 n_34_21_4 n_34_21_5 76.42558882704071
R29858 n_34_21_5 n_35_21_5 4806.594363577878
R29859 n_34_21_5 n_34_22_5 188.70522658018893
R29860 n_34_21_5 n_34_21_6 26.418722063668394
R29861 n_34_21_6 n_35_21_6 801.099060596313
R29862 n_34_21_6 n_34_22_6 31.45087109669815
R29863 n_34_21_6 n_34_21_7 35.85397994354992
R29864 n_34_21_7 n_35_21_7 1373.3126753079694
R29865 n_34_21_7 n_34_22_7 53.915779022911295
R29866 n_34_21_7 n_34_21_8 26.418722063668312
R29867 n_34_21_8 n_35_21_8 1373.3126753079694
R29868 n_34_21_8 n_34_22_8 53.915779022911295
R29869 n_34_21_8 n_34_21_9 26.418722063668312
R29870 n_34_21_9 n_35_21_9 1373.3126753079694
R29871 n_34_21_9 n_34_22_9 53.915779022911295
R29872 n_34_21_9 n_34_21_10 26.418722063668312
R29873 n_34_21_10 n_35_21_10 1373.3126753079694
R29874 n_34_21_10 n_34_22_10 53.915779022911295
R29875 n_34_21_10 n_34_21_11 26.41872206366814
R29876 n_34_21_11 n_35_21_11 1373.312675307987
R29877 n_34_21_11 n_34_22_11 53.91577902291198
R29878 n_34_21_11 n_34_21_12 26.418722063668056
R29879 n_34_21_12 n_35_21_12 1373.312675307978
R29880 n_34_21_12 n_34_22_12 53.915779022911636
R29881 n_34_21_12 n_34_21_13 26.418722063668312
R29882 n_34_21_13 n_35_21_13 1373.3126753079605
R29883 n_34_21_13 n_34_22_13 53.91577902291095
R29884 n_34_21_13 n_34_21_14 132.0936103183419
R29885 n_34_21_14 n_35_21_14 152.59029725644075
R29886 n_34_21_14 n_34_22_14 5.990642113656799
R29887 n_34_21_14 n_34_21_15 4081.692558836802
R29888 n_34_21_15 n_35_21_15 50469.24081756726
R29889 n_34_21_15 n_34_22_15 1981.4048790919662
R29890 n_34_22_0 n_35_22_0 720.9891545367336
R29891 n_34_22_0 n_34_23_0 28.305783987028367
R29892 n_34_22_0 n_34_22_1 3269.316855379193
R29893 n_34_22_1 n_35_22_1 1009.3848163514269
R29894 n_34_22_1 n_34_23_1 39.62809758183971
R29895 n_34_22_1 n_34_22_2 7430.2655804072565
R29896 n_34_22_2 n_35_22_2 1802.472886341834
R29897 n_34_22_2 n_34_23_2 70.76445996757093
R29898 n_34_22_2 n_34_22_3 6954.728583261192
R29899 n_34_22_3 n_35_22_3 25234.620408785653
R29900 n_34_22_3 n_34_23_3 990.7024395459919
R29901 n_34_22_3 n_34_22_4 92.46552722284595
R29902 n_34_22_4 n_35_22_4 764.6854669328985
R29903 n_34_22_4 n_34_23_4 30.02128604684824
R29904 n_34_22_4 n_34_22_5 76.42558882704614
R29905 n_34_22_5 n_35_22_5 4806.59436357822
R29906 n_34_22_5 n_34_23_5 188.70522658018893
R29907 n_34_22_5 n_34_22_6 26.418722063670273
R29908 n_34_22_6 n_35_22_6 801.0990605963699
R29909 n_34_22_6 n_34_23_6 31.45087109669815
R29910 n_34_22_6 n_34_22_7 35.853979943552474
R29911 n_34_22_7 n_35_22_7 1373.312675308067
R29912 n_34_22_7 n_34_23_7 53.915779022911295
R29913 n_34_22_7 n_34_22_8 26.418722063670188
R29914 n_34_22_8 n_35_22_8 1373.312675308067
R29915 n_34_22_8 n_34_23_8 53.915779022911295
R29916 n_34_22_8 n_34_22_9 26.418722063670188
R29917 n_34_22_9 n_35_22_9 1373.312675308067
R29918 n_34_22_9 n_34_23_9 53.915779022911295
R29919 n_34_22_9 n_34_22_10 26.418722063670188
R29920 n_34_22_10 n_35_22_10 1373.312675308067
R29921 n_34_22_10 n_34_23_10 53.915779022911295
R29922 n_34_22_10 n_34_22_11 26.418722063670018
R29923 n_34_22_11 n_35_22_11 1373.3126753080844
R29924 n_34_22_11 n_34_23_11 53.91577902291198
R29925 n_34_22_11 n_34_22_12 26.418722063669936
R29926 n_34_22_12 n_35_22_12 1373.3126753080758
R29927 n_34_22_12 n_34_23_12 53.915779022911636
R29928 n_34_22_12 n_34_22_13 26.418722063670188
R29929 n_34_22_13 n_35_22_13 1373.3126753080583
R29930 n_34_22_13 n_34_23_13 53.91577902291095
R29931 n_34_22_13 n_34_22_14 132.09361031835127
R29932 n_34_22_14 n_35_22_14 152.59029725645155
R29933 n_34_22_14 n_34_23_14 5.990642113656799
R29934 n_34_22_14 n_34_22_15 4081.6925588370914
R29935 n_34_22_15 n_35_22_15 50469.240817570855
R29936 n_34_22_15 n_34_23_15 1981.4048790919662
R29937 n_34_23_0 n_35_23_0 720.9891545366825
R29938 n_34_23_0 n_34_24_0 326.2736359366277
R29939 n_34_23_0 n_34_23_1 3269.3168553789606
R29940 n_34_23_1 n_35_23_1 1009.3848163513552
R29941 n_34_23_1 n_34_24_1 456.7830903112788
R29942 n_34_23_1 n_34_23_2 7430.265580406729
R29943 n_34_23_2 n_35_23_2 1802.4728863417063
R29944 n_34_23_2 n_34_24_2 815.6840898415694
R29945 n_34_23_2 n_34_23_3 6954.7285832606985
R29946 n_34_23_3 n_35_23_3 25234.620408783856
R29947 n_34_23_3 n_34_24_3 11419.57725778196
R29948 n_34_23_3 n_34_23_4 92.46552722283937
R29949 n_34_23_4 n_35_23_4 764.6854669328443
R29950 n_34_23_4 n_34_24_4 346.0477956903624
R29951 n_34_23_4 n_34_23_5 76.42558882704071
R29952 n_34_23_5 n_35_23_5 4806.594363577878
R29953 n_34_23_5 n_34_24_5 2175.1575729108495
R29954 n_34_23_5 n_34_23_6 26.418722063668394
R29955 n_34_23_6 n_35_23_6 801.099060596313
R29956 n_34_23_6 n_34_24_6 362.5262621518082
R29957 n_34_23_6 n_34_23_7 35.85397994354992
R29958 n_34_23_7 n_35_23_7 1373.3126753079694
R29959 n_34_23_7 n_34_24_7 621.4735922602447
R29960 n_34_23_7 n_34_23_8 26.418722063668312
R29961 n_34_23_8 n_35_23_8 1373.3126753079694
R29962 n_34_23_8 n_34_24_8 621.4735922602447
R29963 n_34_23_8 n_34_23_9 26.418722063668312
R29964 n_34_23_9 n_35_23_9 1373.3126753079694
R29965 n_34_23_9 n_34_24_9 621.4735922602447
R29966 n_34_23_9 n_34_23_10 26.418722063668312
R29967 n_34_23_10 n_35_23_10 1373.3126753079694
R29968 n_34_23_10 n_34_24_10 621.4735922602447
R29969 n_34_23_10 n_34_23_11 26.41872206366814
R29970 n_34_23_11 n_35_23_11 1373.312675307987
R29971 n_34_23_11 n_34_24_11 621.4735922602525
R29972 n_34_23_11 n_34_23_12 26.418722063668056
R29973 n_34_23_12 n_35_23_12 1373.312675307978
R29974 n_34_23_12 n_34_24_12 621.4735922602487
R29975 n_34_23_12 n_34_23_13 26.418722063668312
R29976 n_34_23_13 n_35_23_13 1373.3126753079605
R29977 n_34_23_13 n_34_24_13 621.4735922602406
R29978 n_34_23_13 n_34_23_14 132.0936103183419
R29979 n_34_23_14 n_35_23_14 152.59029725644075
R29980 n_34_23_14 n_34_24_14 69.05262136224925
R29981 n_34_23_14 n_34_23_15 4081.692558836802
R29982 n_34_23_15 n_35_23_15 50469.24081756726
R29983 n_34_23_15 n_34_24_15 22839.154515563718
R29984 n_34_24_0 n_35_24_0 32.692737764693156
R29985 n_34_24_0 n_34_25_0 624.2414878862251
R29986 n_34_24_0 n_34_24_1 148.244835515286
R29987 n_34_24_1 n_35_24_1 45.76983287057042
R29988 n_34_24_1 n_34_25_1 873.9380830407151
R29989 n_34_24_1 n_34_24_2 336.92008071655914
R29990 n_34_24_2 n_35_24_2 81.73184441173291
R29991 n_34_24_2 n_34_25_2 1560.6037197155629
R29992 n_34_24_2 n_34_24_3 315.3571955506994
R29993 n_34_24_3 n_35_24_3 1144.2458217642595
R29994 n_34_24_3 n_34_25_3 21848.452076017857
R29995 n_34_24_3 n_34_24_4 4.192783226694962
R29996 n_34_24_4 n_35_24_4 34.67411581103816
R29997 n_34_24_4 n_34_25_4 662.0743053338745
R29998 n_34_24_4 n_34_24_5 3.465463687370326
R29999 n_34_24_5 n_35_24_5 217.9515850979542
R30000 n_34_24_5 n_34_25_5 4161.609919241497
R30001 n_34_24_5 n_34_24_6 1.197938064769989
R30002 n_34_24_6 n_35_24_6 36.32526418299236
R30003 n_34_24_6 n_34_25_6 693.6016532069161
R30004 n_34_24_6 n_34_24_7 1.6257730879021264
R30005 n_34_24_7 n_35_24_7 62.27188145655853
R30006 n_34_24_7 n_34_25_7 1189.0314054975743
R30007 n_34_24_7 n_34_24_8 1.1979380647699855
R30008 n_34_24_8 n_35_24_8 62.27188145655853
R30009 n_34_24_8 n_34_25_8 1189.0314054975743
R30010 n_34_24_8 n_34_24_9 1.1979380647699855
R30011 n_34_24_9 n_35_24_9 62.27188145655853
R30012 n_34_24_9 n_34_25_9 1189.0314054975743
R30013 n_34_24_9 n_34_24_10 1.1979380647699855
R30014 n_34_24_10 n_35_24_10 62.27188145655853
R30015 n_34_24_10 n_34_25_10 1189.0314054975743
R30016 n_34_24_10 n_34_24_11 1.197938064769978
R30017 n_34_24_11 n_35_24_11 62.27188145655932
R30018 n_34_24_11 n_34_25_11 1189.0314054975893
R30019 n_34_24_11 n_34_24_12 1.197938064769974
R30020 n_34_24_12 n_35_24_12 62.27188145655893
R30021 n_34_24_12 n_34_25_12 1189.031405497582
R30022 n_34_24_12 n_34_24_13 1.1979380647699855
R30023 n_34_24_13 n_35_24_13 62.271881456558134
R30024 n_34_24_13 n_34_25_13 1189.0314054975665
R30025 n_34_24_13 n_34_24_14 5.989690323849942
R30026 n_34_24_14 n_35_24_14 6.919097939617599
R30027 n_34_24_14 n_34_25_14 132.1146006108413
R30028 n_34_24_14 n_34_24_15 185.08143100696492
R30029 n_34_24_15 n_35_24_15 2288.4916435284986
R30030 n_34_24_15 n_34_25_15 43696.904152035335
R30031 n_34_25_0 n_35_25_0 32.69273776469326
R30032 n_34_25_0 n_34_26_0 624.2414878862251
R30033 n_34_25_0 n_34_25_1 148.2448355152865
R30034 n_34_25_1 n_35_25_1 45.76983287057057
R30035 n_34_25_1 n_34_26_1 873.9380830407151
R30036 n_34_25_1 n_34_25_2 336.9200807165603
R30037 n_34_25_2 n_35_25_2 81.73184441173316
R30038 n_34_25_2 n_34_26_2 1560.6037197155629
R30039 n_34_25_2 n_34_25_3 315.3571955507004
R30040 n_34_25_3 n_35_25_3 1144.2458217642632
R30041 n_34_25_3 n_34_26_3 21848.452076017857
R30042 n_34_25_3 n_34_25_4 4.192783226694976
R30043 n_34_25_4 n_35_25_4 34.67411581103828
R30044 n_34_25_4 n_34_26_4 662.0743053338745
R30045 n_34_25_4 n_34_25_5 3.4654636873703373
R30046 n_34_25_5 n_35_25_5 217.95158509795488
R30047 n_34_25_5 n_34_26_5 4161.609919241497
R30048 n_34_25_5 n_34_25_6 1.197938064769993
R30049 n_34_25_6 n_35_25_6 36.325264182992484
R30050 n_34_25_6 n_34_26_6 693.6016532069161
R30051 n_34_25_6 n_34_25_7 1.6257730879021315
R30052 n_34_25_7 n_35_25_7 62.27188145655874
R30053 n_34_25_7 n_34_26_7 1189.0314054975743
R30054 n_34_25_7 n_34_25_8 1.1979380647699893
R30055 n_34_25_8 n_35_25_8 62.27188145655874
R30056 n_34_25_8 n_34_26_8 1189.0314054975743
R30057 n_34_25_8 n_34_25_9 1.1979380647699893
R30058 n_34_25_9 n_35_25_9 62.27188145655874
R30059 n_34_25_9 n_34_26_9 1189.0314054975743
R30060 n_34_25_9 n_34_25_10 1.1979380647699893
R30061 n_34_25_10 n_35_25_10 62.27188145655874
R30062 n_34_25_10 n_34_26_10 1189.0314054975743
R30063 n_34_25_10 n_34_25_11 1.1979380647699815
R30064 n_34_25_11 n_35_25_11 62.27188145655953
R30065 n_34_25_11 n_34_26_11 1189.0314054975893
R30066 n_34_25_11 n_34_25_12 1.1979380647699778
R30067 n_34_25_12 n_35_25_12 62.271881456559115
R30068 n_34_25_12 n_34_26_12 1189.031405497582
R30069 n_34_25_12 n_34_25_13 1.197938064769989
R30070 n_34_25_13 n_35_25_13 62.27188145655835
R30071 n_34_25_13 n_34_26_13 1189.0314054975665
R30072 n_34_25_13 n_34_25_14 5.9896903238499615
R30073 n_34_25_14 n_35_25_14 6.919097939617622
R30074 n_34_25_14 n_34_26_14 132.1146006108413
R30075 n_34_25_14 n_34_25_15 185.08143100696552
R30076 n_34_25_15 n_35_25_15 2288.491643528506
R30077 n_34_25_15 n_34_26_15 43696.904152035335
R30078 n_34_26_0 n_35_26_0 32.692737764693156
R30079 n_34_26_0 n_34_27_0 624.2414878862261
R30080 n_34_26_0 n_34_26_1 148.244835515286
R30081 n_34_26_1 n_35_26_1 45.76983287057042
R30082 n_34_26_1 n_34_27_1 873.9380830407165
R30083 n_34_26_1 n_34_26_2 336.92008071655914
R30084 n_34_26_2 n_35_26_2 81.73184441173291
R30085 n_34_26_2 n_34_27_2 1560.6037197155654
R30086 n_34_26_2 n_34_26_3 315.3571955506994
R30087 n_34_26_3 n_35_26_3 1144.2458217642595
R30088 n_34_26_3 n_34_27_3 21848.452076017893
R30089 n_34_26_3 n_34_26_4 4.192783226694962
R30090 n_34_26_4 n_35_26_4 34.67411581103816
R30091 n_34_26_4 n_34_27_4 662.0743053338755
R30092 n_34_26_4 n_34_26_5 3.465463687370326
R30093 n_34_26_5 n_35_26_5 217.9515850979542
R30094 n_34_26_5 n_34_27_5 4161.609919241503
R30095 n_34_26_5 n_34_26_6 1.197938064769989
R30096 n_34_26_6 n_35_26_6 36.32526418299236
R30097 n_34_26_6 n_34_27_6 693.6016532069171
R30098 n_34_26_6 n_34_26_7 1.6257730879021264
R30099 n_34_26_7 n_35_26_7 62.27188145655853
R30100 n_34_26_7 n_34_27_7 1189.031405497576
R30101 n_34_26_7 n_34_26_8 1.1979380647699855
R30102 n_34_26_8 n_35_26_8 62.27188145655853
R30103 n_34_26_8 n_34_27_8 1189.031405497576
R30104 n_34_26_8 n_34_26_9 1.1979380647699855
R30105 n_34_26_9 n_35_26_9 62.27188145655853
R30106 n_34_26_9 n_34_27_9 1189.031405497576
R30107 n_34_26_9 n_34_26_10 1.1979380647699855
R30108 n_34_26_10 n_35_26_10 62.27188145655853
R30109 n_34_26_10 n_34_27_10 1189.031405497576
R30110 n_34_26_10 n_34_26_11 1.197938064769978
R30111 n_34_26_11 n_35_26_11 62.27188145655932
R30112 n_34_26_11 n_34_27_11 1189.031405497591
R30113 n_34_26_11 n_34_26_12 1.197938064769974
R30114 n_34_26_12 n_35_26_12 62.27188145655893
R30115 n_34_26_12 n_34_27_12 1189.0314054975838
R30116 n_34_26_12 n_34_26_13 1.1979380647699855
R30117 n_34_26_13 n_35_26_13 62.271881456558134
R30118 n_34_26_13 n_34_27_13 1189.0314054975684
R30119 n_34_26_13 n_34_26_14 5.989690323849942
R30120 n_34_26_14 n_35_26_14 6.919097939617599
R30121 n_34_26_14 n_34_27_14 132.1146006108415
R30122 n_34_26_14 n_34_26_15 185.08143100696492
R30123 n_34_26_15 n_35_26_15 2288.4916435284986
R30124 n_34_26_15 n_34_27_15 43696.9041520354
R30125 n_34_27_0 n_35_27_0 32.692737764693156
R30126 n_34_27_0 n_34_27_1 148.244835515286
R30127 n_34_27_1 n_35_27_1 45.76983287057042
R30128 n_34_27_1 n_34_27_2 336.92008071655914
R30129 n_34_27_2 n_35_27_2 81.73184441173291
R30130 n_34_27_2 n_34_27_3 315.3571955506994
R30131 n_34_27_3 n_35_27_3 1144.2458217642595
R30132 n_34_27_3 n_34_27_4 4.192783226694962
R30133 n_34_27_4 n_35_27_4 34.67411581103816
R30134 n_34_27_4 n_34_27_5 3.465463687370326
R30135 n_34_27_5 n_35_27_5 217.9515850979542
R30136 n_34_27_5 n_34_27_6 1.197938064769989
R30137 n_34_27_6 n_35_27_6 36.32526418299236
R30138 n_34_27_6 n_34_27_7 1.6257730879021264
R30139 n_34_27_7 n_35_27_7 62.27188145655853
R30140 n_34_27_7 n_34_27_8 1.1979380647699855
R30141 n_34_27_8 n_35_27_8 62.27188145655853
R30142 n_34_27_8 n_34_27_9 1.1979380647699855
R30143 n_34_27_9 n_35_27_9 62.27188145655853
R30144 n_34_27_9 n_34_27_10 1.1979380647699855
R30145 n_34_27_10 n_35_27_10 62.27188145655853
R30146 n_34_27_10 n_34_27_11 1.197938064769978
R30147 n_34_27_11 n_35_27_11 62.27188145655932
R30148 n_34_27_11 n_34_27_12 1.197938064769974
R30149 n_34_27_12 n_35_27_12 62.27188145655893
R30150 n_34_27_12 n_34_27_13 1.1979380647699855
R30151 n_34_27_13 n_35_27_13 62.271881456558134
R30152 n_34_27_13 n_34_27_14 5.989690323849942
R30153 n_34_27_14 n_35_27_14 6.919097939617599
R30154 n_34_27_14 n_34_27_15 185.08143100696492
R30155 n_34_27_15 n_35_27_15 2288.4916435284986
R30156 n_35_0_0 n_35_1_0 624.2415416457984
R30157 n_35_0_0 n_35_0_1 148.2448227484626
R30158 n_35_0_1 n_35_1_1 873.9381583041177
R30159 n_35_0_1 n_35_0_2 336.92005170105136
R30160 n_35_0_2 n_35_1_2 1560.6038541144958
R30161 n_35_0_2 n_35_0_3 315.35716839218406
R30162 n_35_0_3 n_35_1_3 21848.453957602924
R30163 n_35_0_3 n_35_0_4 4.192782865613087
R30164 n_35_0_4 n_35_1_4 662.0743623516037
R30165 n_35_0_4 n_35_0_5 3.465463388925103
R30166 n_35_0_5 n_35_1_5 4161.610277638652
R30167 n_35_0_5 n_35_0_6 1.197937961603739
R30168 n_35_0_6 n_35_1_6 693.6017129397753
R30169 n_35_0_6 n_35_0_7 1.6257729478907872
R30170 n_35_0_7 n_35_1_7 1189.0315078967615
R30171 n_35_0_7 n_35_0_8 1.1979379616037356
R30172 n_35_0_8 n_35_1_8 1189.0315078967615
R30173 n_35_0_8 n_35_0_9 1.1979379616037356
R30174 n_35_0_9 n_35_1_9 1189.0315078967615
R30175 n_35_0_9 n_35_0_10 1.1979379616037356
R30176 n_35_0_10 n_35_1_10 1189.0315078967615
R30177 n_35_0_10 n_35_0_11 1.1979379616037278
R30178 n_35_0_11 n_35_1_11 1189.0315078967762
R30179 n_35_0_11 n_35_0_12 1.197937961603724
R30180 n_35_0_12 n_35_1_12 1189.031507896769
R30181 n_35_0_12 n_35_0_13 1.1979379616037353
R30182 n_35_0_13 n_35_1_13 1189.031507896754
R30183 n_35_0_13 n_35_0_14 5.989689808018693
R30184 n_35_0_14 n_35_1_14 132.1146119885288
R30185 n_35_0_14 n_35_0_15 185.0814150677793
R30186 n_35_0_15 n_35_1_15 43696.907915205455
R30187 n_35_1_0 n_35_2_0 624.2415416457984
R30188 n_35_1_0 n_35_1_1 148.2448227484626
R30189 n_35_1_1 n_35_2_1 873.9381583041177
R30190 n_35_1_1 n_35_1_2 336.92005170105136
R30191 n_35_1_2 n_35_2_2 1560.6038541144958
R30192 n_35_1_2 n_35_1_3 315.35716839218406
R30193 n_35_1_3 n_35_2_3 21848.453957602924
R30194 n_35_1_3 n_35_1_4 4.192782865613087
R30195 n_35_1_4 n_35_2_4 662.0743623516037
R30196 n_35_1_4 n_35_1_5 3.465463388925103
R30197 n_35_1_5 n_35_2_5 4161.610277638652
R30198 n_35_1_5 n_35_1_6 1.197937961603739
R30199 n_35_1_6 n_35_2_6 693.6017129397753
R30200 n_35_1_6 n_35_1_7 1.6257729478907872
R30201 n_35_1_7 n_35_2_7 1189.0315078967615
R30202 n_35_1_7 n_35_1_8 1.1979379616037356
R30203 n_35_1_8 n_35_2_8 1189.0315078967615
R30204 n_35_1_8 n_35_1_9 1.1979379616037356
R30205 n_35_1_9 n_35_2_9 1189.0315078967615
R30206 n_35_1_9 n_35_1_10 1.1979379616037356
R30207 n_35_1_10 n_35_2_10 1189.0315078967615
R30208 n_35_1_10 n_35_1_11 1.1979379616037278
R30209 n_35_1_11 n_35_2_11 1189.0315078967762
R30210 n_35_1_11 n_35_1_12 1.197937961603724
R30211 n_35_1_12 n_35_2_12 1189.031507896769
R30212 n_35_1_12 n_35_1_13 1.1979379616037353
R30213 n_35_1_13 n_35_2_13 1189.031507896754
R30214 n_35_1_13 n_35_1_14 5.989689808018693
R30215 n_35_1_14 n_35_2_14 132.1146119885288
R30216 n_35_1_14 n_35_1_15 185.0814150677793
R30217 n_35_1_15 n_35_2_15 43696.907915205455
R30218 n_35_2_0 n_35_3_0 624.2415416457984
R30219 n_35_2_0 n_35_2_1 148.2448227484626
R30220 n_35_2_1 n_35_3_1 873.9381583041177
R30221 n_35_2_1 n_35_2_2 336.92005170105136
R30222 n_35_2_2 n_35_3_2 1560.6038541144958
R30223 n_35_2_2 n_35_2_3 315.35716839218406
R30224 n_35_2_3 n_35_3_3 21848.453957602924
R30225 n_35_2_3 n_35_2_4 4.192782865613087
R30226 n_35_2_4 n_35_3_4 662.0743623516037
R30227 n_35_2_4 n_35_2_5 3.465463388925103
R30228 n_35_2_5 n_35_3_5 4161.610277638652
R30229 n_35_2_5 n_35_2_6 1.197937961603739
R30230 n_35_2_6 n_35_3_6 693.6017129397753
R30231 n_35_2_6 n_35_2_7 1.6257729478907872
R30232 n_35_2_7 n_35_3_7 1189.0315078967615
R30233 n_35_2_7 n_35_2_8 1.1979379616037356
R30234 n_35_2_8 n_35_3_8 1189.0315078967615
R30235 n_35_2_8 n_35_2_9 1.1979379616037356
R30236 n_35_2_9 n_35_3_9 1189.0315078967615
R30237 n_35_2_9 n_35_2_10 1.1979379616037356
R30238 n_35_2_10 n_35_3_10 1189.0315078967615
R30239 n_35_2_10 n_35_2_11 1.1979379616037278
R30240 n_35_2_11 n_35_3_11 1189.0315078967762
R30241 n_35_2_11 n_35_2_12 1.197937961603724
R30242 n_35_2_12 n_35_3_12 1189.031507896769
R30243 n_35_2_12 n_35_2_13 1.1979379616037353
R30244 n_35_2_13 n_35_3_13 1189.031507896754
R30245 n_35_2_13 n_35_2_14 5.989689808018693
R30246 n_35_2_14 n_35_3_14 132.1146119885288
R30247 n_35_2_14 n_35_2_15 185.0814150677793
R30248 n_35_2_15 n_35_3_15 43696.907915205455
R30249 n_35_3_0 n_35_4_0 326.27363593662244
R30250 n_35_3_0 n_35_3_1 148.2448227484626
R30251 n_35_3_1 n_35_4_1 456.78309031127134
R30252 n_35_3_1 n_35_3_2 336.92005170105136
R30253 n_35_3_2 n_35_4_2 815.684089841556
R30254 n_35_3_2 n_35_3_3 315.35716839218406
R30255 n_35_3_3 n_35_4_3 11419.577257781775
R30256 n_35_3_3 n_35_3_4 4.192782865613087
R30257 n_35_3_4 n_35_4_4 346.04779569035674
R30258 n_35_3_4 n_35_3_5 3.465463388925103
R30259 n_35_3_5 n_35_4_5 2175.1575729108145
R30260 n_35_3_5 n_35_3_6 1.197937961603739
R30261 n_35_3_6 n_35_4_6 362.52626215180237
R30262 n_35_3_6 n_35_3_7 1.6257729478907872
R30263 n_35_3_7 n_35_4_7 621.4735922602346
R30264 n_35_3_7 n_35_3_8 1.1979379616037356
R30265 n_35_3_8 n_35_4_8 621.4735922602346
R30266 n_35_3_8 n_35_3_9 1.1979379616037356
R30267 n_35_3_9 n_35_4_9 621.4735922602346
R30268 n_35_3_9 n_35_3_10 1.1979379616037356
R30269 n_35_3_10 n_35_4_10 621.4735922602346
R30270 n_35_3_10 n_35_3_11 1.1979379616037278
R30271 n_35_3_11 n_35_4_11 621.4735922602423
R30272 n_35_3_11 n_35_3_12 1.197937961603724
R30273 n_35_3_12 n_35_4_12 621.4735922602384
R30274 n_35_3_12 n_35_3_13 1.1979379616037353
R30275 n_35_3_13 n_35_4_13 621.4735922602306
R30276 n_35_3_13 n_35_3_14 5.989689808018693
R30277 n_35_3_14 n_35_4_14 69.05262136224815
R30278 n_35_3_14 n_35_3_15 185.0814150677793
R30279 n_35_3_15 n_35_4_15 22839.154515563343
R30280 n_35_4_0 n_35_5_0 28.305730227446706
R30281 n_35_4_0 n_35_4_1 3269.323064620219
R30282 n_35_4_1 n_35_5_1 39.628022318425394
R30283 n_35_4_1 n_35_4_2 7430.27969231868
R30284 n_35_4_2 n_35_5_2 70.76432556861675
R30285 n_35_4_2 n_35_4_3 6954.741792010284
R30286 n_35_4_3 n_35_5_3 990.7005579606339
R30287 n_35_4_3 n_35_4_4 92.46570283774365
R30288 n_35_4_4 n_35_5_4 30.021229029110113
R30289 n_35_4_4 n_35_4_5 76.42573397813506
R30290 n_35_4_5 n_35_5_5 188.7048681829779
R30291 n_35_4_5 n_35_4_6 26.41877223935533
R30292 n_35_4_6 n_35_5_6 31.450811363829644
R30293 n_35_4_6 n_35_4_7 35.85404803912505
R30294 n_35_4_7 n_35_5_7 53.91567662370813
R30295 n_35_4_7 n_35_4_8 26.41877223935525
R30296 n_35_4_8 n_35_5_8 53.91567662370813
R30297 n_35_4_8 n_35_4_9 26.41877223935525
R30298 n_35_4_9 n_35_5_9 53.91567662370813
R30299 n_35_4_9 n_35_4_10 26.41877223935525
R30300 n_35_4_10 n_35_5_10 53.91567662370813
R30301 n_35_4_10 n_35_4_11 26.41877223935508
R30302 n_35_4_11 n_35_5_11 53.915676623708805
R30303 n_35_4_11 n_35_4_12 26.418772239354993
R30304 n_35_4_12 n_35_5_12 53.91567662370848
R30305 n_35_4_12 n_35_4_13 26.41877223935525
R30306 n_35_4_13 n_35_5_13 53.915676623707796
R30307 n_35_4_13 n_35_4_14 132.09386119677657
R30308 n_35_4_14 n_35_5_14 5.990630735967558
R30309 n_35_4_14 n_35_4_15 4081.7003109804336
R30310 n_35_4_15 n_35_5_15 1981.40111592125
R30311 n_35_5_0 n_35_6_0 28.305730227446958
R30312 n_35_5_0 n_35_5_1 3269.3230646201605
R30313 n_35_5_1 n_35_6_1 39.62802231842574
R30314 n_35_5_1 n_35_5_2 7430.279692318547
R30315 n_35_5_2 n_35_6_2 70.76432556861738
R30316 n_35_5_2 n_35_5_3 6954.74179201016
R30317 n_35_5_3 n_35_6_3 990.7005579606426
R30318 n_35_5_3 n_35_5_4 92.46570283774201
R30319 n_35_5_4 n_35_6_4 30.02122902911038
R30320 n_35_5_4 n_35_5_5 76.4257339781337
R30321 n_35_5_5 n_35_6_5 188.70486818297957
R30322 n_35_5_5 n_35_5_6 26.418772239354862
R30323 n_35_5_6 n_35_6_6 31.45081136382992
R30324 n_35_5_6 n_35_5_7 35.854048039124415
R30325 n_35_5_7 n_35_6_7 53.915676623708606
R30326 n_35_5_7 n_35_5_8 26.41877223935478
R30327 n_35_5_8 n_35_6_8 53.915676623708606
R30328 n_35_5_8 n_35_5_9 26.41877223935478
R30329 n_35_5_9 n_35_6_9 53.915676623708606
R30330 n_35_5_9 n_35_5_10 26.41877223935478
R30331 n_35_5_10 n_35_6_10 53.915676623708606
R30332 n_35_5_10 n_35_5_11 26.41877223935461
R30333 n_35_5_11 n_35_6_11 53.91567662370929
R30334 n_35_5_11 n_35_5_12 26.418772239354524
R30335 n_35_5_12 n_35_6_12 53.915676623708954
R30336 n_35_5_12 n_35_5_13 26.41877223935478
R30337 n_35_5_13 n_35_6_13 53.91567662370827
R30338 n_35_5_13 n_35_5_14 132.0938611967742
R30339 n_35_5_14 n_35_6_14 5.990630735967612
R30340 n_35_5_14 n_35_5_15 4081.700310980361
R30341 n_35_5_15 n_35_6_15 1981.4011159212675
R30342 n_35_6_0 n_35_7_0 28.305730227446706
R30343 n_35_6_0 n_35_6_1 3269.3230646201605
R30344 n_35_6_1 n_35_7_1 39.628022318425394
R30345 n_35_6_1 n_35_6_2 7430.279692318547
R30346 n_35_6_2 n_35_7_2 70.76432556861675
R30347 n_35_6_2 n_35_6_3 6954.74179201016
R30348 n_35_6_3 n_35_7_3 990.7005579606339
R30349 n_35_6_3 n_35_6_4 92.46570283774201
R30350 n_35_6_4 n_35_7_4 30.021229029110113
R30351 n_35_6_4 n_35_6_5 76.4257339781337
R30352 n_35_6_5 n_35_7_5 188.7048681829779
R30353 n_35_6_5 n_35_6_6 26.418772239354862
R30354 n_35_6_6 n_35_7_6 31.450811363829644
R30355 n_35_6_6 n_35_6_7 35.854048039124415
R30356 n_35_6_7 n_35_7_7 53.91567662370813
R30357 n_35_6_7 n_35_6_8 26.41877223935478
R30358 n_35_6_8 n_35_7_8 53.91567662370813
R30359 n_35_6_8 n_35_6_9 26.41877223935478
R30360 n_35_6_9 n_35_7_9 53.91567662370813
R30361 n_35_6_9 n_35_6_10 26.41877223935478
R30362 n_35_6_10 n_35_7_10 53.91567662370813
R30363 n_35_6_10 n_35_6_11 26.41877223935461
R30364 n_35_6_11 n_35_7_11 53.915676623708805
R30365 n_35_6_11 n_35_6_12 26.418772239354524
R30366 n_35_6_12 n_35_7_12 53.91567662370848
R30367 n_35_6_12 n_35_6_13 26.41877223935478
R30368 n_35_6_13 n_35_7_13 53.915676623707796
R30369 n_35_6_13 n_35_6_14 132.0938611967742
R30370 n_35_6_14 n_35_7_14 5.990630735967558
R30371 n_35_6_14 n_35_6_15 4081.700310980361
R30372 n_35_6_15 n_35_7_15 1981.40111592125
R30373 n_35_7_0 n_35_8_0 827.2137876682006
R30374 n_35_7_0 n_35_7_1 3269.323064620219
R30375 n_35_7_1 n_35_8_1 1158.0993027354807
R30376 n_35_7_1 n_35_7_2 7430.27969231868
R30377 n_35_7_2 n_35_8_2 2068.0344691705013
R30378 n_35_7_2 n_35_7_3 6954.741792010284
R30379 n_35_7_3 n_35_8_3 28952.482568386997
R30380 n_35_7_3 n_35_7_4 92.46570283774365
R30381 n_35_7_4 n_35_8_4 877.3479566177876
R30382 n_35_7_4 n_35_7_5 76.42573397813506
R30383 n_35_7_5 n_35_8_5 5514.758584454666
R30384 n_35_7_5 n_35_7_6 26.41877223935533
R30385 n_35_7_6 n_35_8_6 919.1264307424442
R30386 n_35_7_6 n_35_7_7 35.85404803912505
R30387 n_35_7_7 n_35_8_7 1575.6453098441948
R30388 n_35_7_7 n_35_7_8 26.41877223935525
R30389 n_35_7_8 n_35_8_8 1575.6453098441948
R30390 n_35_7_8 n_35_7_9 26.41877223935525
R30391 n_35_7_9 n_35_8_9 1575.6453098441948
R30392 n_35_7_9 n_35_7_10 26.41877223935525
R30393 n_35_7_10 n_35_8_10 1575.6453098441948
R30394 n_35_7_10 n_35_7_11 26.41877223935508
R30395 n_35_7_11 n_35_8_11 1575.6453098442148
R30396 n_35_7_11 n_35_7_12 26.418772239354993
R30397 n_35_7_12 n_35_8_12 1575.645309844205
R30398 n_35_7_12 n_35_7_13 26.41877223935525
R30399 n_35_7_13 n_35_8_13 1575.6453098441852
R30400 n_35_7_13 n_35_7_14 132.09386119677657
R30401 n_35_7_14 n_35_8_14 175.0717010937991
R30402 n_35_7_14 n_35_7_15 4081.7003109804336
R30403 n_35_7_15 n_35_8_15 57904.96513677348
R30404 n_35_8_0 n_35_9_0 1626.121845108955
R30405 n_35_8_0 n_35_8_1 56.90875931090387
R30406 n_35_8_1 n_35_9_1 2276.5705831525374
R30407 n_35_8_1 n_35_8_2 129.33808934296334
R30408 n_35_8_2 n_35_9_2 4065.3046127723874
R30409 n_35_8_2 n_35_8_3 121.06045162501368
R30410 n_35_8_3 n_35_9_3 56914.26457881338
R30411 n_35_8_3 n_35_8_4 1.6095406673791008
R30412 n_35_8_4 n_35_9_4 1724.6746842064658
R30413 n_35_8_4 n_35_8_5 1.3303346332419097
R30414 n_35_8_5 n_35_9_5 10840.812300726358
R30415 n_35_8_5 n_35_8_6 0.4598687621083145
R30416 n_35_8_6 n_35_9_6 1806.8020501210594
R30417 n_35_8_6 n_35_8_7 0.624107605718426
R30418 n_35_8_7 n_35_9_7 3097.374943064683
R30419 n_35_8_7 n_35_8_8 0.45986876210831307
R30420 n_35_8_8 n_35_9_8 3097.374943064683
R30421 n_35_8_8 n_35_8_9 0.45986876210831307
R30422 n_35_8_9 n_35_9_9 3097.374943064683
R30423 n_35_8_9 n_35_8_10 0.45986876210831307
R30424 n_35_8_10 n_35_9_10 3097.374943064683
R30425 n_35_8_10 n_35_8_11 0.4598687621083101
R30426 n_35_8_11 n_35_9_11 3097.374943064722
R30427 n_35_8_11 n_35_8_12 0.4598687621083086
R30428 n_35_8_12 n_35_9_12 3097.374943064703
R30429 n_35_8_12 n_35_8_13 0.45986876210831307
R30430 n_35_8_13 n_35_9_13 3097.374943064664
R30431 n_35_8_13 n_35_8_14 2.299343810541571
R30432 n_35_8_14 n_35_9_14 344.15277145163077
R30433 n_35_8_14 n_35_8_15 71.04972374573519
R30434 n_35_8_15 n_35_9_15 113828.52915762574
R30435 n_35_9_0 n_35_10_0 1626.121845108955
R30436 n_35_9_0 n_35_9_1 56.90875931090384
R30437 n_35_9_1 n_35_10_1 2276.5705831525374
R30438 n_35_9_1 n_35_9_2 129.33808934296326
R30439 n_35_9_2 n_35_10_2 4065.3046127723874
R30440 n_35_9_2 n_35_9_3 121.06045162501361
R30441 n_35_9_3 n_35_10_3 56914.26457881338
R30442 n_35_9_3 n_35_9_4 1.6095406673791
R30443 n_35_9_4 n_35_10_4 1724.6746842064658
R30444 n_35_9_4 n_35_9_5 1.330334633241909
R30445 n_35_9_5 n_35_10_5 10840.812300726358
R30446 n_35_9_5 n_35_9_6 0.45986876210831423
R30447 n_35_9_6 n_35_10_6 1806.8020501210594
R30448 n_35_9_6 n_35_9_7 0.6241076057184257
R30449 n_35_9_7 n_35_10_7 3097.374943064683
R30450 n_35_9_7 n_35_9_8 0.4598687621083128
R30451 n_35_9_8 n_35_10_8 3097.374943064683
R30452 n_35_9_8 n_35_9_9 0.4598687621083128
R30453 n_35_9_9 n_35_10_9 3097.374943064683
R30454 n_35_9_9 n_35_9_10 0.4598687621083128
R30455 n_35_9_10 n_35_10_10 3097.374943064683
R30456 n_35_9_10 n_35_9_11 0.45986876210830985
R30457 n_35_9_11 n_35_10_11 3097.374943064722
R30458 n_35_9_11 n_35_9_12 0.4598687621083084
R30459 n_35_9_12 n_35_10_12 3097.374943064703
R30460 n_35_9_12 n_35_9_13 0.45986876210831285
R30461 n_35_9_13 n_35_10_13 3097.374943064664
R30462 n_35_9_13 n_35_9_14 2.29934381054157
R30463 n_35_9_14 n_35_10_14 344.15277145163077
R30464 n_35_9_14 n_35_9_15 71.04972374573515
R30465 n_35_9_15 n_35_10_15 113828.52915762574
R30466 n_35_10_0 n_35_11_0 1626.1218451089546
R30467 n_35_10_0 n_35_10_1 56.90875931090387
R30468 n_35_10_1 n_35_11_1 2276.5705831525365
R30469 n_35_10_1 n_35_10_2 129.33808934296334
R30470 n_35_10_2 n_35_11_2 4065.3046127723865
R30471 n_35_10_2 n_35_10_3 121.06045162501368
R30472 n_35_10_3 n_35_11_3 56914.26457881337
R30473 n_35_10_3 n_35_10_4 1.6095406673791008
R30474 n_35_10_4 n_35_11_4 1724.6746842064654
R30475 n_35_10_4 n_35_10_5 1.3303346332419097
R30476 n_35_10_5 n_35_11_5 10840.812300726355
R30477 n_35_10_5 n_35_10_6 0.4598687621083145
R30478 n_35_10_6 n_35_11_6 1806.802050121059
R30479 n_35_10_6 n_35_10_7 0.624107605718426
R30480 n_35_10_7 n_35_11_7 3097.374943064682
R30481 n_35_10_7 n_35_10_8 0.45986876210831307
R30482 n_35_10_8 n_35_11_8 3097.374943064682
R30483 n_35_10_8 n_35_10_9 0.45986876210831307
R30484 n_35_10_9 n_35_11_9 3097.374943064682
R30485 n_35_10_9 n_35_10_10 0.45986876210831307
R30486 n_35_10_10 n_35_11_10 3097.374943064682
R30487 n_35_10_10 n_35_10_11 0.4598687621083101
R30488 n_35_10_11 n_35_11_11 3097.3749430647213
R30489 n_35_10_11 n_35_10_12 0.4598687621083086
R30490 n_35_10_12 n_35_11_12 3097.374943064702
R30491 n_35_10_12 n_35_10_13 0.45986876210831307
R30492 n_35_10_13 n_35_11_13 3097.374943064663
R30493 n_35_10_13 n_35_10_14 2.299343810541571
R30494 n_35_10_14 n_35_11_14 344.1527714516307
R30495 n_35_10_14 n_35_10_15 71.04972374573519
R30496 n_35_10_15 n_35_11_15 113828.52915762572
R30497 n_35_11_0 n_35_12_0 827.2138119611456
R30498 n_35_11_0 n_35_11_1 56.90875931090387
R30499 n_35_11_1 n_35_12_1 1158.0993367456038
R30500 n_35_11_1 n_35_11_2 129.33808934296334
R30501 n_35_11_2 n_35_12_2 2068.034529902864
R30502 n_35_11_2 n_35_11_3 121.06045162501368
R30503 n_35_11_3 n_35_12_3 28952.483418640073
R30504 n_35_11_3 n_35_11_4 1.6095406673791008
R30505 n_35_11_4 n_35_12_4 877.3479823830323
R30506 n_35_11_4 n_35_11_5 1.3303346332419097
R30507 n_35_11_5 n_35_12_5 5514.758746407632
R30508 n_35_11_5 n_35_11_6 0.4598687621083145
R30509 n_35_11_6 n_35_12_6 919.1264577346053
R30510 n_35_11_6 n_35_11_7 0.624107605718426
R30511 n_35_11_7 n_35_12_7 1575.6453561164712
R30512 n_35_11_7 n_35_11_8 0.45986876210831307
R30513 n_35_11_8 n_35_12_8 1575.6453561164712
R30514 n_35_11_8 n_35_11_9 0.45986876210831307
R30515 n_35_11_9 n_35_12_9 1575.6453561164712
R30516 n_35_11_9 n_35_11_10 0.45986876210831307
R30517 n_35_11_10 n_35_12_10 1575.6453561164712
R30518 n_35_11_10 n_35_11_11 0.4598687621083101
R30519 n_35_11_11 n_35_12_11 1575.645356116491
R30520 n_35_11_11 n_35_11_12 0.4598687621083086
R30521 n_35_11_12 n_35_12_12 1575.6453561164815
R30522 n_35_11_12 n_35_11_13 0.45986876210831307
R30523 n_35_11_13 n_35_12_13 1575.6453561164615
R30524 n_35_11_13 n_35_11_14 2.299343810541571
R30525 n_35_11_14 n_35_12_14 175.07170623516313
R30526 n_35_11_14 n_35_11_15 71.04972374573519
R30527 n_35_11_15 n_35_12_15 57904.96683727963
R30528 n_35_12_0 n_35_13_0 28.305778813336563
R30529 n_35_12_0 n_35_12_1 3269.3174529402795
R30530 n_35_12_1 n_35_13_1 39.628090338671186
R30531 n_35_12_1 n_35_12_2 7430.266938500636
R30532 n_35_12_2 n_35_13_2 70.7644470333414
R30533 n_35_12_2 n_35_12_3 6954.729854436595
R30534 n_35_12_3 n_35_13_3 990.7022584667787
R30535 n_35_12_3 n_35_12_4 92.46554412356353
R30536 n_35_12_4 n_35_13_4 30.02128055959935
R30537 n_35_12_4 n_35_12_5 76.42560279600659
R30538 n_35_12_5 n_35_13_5 188.70519208891025
R30539 n_35_12_5 n_35_12_6 26.418726892446728
R30540 n_35_12_6 n_35_13_6 31.450865348151705
R30541 n_35_12_6 n_35_12_7 35.85398649689195
R30542 n_35_12_7 n_35_13_7 53.91576916826023
R30543 n_35_12_7 n_35_12_8 26.418726892446646
R30544 n_35_12_8 n_35_13_8 53.91576916826023
R30545 n_35_12_8 n_35_12_9 26.418726892446646
R30546 n_35_12_9 n_35_13_9 53.91576916826023
R30547 n_35_12_9 n_35_12_10 26.418726892446646
R30548 n_35_12_10 n_35_13_10 53.91576916826023
R30549 n_35_12_10 n_35_12_11 26.41872689244648
R30550 n_35_12_11 n_35_13_11 53.91576916826091
R30551 n_35_12_11 n_35_12_12 26.418726892446394
R30552 n_35_12_12 n_35_13_12 53.91576916826058
R30553 n_35_12_12 n_35_12_13 26.41872689244665
R30554 n_35_12_13 n_35_13_13 53.9157691682599
R30555 n_35_12_13 n_35_12_14 132.09363446223358
R30556 n_35_12_14 n_35_13_14 5.99064101869557
R30557 n_35_12_14 n_35_12_15 4081.6933048830547
R30558 n_35_12_15 n_35_13_15 1981.40451693354
R30559 n_35_13_0 n_35_14_0 28.305778813336563
R30560 n_35_13_0 n_35_13_1 3269.3174529402795
R30561 n_35_13_1 n_35_14_1 39.628090338671186
R30562 n_35_13_1 n_35_13_2 7430.266938500636
R30563 n_35_13_2 n_35_14_2 70.7644470333414
R30564 n_35_13_2 n_35_13_3 6954.729854436595
R30565 n_35_13_3 n_35_14_3 990.7022584667787
R30566 n_35_13_3 n_35_13_4 92.46554412356353
R30567 n_35_13_4 n_35_14_4 30.02128055959935
R30568 n_35_13_4 n_35_13_5 76.42560279600659
R30569 n_35_13_5 n_35_14_5 188.70519208891025
R30570 n_35_13_5 n_35_13_6 26.418726892446728
R30571 n_35_13_6 n_35_14_6 31.450865348151705
R30572 n_35_13_6 n_35_13_7 35.85398649689195
R30573 n_35_13_7 n_35_14_7 53.91576916826023
R30574 n_35_13_7 n_35_13_8 26.418726892446646
R30575 n_35_13_8 n_35_14_8 53.91576916826023
R30576 n_35_13_8 n_35_13_9 26.418726892446646
R30577 n_35_13_9 n_35_14_9 53.91576916826023
R30578 n_35_13_9 n_35_13_10 26.418726892446646
R30579 n_35_13_10 n_35_14_10 53.91576916826023
R30580 n_35_13_10 n_35_13_11 26.41872689244648
R30581 n_35_13_11 n_35_14_11 53.91576916826091
R30582 n_35_13_11 n_35_13_12 26.418726892446394
R30583 n_35_13_12 n_35_14_12 53.91576916826058
R30584 n_35_13_12 n_35_13_13 26.41872689244665
R30585 n_35_13_13 n_35_14_13 53.9157691682599
R30586 n_35_13_13 n_35_13_14 132.09363446223358
R30587 n_35_13_14 n_35_14_14 5.99064101869557
R30588 n_35_13_14 n_35_13_15 4081.6933048830547
R30589 n_35_13_15 n_35_14_15 1981.40451693354
R30590 n_35_14_0 n_35_15_0 28.305778813336563
R30591 n_35_14_0 n_35_14_1 3269.3174529402795
R30592 n_35_14_1 n_35_15_1 39.628090338671186
R30593 n_35_14_1 n_35_14_2 7430.266938500636
R30594 n_35_14_2 n_35_15_2 70.7644470333414
R30595 n_35_14_2 n_35_14_3 6954.729854436595
R30596 n_35_14_3 n_35_15_3 990.7022584667787
R30597 n_35_14_3 n_35_14_4 92.46554412356353
R30598 n_35_14_4 n_35_15_4 30.02128055959935
R30599 n_35_14_4 n_35_14_5 76.42560279600659
R30600 n_35_14_5 n_35_15_5 188.70519208891025
R30601 n_35_14_5 n_35_14_6 26.418726892446728
R30602 n_35_14_6 n_35_15_6 31.450865348151705
R30603 n_35_14_6 n_35_14_7 35.85398649689195
R30604 n_35_14_7 n_35_15_7 53.91576916826023
R30605 n_35_14_7 n_35_14_8 26.418726892446646
R30606 n_35_14_8 n_35_15_8 53.91576916826023
R30607 n_35_14_8 n_35_14_9 26.418726892446646
R30608 n_35_14_9 n_35_15_9 53.91576916826023
R30609 n_35_14_9 n_35_14_10 26.418726892446646
R30610 n_35_14_10 n_35_15_10 53.91576916826023
R30611 n_35_14_10 n_35_14_11 26.41872689244648
R30612 n_35_14_11 n_35_15_11 53.91576916826091
R30613 n_35_14_11 n_35_14_12 26.418726892446394
R30614 n_35_14_12 n_35_15_12 53.91576916826058
R30615 n_35_14_12 n_35_14_13 26.41872689244665
R30616 n_35_14_13 n_35_15_13 53.9157691682599
R30617 n_35_14_13 n_35_14_14 132.09363446223358
R30618 n_35_14_14 n_35_15_14 5.99064101869557
R30619 n_35_14_14 n_35_14_15 4081.6933048830547
R30620 n_35_14_15 n_35_15_15 1981.40451693354
R30621 n_35_15_0 n_35_16_0 827.2138119611451
R30622 n_35_15_0 n_35_15_1 3269.3174529402795
R30623 n_35_15_1 n_35_16_1 1158.099336745603
R30624 n_35_15_1 n_35_15_2 7430.266938500636
R30625 n_35_15_2 n_35_16_2 2068.0345299028627
R30626 n_35_15_2 n_35_15_3 6954.729854436595
R30627 n_35_15_3 n_35_16_3 28952.483418640055
R30628 n_35_15_3 n_35_15_4 92.46554412356353
R30629 n_35_15_4 n_35_16_4 877.3479823830318
R30630 n_35_15_4 n_35_15_5 76.42560279600659
R30631 n_35_15_5 n_35_16_5 5514.75874640763
R30632 n_35_15_5 n_35_15_6 26.418726892446728
R30633 n_35_15_6 n_35_16_6 919.1264577346047
R30634 n_35_15_6 n_35_15_7 35.85398649689195
R30635 n_35_15_7 n_35_16_7 1575.6453561164703
R30636 n_35_15_7 n_35_15_8 26.418726892446646
R30637 n_35_15_8 n_35_16_8 1575.6453561164703
R30638 n_35_15_8 n_35_15_9 26.418726892446646
R30639 n_35_15_9 n_35_16_9 1575.6453561164703
R30640 n_35_15_9 n_35_15_10 26.418726892446646
R30641 n_35_15_10 n_35_16_10 1575.6453561164703
R30642 n_35_15_10 n_35_15_11 26.41872689244648
R30643 n_35_15_11 n_35_16_11 1575.6453561164901
R30644 n_35_15_11 n_35_15_12 26.418726892446394
R30645 n_35_15_12 n_35_16_12 1575.6453561164806
R30646 n_35_15_12 n_35_15_13 26.41872689244665
R30647 n_35_15_13 n_35_16_13 1575.6453561164606
R30648 n_35_15_13 n_35_15_14 132.09363446223358
R30649 n_35_15_14 n_35_16_14 175.07170623516302
R30650 n_35_15_14 n_35_15_15 4081.6933048830547
R30651 n_35_15_15 n_35_16_15 57904.96683727959
R30652 n_35_16_0 n_35_17_0 1626.1218451089546
R30653 n_35_16_0 n_35_16_1 56.9087593109039
R30654 n_35_16_1 n_35_17_1 2276.5705831525365
R30655 n_35_16_1 n_35_16_2 129.33808934296343
R30656 n_35_16_2 n_35_17_2 4065.3046127723865
R30657 n_35_16_2 n_35_16_3 121.06045162501377
R30658 n_35_16_3 n_35_17_3 56914.26457881337
R30659 n_35_16_3 n_35_16_4 1.6095406673791017
R30660 n_35_16_4 n_35_17_4 1724.6746842064654
R30661 n_35_16_4 n_35_16_5 1.3303346332419106
R30662 n_35_16_5 n_35_17_5 10840.812300726357
R30663 n_35_16_5 n_35_16_6 0.45986876210831473
R30664 n_35_16_6 n_35_17_6 1806.802050121059
R30665 n_35_16_6 n_35_16_7 0.6241076057184265
R30666 n_35_16_7 n_35_17_7 3097.374943064682
R30667 n_35_16_7 n_35_16_8 0.4598687621083133
R30668 n_35_16_8 n_35_17_8 3097.374943064682
R30669 n_35_16_8 n_35_16_9 0.4598687621083133
R30670 n_35_16_9 n_35_17_9 3097.374943064682
R30671 n_35_16_9 n_35_16_10 0.4598687621083133
R30672 n_35_16_10 n_35_17_10 3097.374943064682
R30673 n_35_16_10 n_35_16_11 0.45986876210831035
R30674 n_35_16_11 n_35_17_11 3097.3749430647213
R30675 n_35_16_11 n_35_16_12 0.45986876210830885
R30676 n_35_16_12 n_35_17_12 3097.374943064702
R30677 n_35_16_12 n_35_16_13 0.4598687621083133
R30678 n_35_16_13 n_35_17_13 3097.374943064663
R30679 n_35_16_13 n_35_16_14 2.2993438105415724
R30680 n_35_16_14 n_35_17_14 344.15277145163066
R30681 n_35_16_14 n_35_16_15 71.04972374573525
R30682 n_35_16_15 n_35_17_15 113828.52915762572
R30683 n_35_17_0 n_35_18_0 1626.1218451089555
R30684 n_35_17_0 n_35_17_1 56.90875931090384
R30685 n_35_17_1 n_35_18_1 2276.570583152538
R30686 n_35_17_1 n_35_17_2 129.33808934296326
R30687 n_35_17_2 n_35_18_2 4065.3046127723887
R30688 n_35_17_2 n_35_17_3 121.06045162501361
R30689 n_35_17_3 n_35_18_3 56914.264578813396
R30690 n_35_17_3 n_35_17_4 1.6095406673791
R30691 n_35_17_4 n_35_18_4 1724.6746842064663
R30692 n_35_17_4 n_35_17_5 1.330334633241909
R30693 n_35_17_5 n_35_18_5 10840.812300726362
R30694 n_35_17_5 n_35_17_6 0.45986876210831423
R30695 n_35_17_6 n_35_18_6 1806.8020501210601
R30696 n_35_17_6 n_35_17_7 0.6241076057184257
R30697 n_35_17_7 n_35_18_7 3097.374943064684
R30698 n_35_17_7 n_35_17_8 0.4598687621083128
R30699 n_35_17_8 n_35_18_8 3097.374943064684
R30700 n_35_17_8 n_35_17_9 0.4598687621083128
R30701 n_35_17_9 n_35_18_9 3097.374943064684
R30702 n_35_17_9 n_35_17_10 0.4598687621083128
R30703 n_35_17_10 n_35_18_10 3097.374943064684
R30704 n_35_17_10 n_35_17_11 0.45986876210830985
R30705 n_35_17_11 n_35_18_11 3097.374943064723
R30706 n_35_17_11 n_35_17_12 0.4598687621083084
R30707 n_35_17_12 n_35_18_12 3097.374943064704
R30708 n_35_17_12 n_35_17_13 0.45986876210831285
R30709 n_35_17_13 n_35_18_13 3097.3749430646653
R30710 n_35_17_13 n_35_17_14 2.29934381054157
R30711 n_35_17_14 n_35_18_14 344.1527714516309
R30712 n_35_17_14 n_35_17_15 71.04972374573515
R30713 n_35_17_15 n_35_18_15 113828.52915762579
R30714 n_35_18_0 n_35_19_0 1626.1218451089546
R30715 n_35_18_0 n_35_18_1 56.90875931090384
R30716 n_35_18_1 n_35_19_1 2276.5705831525365
R30717 n_35_18_1 n_35_18_2 129.33808934296326
R30718 n_35_18_2 n_35_19_2 4065.3046127723865
R30719 n_35_18_2 n_35_18_3 121.06045162501361
R30720 n_35_18_3 n_35_19_3 56914.26457881337
R30721 n_35_18_3 n_35_18_4 1.6095406673791
R30722 n_35_18_4 n_35_19_4 1724.6746842064654
R30723 n_35_18_4 n_35_18_5 1.330334633241909
R30724 n_35_18_5 n_35_19_5 10840.812300726357
R30725 n_35_18_5 n_35_18_6 0.45986876210831423
R30726 n_35_18_6 n_35_19_6 1806.802050121059
R30727 n_35_18_6 n_35_18_7 0.6241076057184257
R30728 n_35_18_7 n_35_19_7 3097.374943064682
R30729 n_35_18_7 n_35_18_8 0.4598687621083128
R30730 n_35_18_8 n_35_19_8 3097.374943064682
R30731 n_35_18_8 n_35_18_9 0.4598687621083128
R30732 n_35_18_9 n_35_19_9 3097.374943064682
R30733 n_35_18_9 n_35_18_10 0.4598687621083128
R30734 n_35_18_10 n_35_19_10 3097.374943064682
R30735 n_35_18_10 n_35_18_11 0.45986876210830985
R30736 n_35_18_11 n_35_19_11 3097.3749430647213
R30737 n_35_18_11 n_35_18_12 0.4598687621083084
R30738 n_35_18_12 n_35_19_12 3097.374943064702
R30739 n_35_18_12 n_35_18_13 0.45986876210831285
R30740 n_35_18_13 n_35_19_13 3097.374943064663
R30741 n_35_18_13 n_35_18_14 2.29934381054157
R30742 n_35_18_14 n_35_19_14 344.15277145163066
R30743 n_35_18_14 n_35_18_15 71.04972374573515
R30744 n_35_18_15 n_35_19_15 113828.52915762572
R30745 n_35_19_0 n_35_20_0 827.2138145479913
R30746 n_35_19_0 n_35_19_1 56.9087593109039
R30747 n_35_19_1 n_35_20_1 1158.0993403671878
R30748 n_35_19_1 n_35_19_2 129.33808934296343
R30749 n_35_19_2 n_35_20_2 2068.034536369978
R30750 n_35_19_2 n_35_19_3 121.06045162501377
R30751 n_35_19_3 n_35_20_3 28952.48350917967
R30752 n_35_19_3 n_35_19_4 1.6095406673791017
R30753 n_35_19_4 n_35_20_4 877.3479851266566
R30754 n_35_19_4 n_35_19_5 1.3303346332419106
R30755 n_35_19_5 n_35_20_5 5514.758763653271
R30756 n_35_19_5 n_35_19_6 0.45986876210831473
R30757 n_35_19_6 n_35_20_6 919.1264606088783
R30758 n_35_19_6 n_35_19_7 0.6241076057184265
R30759 n_35_19_7 n_35_20_7 1575.6453610437964
R30760 n_35_19_7 n_35_19_8 0.4598687621083133
R30761 n_35_19_8 n_35_20_8 1575.6453610437964
R30762 n_35_19_8 n_35_19_9 0.4598687621083133
R30763 n_35_19_9 n_35_20_9 1575.6453610437964
R30764 n_35_19_9 n_35_19_10 0.4598687621083133
R30765 n_35_19_10 n_35_20_10 1575.6453610437964
R30766 n_35_19_10 n_35_19_11 0.45986876210831035
R30767 n_35_19_11 n_35_20_11 1575.6453610438164
R30768 n_35_19_11 n_35_19_12 0.45986876210830885
R30769 n_35_19_12 n_35_20_12 1575.6453610438066
R30770 n_35_19_12 n_35_19_13 0.4598687621083133
R30771 n_35_19_13 n_35_20_13 1575.6453610437866
R30772 n_35_19_13 n_35_19_14 2.2993438105415724
R30773 n_35_19_14 n_35_20_14 175.0717067826437
R30774 n_35_19_14 n_35_19_15 71.04972374573525
R30775 n_35_19_15 n_35_20_15 57904.967018358824
R30776 n_35_20_0 n_35_21_0 28.305783987028974
R30777 n_35_20_0 n_35_20_1 3269.3168553789146
R30778 n_35_20_1 n_35_21_1 39.628097581840564
R30779 n_35_20_1 n_35_20_2 7430.265580406624
R30780 n_35_20_2 n_35_21_2 70.76445996757244
R30781 n_35_20_2 n_35_20_3 6954.7285832606
R30782 n_35_20_3 n_35_21_3 990.7024395460132
R30783 n_35_20_3 n_35_20_4 92.46552722283808
R30784 n_35_20_4 n_35_21_4 30.021286046848882
R30785 n_35_20_4 n_35_20_5 76.42558882703963
R30786 n_35_20_5 n_35_21_5 188.705226580193
R30787 n_35_20_5 n_35_20_6 26.41872206366802
R30788 n_35_20_6 n_35_21_6 31.45087109669883
R30789 n_35_20_6 n_35_20_7 35.85397994354942
R30790 n_35_20_7 n_35_21_7 53.915779022912446
R30791 n_35_20_7 n_35_20_8 26.41872206366794
R30792 n_35_20_8 n_35_21_8 53.915779022912446
R30793 n_35_20_8 n_35_20_9 26.41872206366794
R30794 n_35_20_9 n_35_21_9 53.915779022912446
R30795 n_35_20_9 n_35_20_10 26.41872206366794
R30796 n_35_20_10 n_35_21_10 53.915779022912446
R30797 n_35_20_10 n_35_20_11 26.418722063667772
R30798 n_35_20_11 n_35_21_11 53.91577902291313
R30799 n_35_20_11 n_35_20_12 26.418722063667687
R30800 n_35_20_12 n_35_21_12 53.915779022912794
R30801 n_35_20_12 n_35_20_13 26.418722063667936
R30802 n_35_20_13 n_35_21_13 53.91577902291212
R30803 n_35_20_13 n_35_20_14 132.09361031834004
R30804 n_35_20_14 n_35_21_14 5.990642113656927
R30805 n_35_20_14 n_35_20_15 4081.6925588367444
R30806 n_35_20_15 n_35_21_15 1981.4048790920087
R30807 n_35_21_0 n_35_22_0 28.30578398702797
R30808 n_35_21_0 n_35_21_1 3269.3168553789146
R30809 n_35_21_1 n_35_22_1 39.62809758183916
R30810 n_35_21_1 n_35_21_2 7430.265580406624
R30811 n_35_21_2 n_35_22_2 70.76445996756992
R30812 n_35_21_2 n_35_21_3 6954.7285832606
R30813 n_35_21_3 n_35_22_3 990.702439545978
R30814 n_35_21_3 n_35_21_4 92.46552722283808
R30815 n_35_21_4 n_35_22_4 30.021286046847816
R30816 n_35_21_4 n_35_21_5 76.42558882703963
R30817 n_35_21_5 n_35_22_5 188.70522658018632
R30818 n_35_21_5 n_35_21_6 26.41872206366802
R30819 n_35_21_6 n_35_22_6 31.45087109669771
R30820 n_35_21_6 n_35_21_7 35.85397994354942
R30821 n_35_21_7 n_35_22_7 53.915779022910534
R30822 n_35_21_7 n_35_21_8 26.41872206366794
R30823 n_35_21_8 n_35_22_8 53.915779022910534
R30824 n_35_21_8 n_35_21_9 26.41872206366794
R30825 n_35_21_9 n_35_22_9 53.915779022910534
R30826 n_35_21_9 n_35_21_10 26.41872206366794
R30827 n_35_21_10 n_35_22_10 53.915779022910534
R30828 n_35_21_10 n_35_21_11 26.418722063667772
R30829 n_35_21_11 n_35_22_11 53.91577902291121
R30830 n_35_21_11 n_35_21_12 26.418722063667687
R30831 n_35_21_12 n_35_22_12 53.91577902291088
R30832 n_35_21_12 n_35_21_13 26.418722063667936
R30833 n_35_21_13 n_35_22_13 53.9157790229102
R30834 n_35_21_13 n_35_21_14 132.09361031834004
R30835 n_35_21_14 n_35_22_14 5.990642113656714
R30836 n_35_21_14 n_35_21_15 4081.6925588367444
R30837 n_35_21_15 n_35_22_15 1981.4048790919383
R30838 n_35_22_0 n_35_23_0 28.30578398702797
R30839 n_35_22_0 n_35_22_1 3269.316855379147
R30840 n_35_22_1 n_35_23_1 39.62809758183916
R30841 n_35_22_1 n_35_22_2 7430.265580407153
R30842 n_35_22_2 n_35_23_2 70.76445996756992
R30843 n_35_22_2 n_35_22_3 6954.728583261095
R30844 n_35_22_3 n_35_23_3 990.702439545978
R30845 n_35_22_3 n_35_22_4 92.46552722284464
R30846 n_35_22_4 n_35_23_4 30.021286046847816
R30847 n_35_22_4 n_35_22_5 76.42558882704506
R30848 n_35_22_5 n_35_23_5 188.70522658018632
R30849 n_35_22_5 n_35_22_6 26.418722063669897
R30850 n_35_22_6 n_35_23_6 31.45087109669771
R30851 n_35_22_6 n_35_22_7 35.85397994355196
R30852 n_35_22_7 n_35_23_7 53.915779022910534
R30853 n_35_22_7 n_35_22_8 26.418722063669815
R30854 n_35_22_8 n_35_23_8 53.915779022910534
R30855 n_35_22_8 n_35_22_9 26.418722063669815
R30856 n_35_22_9 n_35_23_9 53.915779022910534
R30857 n_35_22_9 n_35_22_10 26.418722063669815
R30858 n_35_22_10 n_35_23_10 53.915779022910534
R30859 n_35_22_10 n_35_22_11 26.418722063669648
R30860 n_35_22_11 n_35_23_11 53.91577902291121
R30861 n_35_22_11 n_35_22_12 26.418722063669563
R30862 n_35_22_12 n_35_23_12 53.91577902291088
R30863 n_35_22_12 n_35_22_13 26.41872206366981
R30864 n_35_22_13 n_35_23_13 53.9157790229102
R30865 n_35_22_13 n_35_22_14 132.0936103183494
R30866 n_35_22_14 n_35_23_14 5.990642113656714
R30867 n_35_22_14 n_35_22_15 4081.692558837034
R30868 n_35_22_15 n_35_23_15 1981.4048790919383
R30869 n_35_23_0 n_35_24_0 326.2736359366231
R30870 n_35_23_0 n_35_23_1 3269.3168553789146
R30871 n_35_23_1 n_35_24_1 456.7830903112724
R30872 n_35_23_1 n_35_23_2 7430.265580406624
R30873 n_35_23_2 n_35_24_2 815.6840898415578
R30874 n_35_23_2 n_35_23_3 6954.7285832606
R30875 n_35_23_3 n_35_24_3 11419.5772577818
R30876 n_35_23_3 n_35_23_4 92.46552722283808
R30877 n_35_23_4 n_35_24_4 346.04779569035753
R30878 n_35_23_4 n_35_23_5 76.42558882703963
R30879 n_35_23_5 n_35_24_5 2175.157572910819
R30880 n_35_23_5 n_35_23_6 26.41872206366802
R30881 n_35_23_6 n_35_24_6 362.52626215180317
R30882 n_35_23_6 n_35_23_7 35.85397994354942
R30883 n_35_23_7 n_35_24_7 621.4735922602358
R30884 n_35_23_7 n_35_23_8 26.41872206366794
R30885 n_35_23_8 n_35_24_8 621.4735922602358
R30886 n_35_23_8 n_35_23_9 26.41872206366794
R30887 n_35_23_9 n_35_24_9 621.4735922602358
R30888 n_35_23_9 n_35_23_10 26.41872206366794
R30889 n_35_23_10 n_35_24_10 621.4735922602358
R30890 n_35_23_10 n_35_23_11 26.418722063667772
R30891 n_35_23_11 n_35_24_11 621.4735922602437
R30892 n_35_23_11 n_35_23_12 26.418722063667687
R30893 n_35_23_12 n_35_24_12 621.4735922602399
R30894 n_35_23_12 n_35_23_13 26.418722063667936
R30895 n_35_23_13 n_35_24_13 621.4735922602321
R30896 n_35_23_13 n_35_23_14 132.09361031834004
R30897 n_35_23_14 n_35_24_14 69.05262136224829
R30898 n_35_23_14 n_35_23_15 4081.6925588367444
R30899 n_35_23_15 n_35_24_15 22839.154515563394
R30900 n_35_24_0 n_35_25_0 624.2414878862163
R30901 n_35_24_0 n_35_24_1 148.24483551528397
R30902 n_35_24_1 n_35_25_1 873.9380830407028
R30903 n_35_24_1 n_35_24_2 336.9200807165545
R30904 n_35_24_2 n_35_25_2 1560.6037197155406
R30905 n_35_24_2 n_35_24_3 315.357195550695
R30906 n_35_24_3 n_35_25_3 21848.45207601755
R30907 n_35_24_3 n_35_24_4 4.192783226694903
R30908 n_35_24_4 n_35_25_4 662.0743053338651
R30909 n_35_24_4 n_35_24_5 3.4654636873702773
R30910 n_35_24_5 n_35_25_5 4161.609919241439
R30911 n_35_24_5 n_35_24_6 1.1979380647699724
R30912 n_35_24_6 n_35_25_6 693.6016532069063
R30913 n_35_24_6 n_35_24_7 1.6257730879021035
R30914 n_35_24_7 n_35_25_7 1189.0314054975574
R30915 n_35_24_7 n_35_24_8 1.1979380647699687
R30916 n_35_24_8 n_35_25_8 1189.0314054975574
R30917 n_35_24_8 n_35_24_9 1.1979380647699687
R30918 n_35_24_9 n_35_25_9 1189.0314054975574
R30919 n_35_24_9 n_35_24_10 1.1979380647699687
R30920 n_35_24_10 n_35_25_10 1189.0314054975574
R30921 n_35_24_10 n_35_24_11 1.1979380647699611
R30922 n_35_24_11 n_35_25_11 1189.0314054975725
R30923 n_35_24_11 n_35_24_12 1.1979380647699571
R30924 n_35_24_12 n_35_25_12 1189.0314054975652
R30925 n_35_24_12 n_35_24_13 1.1979380647699687
R30926 n_35_24_13 n_35_25_13 1189.0314054975502
R30927 n_35_24_13 n_35_24_14 5.9896903238498584
R30928 n_35_24_14 n_35_25_14 132.11460061083946
R30929 n_35_24_14 n_35_24_15 185.08143100696236
R30930 n_35_24_15 n_35_25_15 43696.90415203471
R30931 n_35_25_0 n_35_26_0 624.2414878862163
R30932 n_35_25_0 n_35_25_1 148.24483551528445
R30933 n_35_25_1 n_35_26_1 873.9380830407028
R30934 n_35_25_1 n_35_25_2 336.92008071655556
R30935 n_35_25_2 n_35_26_2 1560.6037197155406
R30936 n_35_25_2 n_35_25_3 315.357195550696
R30937 n_35_25_3 n_35_26_3 21848.45207601755
R30938 n_35_25_3 n_35_25_4 4.1927832266949165
R30939 n_35_25_4 n_35_26_4 662.0743053338651
R30940 n_35_25_4 n_35_25_5 3.4654636873702884
R30941 n_35_25_5 n_35_26_5 4161.609919241439
R30942 n_35_25_5 n_35_25_6 1.1979380647699762
R30943 n_35_25_6 n_35_26_6 693.6016532069063
R30944 n_35_25_6 n_35_25_7 1.6257730879021088
R30945 n_35_25_7 n_35_26_7 1189.0314054975574
R30946 n_35_25_7 n_35_25_8 1.1979380647699727
R30947 n_35_25_8 n_35_26_8 1189.0314054975574
R30948 n_35_25_8 n_35_25_9 1.1979380647699727
R30949 n_35_25_9 n_35_26_9 1189.0314054975574
R30950 n_35_25_9 n_35_25_10 1.1979380647699727
R30951 n_35_25_10 n_35_26_10 1189.0314054975574
R30952 n_35_25_10 n_35_25_11 1.1979380647699651
R30953 n_35_25_11 n_35_26_11 1189.0314054975725
R30954 n_35_25_11 n_35_25_12 1.1979380647699611
R30955 n_35_25_12 n_35_26_12 1189.0314054975652
R30956 n_35_25_12 n_35_25_13 1.1979380647699727
R30957 n_35_25_13 n_35_26_13 1189.0314054975502
R30958 n_35_25_13 n_35_25_14 5.989690323849878
R30959 n_35_25_14 n_35_26_14 132.11460061083946
R30960 n_35_25_14 n_35_25_15 185.08143100696296
R30961 n_35_25_15 n_35_26_15 43696.90415203471
R30962 n_35_26_0 n_35_27_0 624.2414878862173
R30963 n_35_26_0 n_35_26_1 148.24483551528397
R30964 n_35_26_1 n_35_27_1 873.9380830407042
R30965 n_35_26_1 n_35_26_2 336.9200807165545
R30966 n_35_26_2 n_35_27_2 1560.603719715543
R30967 n_35_26_2 n_35_26_3 315.357195550695
R30968 n_35_26_3 n_35_27_3 21848.452076017587
R30969 n_35_26_3 n_35_26_4 4.192783226694903
R30970 n_35_26_4 n_35_27_4 662.0743053338662
R30971 n_35_26_4 n_35_26_5 3.4654636873702773
R30972 n_35_26_5 n_35_27_5 4161.609919241445
R30973 n_35_26_5 n_35_26_6 1.1979380647699724
R30974 n_35_26_6 n_35_27_6 693.6016532069075
R30975 n_35_26_6 n_35_26_7 1.6257730879021035
R30976 n_35_26_7 n_35_27_7 1189.0314054975593
R30977 n_35_26_7 n_35_26_8 1.1979380647699687
R30978 n_35_26_8 n_35_27_8 1189.0314054975593
R30979 n_35_26_8 n_35_26_9 1.1979380647699687
R30980 n_35_26_9 n_35_27_9 1189.0314054975593
R30981 n_35_26_9 n_35_26_10 1.1979380647699687
R30982 n_35_26_10 n_35_27_10 1189.0314054975593
R30983 n_35_26_10 n_35_26_11 1.1979380647699611
R30984 n_35_26_11 n_35_27_11 1189.0314054975743
R30985 n_35_26_11 n_35_26_12 1.1979380647699571
R30986 n_35_26_12 n_35_27_12 1189.031405497567
R30987 n_35_26_12 n_35_26_13 1.1979380647699687
R30988 n_35_26_13 n_35_27_13 1189.031405497552
R30989 n_35_26_13 n_35_26_14 5.9896903238498584
R30990 n_35_26_14 n_35_27_14 132.11460061083966
R30991 n_35_26_14 n_35_26_15 185.08143100696236
R30992 n_35_26_15 n_35_27_15 43696.90415203478
R30993 n_35_27_0 n_35_27_1 148.24483551528397
R30994 n_35_27_1 n_35_27_2 336.9200807165545
R30995 n_35_27_2 n_35_27_3 315.357195550695
R30996 n_35_27_3 n_35_27_4 4.192783226694903
R30997 n_35_27_4 n_35_27_5 3.4654636873702773
R30998 n_35_27_5 n_35_27_6 1.1979380647699724
R30999 n_35_27_6 n_35_27_7 1.6257730879021035
R31000 n_35_27_7 n_35_27_8 1.1979380647699687
R31001 n_35_27_8 n_35_27_9 1.1979380647699687
R31002 n_35_27_9 n_35_27_10 1.1979380647699687
R31003 n_35_27_10 n_35_27_11 1.1979380647699611
R31004 n_35_27_11 n_35_27_12 1.1979380647699571
R31005 n_35_27_12 n_35_27_13 1.1979380647699687
R31006 n_35_27_13 n_35_27_14 5.9896903238498584
R31007 n_35_27_14 n_35_27_15 185.08143100696236
R31008 n_0_0_15 amb 513.4019835444593
R31009 n_0_1_15 amb 513.4019835444593
R31010 n_0_2_15 amb 513.4019835444593
R31011 n_0_3_15 amb 513.4019835444593
R31012 n_0_4_15 amb 11322.330959723704
R31013 n_0_5_15 amb 11322.330959723502
R31014 n_0_6_15 amb 11322.330959723502
R31015 n_0_7_15 amb 11322.330959723704
R31016 n_0_8_15 amb 197.0866123321347
R31017 n_0_9_15 amb 197.08661233213454
R31018 n_0_10_15 amb 197.0866123321347
R31019 n_0_11_15 amb 197.0866123321347
R31020 n_0_12_15 amb 11322.311525334302
R31021 n_0_13_15 amb 11322.311525334302
R31022 n_0_14_15 amb 11322.311525334302
R31023 n_0_15_15 amb 11322.311525334302
R31024 n_0_16_15 amb 197.08661233213482
R31025 n_0_17_15 amb 197.08661233213454
R31026 n_0_18_15 amb 197.08661233213454
R31027 n_0_19_15 amb 197.08661233213482
R31028 n_0_20_15 amb 11322.309455857716
R31029 n_0_21_15 amb 11322.309455857716
R31030 n_0_22_15 amb 11322.30945585852
R31031 n_0_23_15 amb 11322.309455857716
R31032 n_0_24_15 amb 513.4020277585593
R31033 n_0_25_15 amb 513.402027758561
R31034 n_0_26_15 amb 513.4020277585593
R31035 n_0_27_15 amb 513.4020277585593
R31036 n_1_0_15 amb 513.4019835444593
R31037 n_1_1_15 amb 513.4019835444593
R31038 n_1_2_15 amb 513.4019835444593
R31039 n_1_3_15 amb 513.4019835444593
R31040 n_1_4_15 amb 11322.330959723704
R31041 n_1_5_15 amb 11322.330959723502
R31042 n_1_6_15 amb 11322.330959723502
R31043 n_1_7_15 amb 11322.330959723704
R31044 n_1_8_15 amb 197.0866123321347
R31045 n_1_9_15 amb 197.08661233213454
R31046 n_1_10_15 amb 197.0866123321347
R31047 n_1_11_15 amb 197.0866123321347
R31048 n_1_12_15 amb 11322.311525334302
R31049 n_1_13_15 amb 11322.311525334302
R31050 n_1_14_15 amb 11322.311525334302
R31051 n_1_15_15 amb 11322.311525334302
R31052 n_1_16_15 amb 197.08661233213482
R31053 n_1_17_15 amb 197.08661233213454
R31054 n_1_18_15 amb 197.08661233213454
R31055 n_1_19_15 amb 197.08661233213482
R31056 n_1_20_15 amb 11322.309455857716
R31057 n_1_21_15 amb 11322.309455857716
R31058 n_1_22_15 amb 11322.30945585852
R31059 n_1_23_15 amb 11322.309455857716
R31060 n_1_24_15 amb 513.4020277585593
R31061 n_1_25_15 amb 513.402027758561
R31062 n_1_26_15 amb 513.4020277585593
R31063 n_1_27_15 amb 513.4020277585593
R31064 n_2_0_15 amb 513.4019835444594
R31065 n_2_1_15 amb 513.4019835444594
R31066 n_2_2_15 amb 513.4019835444594
R31067 n_2_3_15 amb 513.4019835444594
R31068 n_2_4_15 amb 11322.330959723708
R31069 n_2_5_15 amb 11322.330959723506
R31070 n_2_6_15 amb 11322.330959723506
R31071 n_2_7_15 amb 11322.330959723708
R31072 n_2_8_15 amb 197.0866123321347
R31073 n_2_9_15 amb 197.08661233213456
R31074 n_2_10_15 amb 197.0866123321347
R31075 n_2_11_15 amb 197.0866123321347
R31076 n_2_12_15 amb 11322.311525334306
R31077 n_2_13_15 amb 11322.311525334306
R31078 n_2_14_15 amb 11322.311525334306
R31079 n_2_15_15 amb 11322.311525334306
R31080 n_2_16_15 amb 197.08661233213485
R31081 n_2_17_15 amb 197.08661233213456
R31082 n_2_18_15 amb 197.08661233213456
R31083 n_2_19_15 amb 197.08661233213485
R31084 n_2_20_15 amb 11322.309455857718
R31085 n_2_21_15 amb 11322.309455857718
R31086 n_2_22_15 amb 11322.309455858522
R31087 n_2_23_15 amb 11322.309455857718
R31088 n_2_24_15 amb 513.4020277585594
R31089 n_2_25_15 amb 513.4020277585611
R31090 n_2_26_15 amb 513.4020277585594
R31091 n_2_27_15 amb 513.4020277585594
R31092 n_3_0_15 amb 513.4019835444592
R31093 n_3_1_15 amb 513.4019835444592
R31094 n_3_2_15 amb 513.4019835444592
R31095 n_3_3_15 amb 513.4019835444592
R31096 n_3_4_15 amb 11322.330959723702
R31097 n_3_5_15 amb 11322.3309597235
R31098 n_3_6_15 amb 11322.3309597235
R31099 n_3_7_15 amb 11322.330959723702
R31100 n_3_8_15 amb 197.08661233213462
R31101 n_3_9_15 amb 197.0866123321345
R31102 n_3_10_15 amb 197.08661233213462
R31103 n_3_11_15 amb 197.08661233213462
R31104 n_3_12_15 amb 11322.3115253343
R31105 n_3_13_15 amb 11322.3115253343
R31106 n_3_14_15 amb 11322.3115253343
R31107 n_3_15_15 amb 11322.3115253343
R31108 n_3_16_15 amb 197.08661233213473
R31109 n_3_17_15 amb 197.0866123321345
R31110 n_3_18_15 amb 197.0866123321345
R31111 n_3_19_15 amb 197.08661233213473
R31112 n_3_20_15 amb 11322.309455857712
R31113 n_3_21_15 amb 11322.309455857712
R31114 n_3_22_15 amb 11322.309455858518
R31115 n_3_23_15 amb 11322.309455857712
R31116 n_3_24_15 amb 513.4020277585593
R31117 n_3_25_15 amb 513.4020277585608
R31118 n_3_26_15 amb 513.4020277585593
R31119 n_3_27_15 amb 513.4020277585593
R31120 n_4_0_15 amb 2591.101318922608
R31121 n_4_1_15 amb 2591.101318922608
R31122 n_4_2_15 amb 2591.101318922608
R31123 n_4_3_15 amb 2591.101318922608
R31124 n_4_4_4 amb 57142.95546830085
R31125 n_4_4_15 amb 57142.95546830085
R31126 n_4_5_4 amb 57142.95546829983
R31127 n_4_5_15 amb 57142.95546829983
R31128 n_4_6_4 amb 57142.95546829983
R31129 n_4_6_15 amb 57142.95546829983
R31130 n_4_7_4 amb 57142.95546830085
R31131 n_4_7_15 amb 57142.95546830085
R31132 n_4_8_4 amb 994.6813559818668
R31133 n_4_8_15 amb 994.6813559818668
R31134 n_4_9_4 amb 994.6813559818661
R31135 n_4_9_15 amb 994.6813559818661
R31136 n_4_10_4 amb 994.6813559818668
R31137 n_4_10_15 amb 994.6813559818668
R31138 n_4_11_4 amb 994.6813559818668
R31139 n_4_11_15 amb 994.6813559818668
R31140 n_4_12_4 amb 57142.85738439462
R31141 n_4_12_15 amb 57142.85738439462
R31142 n_4_13_4 amb 57142.85738439462
R31143 n_4_13_15 amb 57142.85738439462
R31144 n_4_14_4 amb 57142.85738439462
R31145 n_4_14_15 amb 57142.85738439462
R31146 n_4_15_4 amb 57142.85738439462
R31147 n_4_15_15 amb 57142.85738439462
R31148 n_4_16_4 amb 994.6813559818673
R31149 n_4_16_15 amb 994.6813559818673
R31150 n_4_17_4 amb 994.6813559818661
R31151 n_4_17_15 amb 994.6813559818661
R31152 n_4_18_4 amb 994.6813559818661
R31153 n_4_18_15 amb 994.6813559818661
R31154 n_4_19_4 amb 994.6813559818673
R31155 n_4_19_15 amb 994.6813559818673
R31156 n_4_20_4 amb 57142.84693990145
R31157 n_4_20_15 amb 57142.84693990145
R31158 n_4_21_4 amb 57142.84693990145
R31159 n_4_21_15 amb 57142.84693990145
R31160 n_4_22_4 amb 57142.8469399055
R31161 n_4_22_15 amb 57142.8469399055
R31162 n_4_23_4 amb 57142.84693990145
R31163 n_4_23_15 amb 57142.84693990145
R31164 n_4_24_15 amb 2591.1015420678555
R31165 n_4_25_15 amb 2591.1015420678636
R31166 n_4_26_15 amb 2591.1015420678555
R31167 n_4_27_15 amb 2591.1015420678555
R31168 n_5_0_15 amb 2591.101318922608
R31169 n_5_1_15 amb 2591.101318922608
R31170 n_5_2_15 amb 2591.101318922608
R31171 n_5_3_15 amb 2591.101318922608
R31172 n_5_4_4 amb 57142.95546830085
R31173 n_5_4_15 amb 57142.95546830085
R31174 n_5_5_4 amb 57142.95546829983
R31175 n_5_5_15 amb 57142.95546829983
R31176 n_5_6_4 amb 57142.95546829983
R31177 n_5_6_15 amb 57142.95546829983
R31178 n_5_7_4 amb 57142.95546830085
R31179 n_5_7_15 amb 57142.95546830085
R31180 n_5_8_4 amb 994.6813559818668
R31181 n_5_8_15 amb 994.6813559818668
R31182 n_5_9_4 amb 994.6813559818661
R31183 n_5_9_15 amb 994.6813559818661
R31184 n_5_10_4 amb 994.6813559818668
R31185 n_5_10_15 amb 994.6813559818668
R31186 n_5_11_4 amb 994.6813559818668
R31187 n_5_11_15 amb 994.6813559818668
R31188 n_5_12_4 amb 57142.85738439462
R31189 n_5_12_15 amb 57142.85738439462
R31190 n_5_13_4 amb 57142.85738439462
R31191 n_5_13_15 amb 57142.85738439462
R31192 n_5_14_4 amb 57142.85738439462
R31193 n_5_14_15 amb 57142.85738439462
R31194 n_5_15_4 amb 57142.85738439462
R31195 n_5_15_15 amb 57142.85738439462
R31196 n_5_16_4 amb 994.6813559818673
R31197 n_5_16_15 amb 994.6813559818673
R31198 n_5_17_4 amb 994.6813559818661
R31199 n_5_17_15 amb 994.6813559818661
R31200 n_5_18_4 amb 994.6813559818661
R31201 n_5_18_15 amb 994.6813559818661
R31202 n_5_19_4 amb 994.6813559818673
R31203 n_5_19_15 amb 994.6813559818673
R31204 n_5_20_4 amb 57142.84693990145
R31205 n_5_20_15 amb 57142.84693990145
R31206 n_5_21_4 amb 57142.84693990145
R31207 n_5_21_15 amb 57142.84693990145
R31208 n_5_22_4 amb 57142.8469399055
R31209 n_5_22_15 amb 57142.8469399055
R31210 n_5_23_4 amb 57142.84693990145
R31211 n_5_23_15 amb 57142.84693990145
R31212 n_5_24_15 amb 2591.1015420678555
R31213 n_5_25_15 amb 2591.1015420678636
R31214 n_5_26_15 amb 2591.1015420678555
R31215 n_5_27_15 amb 2591.1015420678555
R31216 n_6_0_15 amb 2591.101318922608
R31217 n_6_1_15 amb 2591.101318922608
R31218 n_6_2_15 amb 2591.101318922608
R31219 n_6_3_15 amb 2591.101318922608
R31220 n_6_4_4 amb 57142.95546830085
R31221 n_6_4_15 amb 57142.95546830085
R31222 n_6_5_4 amb 57142.95546829983
R31223 n_6_5_15 amb 57142.95546829983
R31224 n_6_6_4 amb 57142.95546829983
R31225 n_6_6_15 amb 57142.95546829983
R31226 n_6_7_4 amb 57142.95546830085
R31227 n_6_7_15 amb 57142.95546830085
R31228 n_6_8_4 amb 994.6813559818668
R31229 n_6_8_15 amb 994.6813559818668
R31230 n_6_9_4 amb 994.6813559818661
R31231 n_6_9_15 amb 994.6813559818661
R31232 n_6_10_4 amb 994.6813559818668
R31233 n_6_10_15 amb 994.6813559818668
R31234 n_6_11_4 amb 994.6813559818668
R31235 n_6_11_15 amb 994.6813559818668
R31236 n_6_12_4 amb 57142.85738439462
R31237 n_6_12_15 amb 57142.85738439462
R31238 n_6_13_4 amb 57142.85738439462
R31239 n_6_13_15 amb 57142.85738439462
R31240 n_6_14_4 amb 57142.85738439462
R31241 n_6_14_15 amb 57142.85738439462
R31242 n_6_15_4 amb 57142.85738439462
R31243 n_6_15_15 amb 57142.85738439462
R31244 n_6_16_4 amb 994.6813559818673
R31245 n_6_16_15 amb 994.6813559818673
R31246 n_6_17_4 amb 994.6813559818661
R31247 n_6_17_15 amb 994.6813559818661
R31248 n_6_18_4 amb 994.6813559818661
R31249 n_6_18_15 amb 994.6813559818661
R31250 n_6_19_4 amb 994.6813559818673
R31251 n_6_19_15 amb 994.6813559818673
R31252 n_6_20_4 amb 57142.84693990145
R31253 n_6_20_15 amb 57142.84693990145
R31254 n_6_21_4 amb 57142.84693990145
R31255 n_6_21_15 amb 57142.84693990145
R31256 n_6_22_4 amb 57142.8469399055
R31257 n_6_22_15 amb 57142.8469399055
R31258 n_6_23_4 amb 57142.84693990145
R31259 n_6_23_15 amb 57142.84693990145
R31260 n_6_24_15 amb 2591.1015420678555
R31261 n_6_25_15 amb 2591.1015420678636
R31262 n_6_26_15 amb 2591.1015420678555
R31263 n_6_27_15 amb 2591.1015420678555
R31264 n_7_0_15 amb 2591.101318922608
R31265 n_7_1_15 amb 2591.101318922608
R31266 n_7_2_15 amb 2591.101318922608
R31267 n_7_3_15 amb 2591.101318922608
R31268 n_7_4_4 amb 57142.95546830085
R31269 n_7_4_15 amb 57142.95546830085
R31270 n_7_5_4 amb 57142.95546829983
R31271 n_7_5_15 amb 57142.95546829983
R31272 n_7_6_4 amb 57142.95546829983
R31273 n_7_6_15 amb 57142.95546829983
R31274 n_7_7_4 amb 57142.95546830085
R31275 n_7_7_15 amb 57142.95546830085
R31276 n_7_8_4 amb 994.6813559818668
R31277 n_7_8_15 amb 994.6813559818668
R31278 n_7_9_4 amb 994.6813559818661
R31279 n_7_9_15 amb 994.6813559818661
R31280 n_7_10_4 amb 994.6813559818668
R31281 n_7_10_15 amb 994.6813559818668
R31282 n_7_11_4 amb 994.6813559818668
R31283 n_7_11_15 amb 994.6813559818668
R31284 n_7_12_4 amb 57142.85738439462
R31285 n_7_12_15 amb 57142.85738439462
R31286 n_7_13_4 amb 57142.85738439462
R31287 n_7_13_15 amb 57142.85738439462
R31288 n_7_14_4 amb 57142.85738439462
R31289 n_7_14_15 amb 57142.85738439462
R31290 n_7_15_4 amb 57142.85738439462
R31291 n_7_15_15 amb 57142.85738439462
R31292 n_7_16_4 amb 994.6813559818673
R31293 n_7_16_15 amb 994.6813559818673
R31294 n_7_17_4 amb 994.6813559818661
R31295 n_7_17_15 amb 994.6813559818661
R31296 n_7_18_4 amb 994.6813559818661
R31297 n_7_18_15 amb 994.6813559818661
R31298 n_7_19_4 amb 994.6813559818673
R31299 n_7_19_15 amb 994.6813559818673
R31300 n_7_20_4 amb 57142.84693990145
R31301 n_7_20_15 amb 57142.84693990145
R31302 n_7_21_4 amb 57142.84693990145
R31303 n_7_21_15 amb 57142.84693990145
R31304 n_7_22_4 amb 57142.8469399055
R31305 n_7_22_15 amb 57142.8469399055
R31306 n_7_23_4 amb 57142.84693990145
R31307 n_7_23_15 amb 57142.84693990145
R31308 n_7_24_15 amb 2591.1015420678555
R31309 n_7_25_15 amb 2591.1015420678636
R31310 n_7_26_15 amb 2591.1015420678555
R31311 n_7_27_15 amb 2591.1015420678555
R31312 n_8_0_15 amb 68.54574962018488
R31313 n_8_1_15 amb 68.54574962018488
R31314 n_8_2_15 amb 68.54574962018488
R31315 n_8_3_15 amb 68.54574962018488
R31316 n_8_4_4 amb 1511.6764016453794
R31317 n_8_4_15 amb 1511.6764016453794
R31318 n_8_5_4 amb 1511.6764016453526
R31319 n_8_5_15 amb 1511.6764016453526
R31320 n_8_6_4 amb 1511.6764016453526
R31321 n_8_6_15 amb 1511.6764016453526
R31322 n_8_7_4 amb 1511.6764016453794
R31323 n_8_7_15 amb 1511.6764016453794
R31324 n_8_8_15 amb 26.3135905497316
R31325 n_8_9_15 amb 26.313590549731586
R31326 n_8_10_15 amb 26.3135905497316
R31327 n_8_11_15 amb 26.3135905497316
R31328 n_8_12_4 amb 1511.6738069051319
R31329 n_8_12_15 amb 1511.6738069051319
R31330 n_8_13_4 amb 1511.6738069051319
R31331 n_8_13_15 amb 1511.6738069051319
R31332 n_8_14_4 amb 1511.6738069051319
R31333 n_8_14_15 amb 1511.6738069051319
R31334 n_8_15_4 amb 1511.6738069051319
R31335 n_8_15_15 amb 1511.6738069051319
R31336 n_8_16_15 amb 26.313590549731618
R31337 n_8_17_15 amb 26.313590549731586
R31338 n_8_18_15 amb 26.313590549731586
R31339 n_8_19_15 amb 26.313590549731618
R31340 n_8_20_4 amb 1511.6735306034648
R31341 n_8_20_15 amb 1511.6735306034648
R31342 n_8_21_4 amb 1511.6735306034648
R31343 n_8_21_15 amb 1511.6735306034648
R31344 n_8_22_4 amb 1511.673530603572
R31345 n_8_22_15 amb 1511.673530603572
R31346 n_8_23_4 amb 1511.6735306034648
R31347 n_8_23_15 amb 1511.6735306034648
R31348 n_8_24_15 amb 68.54575552333431
R31349 n_8_25_15 amb 68.54575552333453
R31350 n_8_26_15 amb 68.54575552333431
R31351 n_8_27_15 amb 68.54575552333431
R31352 n_9_0_15 amb 68.54574962018488
R31353 n_9_1_15 amb 68.54574962018488
R31354 n_9_2_15 amb 68.54574962018488
R31355 n_9_3_15 amb 68.54574962018488
R31356 n_9_4_4 amb 1511.6764016453797
R31357 n_9_4_15 amb 1511.6764016453797
R31358 n_9_5_4 amb 1511.6764016453528
R31359 n_9_5_15 amb 1511.6764016453528
R31360 n_9_6_4 amb 1511.6764016453528
R31361 n_9_6_15 amb 1511.6764016453528
R31362 n_9_7_4 amb 1511.6764016453797
R31363 n_9_7_15 amb 1511.6764016453797
R31364 n_9_8_15 amb 26.313590549731607
R31365 n_9_9_15 amb 26.313590549731586
R31366 n_9_10_15 amb 26.313590549731607
R31367 n_9_11_15 amb 26.313590549731607
R31368 n_9_12_4 amb 1511.673806905132
R31369 n_9_12_15 amb 1511.673806905132
R31370 n_9_13_4 amb 1511.673806905132
R31371 n_9_13_15 amb 1511.673806905132
R31372 n_9_14_4 amb 1511.673806905132
R31373 n_9_14_15 amb 1511.673806905132
R31374 n_9_15_4 amb 1511.673806905132
R31375 n_9_15_15 amb 1511.673806905132
R31376 n_9_16_15 amb 26.313590549731625
R31377 n_9_17_15 amb 26.313590549731586
R31378 n_9_18_15 amb 26.313590549731586
R31379 n_9_19_15 amb 26.313590549731625
R31380 n_9_20_4 amb 1511.6735306034648
R31381 n_9_20_15 amb 1511.6735306034648
R31382 n_9_21_4 amb 1511.6735306034648
R31383 n_9_21_15 amb 1511.6735306034648
R31384 n_9_22_4 amb 1511.6735306035723
R31385 n_9_22_15 amb 1511.6735306035723
R31386 n_9_23_4 amb 1511.6735306034648
R31387 n_9_23_15 amb 1511.6735306034648
R31388 n_9_24_15 amb 68.54575552333431
R31389 n_9_25_15 amb 68.54575552333453
R31390 n_9_26_15 amb 68.54575552333431
R31391 n_9_27_15 amb 68.54575552333431
R31392 n_10_0_15 amb 68.54574962018485
R31393 n_10_1_15 amb 68.54574962018485
R31394 n_10_2_15 amb 68.54574962018485
R31395 n_10_3_15 amb 68.54574962018485
R31396 n_10_4_4 amb 1511.6764016453787
R31397 n_10_4_15 amb 1511.6764016453787
R31398 n_10_5_4 amb 1511.676401645352
R31399 n_10_5_15 amb 1511.676401645352
R31400 n_10_6_4 amb 1511.676401645352
R31401 n_10_6_15 amb 1511.676401645352
R31402 n_10_7_4 amb 1511.6764016453787
R31403 n_10_7_15 amb 1511.6764016453787
R31404 n_10_8_15 amb 26.313590549731593
R31405 n_10_9_15 amb 26.31359054973158
R31406 n_10_10_15 amb 26.313590549731593
R31407 n_10_11_15 amb 26.313590549731593
R31408 n_10_12_4 amb 1511.6738069051314
R31409 n_10_12_15 amb 1511.6738069051314
R31410 n_10_13_4 amb 1511.6738069051314
R31411 n_10_13_15 amb 1511.6738069051314
R31412 n_10_14_4 amb 1511.6738069051314
R31413 n_10_14_15 amb 1511.6738069051314
R31414 n_10_15_4 amb 1511.6738069051314
R31415 n_10_15_15 amb 1511.6738069051314
R31416 n_10_16_15 amb 26.313590549731607
R31417 n_10_17_15 amb 26.31359054973158
R31418 n_10_18_15 amb 26.31359054973158
R31419 n_10_19_15 amb 26.313590549731607
R31420 n_10_20_4 amb 1511.673530603464
R31421 n_10_20_15 amb 1511.673530603464
R31422 n_10_21_4 amb 1511.673530603464
R31423 n_10_21_15 amb 1511.673530603464
R31424 n_10_22_4 amb 1511.6735306035716
R31425 n_10_22_15 amb 1511.6735306035716
R31426 n_10_23_4 amb 1511.673530603464
R31427 n_10_23_15 amb 1511.673530603464
R31428 n_10_24_15 amb 68.54575552333428
R31429 n_10_25_15 amb 68.54575552333449
R31430 n_10_26_15 amb 68.54575552333428
R31431 n_10_27_15 amb 68.54575552333428
R31432 n_11_0_15 amb 68.54574962018488
R31433 n_11_1_15 amb 68.54574962018488
R31434 n_11_2_15 amb 68.54574962018488
R31435 n_11_3_15 amb 68.54574962018488
R31436 n_11_4_4 amb 1511.6764016453797
R31437 n_11_4_15 amb 1511.6764016453797
R31438 n_11_5_4 amb 1511.6764016453528
R31439 n_11_5_15 amb 1511.6764016453528
R31440 n_11_6_4 amb 1511.6764016453528
R31441 n_11_6_15 amb 1511.6764016453528
R31442 n_11_7_4 amb 1511.6764016453797
R31443 n_11_7_15 amb 1511.6764016453797
R31444 n_11_8_15 amb 26.313590549731607
R31445 n_11_9_15 amb 26.313590549731586
R31446 n_11_10_15 amb 26.313590549731607
R31447 n_11_11_15 amb 26.313590549731607
R31448 n_11_12_4 amb 1511.673806905132
R31449 n_11_12_15 amb 1511.673806905132
R31450 n_11_13_4 amb 1511.673806905132
R31451 n_11_13_15 amb 1511.673806905132
R31452 n_11_14_4 amb 1511.673806905132
R31453 n_11_14_15 amb 1511.673806905132
R31454 n_11_15_4 amb 1511.673806905132
R31455 n_11_15_15 amb 1511.673806905132
R31456 n_11_16_15 amb 26.313590549731625
R31457 n_11_17_15 amb 26.313590549731586
R31458 n_11_18_15 amb 26.313590549731586
R31459 n_11_19_15 amb 26.313590549731625
R31460 n_11_20_4 amb 1511.6735306034648
R31461 n_11_20_15 amb 1511.6735306034648
R31462 n_11_21_4 amb 1511.6735306034648
R31463 n_11_21_15 amb 1511.6735306034648
R31464 n_11_22_4 amb 1511.6735306035723
R31465 n_11_22_15 amb 1511.6735306035723
R31466 n_11_23_4 amb 1511.6735306034648
R31467 n_11_23_15 amb 1511.6735306034648
R31468 n_11_24_15 amb 68.54575552333431
R31469 n_11_25_15 amb 68.54575552333453
R31470 n_11_26_15 amb 68.54575552333431
R31471 n_11_27_15 amb 68.54575552333431
R31472 n_12_0_15 amb 2591.101307970193
R31473 n_12_1_15 amb 2591.101307970193
R31474 n_12_2_15 amb 2591.101307970193
R31475 n_12_3_15 amb 2591.101307970193
R31476 n_12_4_4 amb 57142.95522676133
R31477 n_12_4_15 amb 57142.95522676133
R31478 n_12_5_4 amb 57142.95522676032
R31479 n_12_5_15 amb 57142.95522676032
R31480 n_12_6_4 amb 57142.95522676032
R31481 n_12_6_15 amb 57142.95522676032
R31482 n_12_7_4 amb 57142.95522676133
R31483 n_12_7_15 amb 57142.95522676133
R31484 n_12_8_4 amb 994.6813517774141
R31485 n_12_8_15 amb 994.6813517774141
R31486 n_12_9_4 amb 994.6813517774134
R31487 n_12_9_15 amb 994.6813517774134
R31488 n_12_10_4 amb 994.6813517774141
R31489 n_12_10_15 amb 994.6813517774141
R31490 n_12_11_4 amb 994.6813517774141
R31491 n_12_11_15 amb 994.6813517774141
R31492 n_12_12_4 amb 57142.85714285551
R31493 n_12_12_15 amb 57142.85714285551
R31494 n_12_13_4 amb 57142.85714285551
R31495 n_12_13_15 amb 57142.85714285551
R31496 n_12_14_4 amb 57142.85714285551
R31497 n_12_14_15 amb 57142.85714285551
R31498 n_12_15_4 amb 57142.85714285551
R31499 n_12_15_15 amb 57142.85714285551
R31500 n_12_16_4 amb 994.6813517774146
R31501 n_12_16_15 amb 994.6813517774146
R31502 n_12_17_4 amb 994.6813517774134
R31503 n_12_17_15 amb 994.6813517774134
R31504 n_12_18_4 amb 994.6813517774134
R31505 n_12_18_15 amb 994.6813517774134
R31506 n_12_19_4 amb 994.6813517774146
R31507 n_12_19_15 amb 994.6813517774146
R31508 n_12_20_4 amb 57142.84669836238
R31509 n_12_20_15 amb 57142.84669836238
R31510 n_12_21_4 amb 57142.84669836238
R31511 n_12_21_15 amb 57142.84669836238
R31512 n_12_22_4 amb 57142.84669836644
R31513 n_12_22_15 amb 57142.84669836644
R31514 n_12_23_4 amb 57142.84669836238
R31515 n_12_23_15 amb 57142.84669836238
R31516 n_12_24_15 amb 2591.1015311154392
R31517 n_12_25_15 amb 2591.1015311154474
R31518 n_12_26_15 amb 2591.1015311154392
R31519 n_12_27_15 amb 2591.1015311154392
R31520 n_13_0_15 amb 2591.101307970285
R31521 n_13_1_15 amb 2591.101307970285
R31522 n_13_2_15 amb 2591.101307970285
R31523 n_13_3_15 amb 2591.101307970285
R31524 n_13_4_4 amb 57142.95522676336
R31525 n_13_4_15 amb 57142.95522676336
R31526 n_13_5_4 amb 57142.955226762344
R31527 n_13_5_15 amb 57142.955226762344
R31528 n_13_6_4 amb 57142.955226762344
R31529 n_13_6_15 amb 57142.955226762344
R31530 n_13_7_4 amb 57142.95522676336
R31531 n_13_7_15 amb 57142.95522676336
R31532 n_13_8_4 amb 994.6813517774494
R31533 n_13_8_15 amb 994.6813517774494
R31534 n_13_9_4 amb 994.6813517774488
R31535 n_13_9_15 amb 994.6813517774488
R31536 n_13_10_4 amb 994.6813517774494
R31537 n_13_10_15 amb 994.6813517774494
R31538 n_13_11_4 amb 994.6813517774494
R31539 n_13_11_15 amb 994.6813517774494
R31540 n_13_12_4 amb 57142.857142857545
R31541 n_13_12_15 amb 57142.857142857545
R31542 n_13_13_4 amb 57142.857142857545
R31543 n_13_13_15 amb 57142.857142857545
R31544 n_13_14_4 amb 57142.857142857545
R31545 n_13_14_15 amb 57142.857142857545
R31546 n_13_15_4 amb 57142.857142857545
R31547 n_13_15_15 amb 57142.857142857545
R31548 n_13_16_4 amb 994.6813517774499
R31549 n_13_16_15 amb 994.6813517774499
R31550 n_13_17_4 amb 994.6813517774488
R31551 n_13_17_15 amb 994.6813517774488
R31552 n_13_18_4 amb 994.6813517774488
R31553 n_13_18_15 amb 994.6813517774488
R31554 n_13_19_4 amb 994.6813517774499
R31555 n_13_19_15 amb 994.6813517774499
R31556 n_13_20_4 amb 57142.8466983644
R31557 n_13_20_15 amb 57142.8466983644
R31558 n_13_21_4 amb 57142.8466983644
R31559 n_13_21_15 amb 57142.8466983644
R31560 n_13_22_4 amb 57142.84669836848
R31561 n_13_22_15 amb 57142.84669836848
R31562 n_13_23_4 amb 57142.8466983644
R31563 n_13_23_15 amb 57142.8466983644
R31564 n_13_24_15 amb 2591.101531115531
R31565 n_13_25_15 amb 2591.1015311155393
R31566 n_13_26_15 amb 2591.101531115531
R31567 n_13_27_15 amb 2591.101531115531
R31568 n_14_0_15 amb 2591.101307970285
R31569 n_14_1_15 amb 2591.101307970285
R31570 n_14_2_15 amb 2591.101307970285
R31571 n_14_3_15 amb 2591.101307970285
R31572 n_14_4_4 amb 57142.95522676336
R31573 n_14_4_15 amb 57142.95522676336
R31574 n_14_5_4 amb 57142.955226762344
R31575 n_14_5_15 amb 57142.955226762344
R31576 n_14_6_4 amb 57142.955226762344
R31577 n_14_6_15 amb 57142.955226762344
R31578 n_14_7_4 amb 57142.95522676336
R31579 n_14_7_15 amb 57142.95522676336
R31580 n_14_8_4 amb 994.6813517774494
R31581 n_14_8_15 amb 994.6813517774494
R31582 n_14_9_4 amb 994.6813517774488
R31583 n_14_9_15 amb 994.6813517774488
R31584 n_14_10_4 amb 994.6813517774494
R31585 n_14_10_15 amb 994.6813517774494
R31586 n_14_11_4 amb 994.6813517774494
R31587 n_14_11_15 amb 994.6813517774494
R31588 n_14_12_4 amb 57142.857142857545
R31589 n_14_12_15 amb 57142.857142857545
R31590 n_14_13_4 amb 57142.857142857545
R31591 n_14_13_15 amb 57142.857142857545
R31592 n_14_14_4 amb 57142.857142857545
R31593 n_14_14_15 amb 57142.857142857545
R31594 n_14_15_4 amb 57142.857142857545
R31595 n_14_15_15 amb 57142.857142857545
R31596 n_14_16_4 amb 994.6813517774499
R31597 n_14_16_15 amb 994.6813517774499
R31598 n_14_17_4 amb 994.6813517774488
R31599 n_14_17_15 amb 994.6813517774488
R31600 n_14_18_4 amb 994.6813517774488
R31601 n_14_18_15 amb 994.6813517774488
R31602 n_14_19_4 amb 994.6813517774499
R31603 n_14_19_15 amb 994.6813517774499
R31604 n_14_20_4 amb 57142.8466983644
R31605 n_14_20_15 amb 57142.8466983644
R31606 n_14_21_4 amb 57142.8466983644
R31607 n_14_21_15 amb 57142.8466983644
R31608 n_14_22_4 amb 57142.84669836848
R31609 n_14_22_15 amb 57142.84669836848
R31610 n_14_23_4 amb 57142.8466983644
R31611 n_14_23_15 amb 57142.8466983644
R31612 n_14_24_15 amb 2591.101531115531
R31613 n_14_25_15 amb 2591.1015311155393
R31614 n_14_26_15 amb 2591.101531115531
R31615 n_14_27_15 amb 2591.101531115531
R31616 n_15_0_15 amb 2591.101307970193
R31617 n_15_1_15 amb 2591.101307970193
R31618 n_15_2_15 amb 2591.101307970193
R31619 n_15_3_15 amb 2591.101307970193
R31620 n_15_4_4 amb 57142.95522676133
R31621 n_15_4_15 amb 57142.95522676133
R31622 n_15_5_4 amb 57142.95522676032
R31623 n_15_5_15 amb 57142.95522676032
R31624 n_15_6_4 amb 57142.95522676032
R31625 n_15_6_15 amb 57142.95522676032
R31626 n_15_7_4 amb 57142.95522676133
R31627 n_15_7_15 amb 57142.95522676133
R31628 n_15_8_4 amb 994.6813517774141
R31629 n_15_8_15 amb 994.6813517774141
R31630 n_15_9_4 amb 994.6813517774134
R31631 n_15_9_15 amb 994.6813517774134
R31632 n_15_10_4 amb 994.6813517774141
R31633 n_15_10_15 amb 994.6813517774141
R31634 n_15_11_4 amb 994.6813517774141
R31635 n_15_11_15 amb 994.6813517774141
R31636 n_15_12_4 amb 57142.85714285551
R31637 n_15_12_15 amb 57142.85714285551
R31638 n_15_13_4 amb 57142.85714285551
R31639 n_15_13_15 amb 57142.85714285551
R31640 n_15_14_4 amb 57142.85714285551
R31641 n_15_14_15 amb 57142.85714285551
R31642 n_15_15_4 amb 57142.85714285551
R31643 n_15_15_15 amb 57142.85714285551
R31644 n_15_16_4 amb 994.6813517774146
R31645 n_15_16_15 amb 994.6813517774146
R31646 n_15_17_4 amb 994.6813517774134
R31647 n_15_17_15 amb 994.6813517774134
R31648 n_15_18_4 amb 994.6813517774134
R31649 n_15_18_15 amb 994.6813517774134
R31650 n_15_19_4 amb 994.6813517774146
R31651 n_15_19_15 amb 994.6813517774146
R31652 n_15_20_4 amb 57142.84669836238
R31653 n_15_20_15 amb 57142.84669836238
R31654 n_15_21_4 amb 57142.84669836238
R31655 n_15_21_15 amb 57142.84669836238
R31656 n_15_22_4 amb 57142.84669836644
R31657 n_15_22_15 amb 57142.84669836644
R31658 n_15_23_4 amb 57142.84669836238
R31659 n_15_23_15 amb 57142.84669836238
R31660 n_15_24_15 amb 2591.1015311154392
R31661 n_15_25_15 amb 2591.1015311154474
R31662 n_15_26_15 amb 2591.1015311154392
R31663 n_15_27_15 amb 2591.1015311154392
R31664 n_16_0_15 amb 68.54574962784964
R31665 n_16_1_15 amb 68.54574962784964
R31666 n_16_2_15 amb 68.54574962784964
R31667 n_16_3_15 amb 68.54574962784964
R31668 n_16_4_4 amb 1511.6764018144145
R31669 n_16_4_15 amb 1511.6764018144145
R31670 n_16_5_4 amb 1511.6764018143876
R31671 n_16_5_15 amb 1511.6764018143876
R31672 n_16_6_4 amb 1511.6764018143876
R31673 n_16_6_15 amb 1511.6764018143876
R31674 n_16_7_4 amb 1511.6764018144145
R31675 n_16_7_15 amb 1511.6764018144145
R31676 n_16_8_15 amb 26.31359055267398
R31677 n_16_9_15 amb 26.31359055267396
R31678 n_16_10_15 amb 26.31359055267398
R31679 n_16_11_15 amb 26.31359055267398
R31680 n_16_12_4 amb 1511.6738070741667
R31681 n_16_12_15 amb 1511.6738070741667
R31682 n_16_13_4 amb 1511.6738070741667
R31683 n_16_13_15 amb 1511.6738070741667
R31684 n_16_14_4 amb 1511.6738070741667
R31685 n_16_14_15 amb 1511.6738070741667
R31686 n_16_15_4 amb 1511.6738070741667
R31687 n_16_15_15 amb 1511.6738070741667
R31688 n_16_16_15 amb 26.313590552673993
R31689 n_16_17_15 amb 26.31359055267396
R31690 n_16_18_15 amb 26.31359055267396
R31691 n_16_19_15 amb 26.313590552673993
R31692 n_16_20_4 amb 1511.6735307724994
R31693 n_16_20_15 amb 1511.6735307724994
R31694 n_16_21_4 amb 1511.6735307724994
R31695 n_16_21_15 amb 1511.6735307724994
R31696 n_16_22_4 amb 1511.673530772607
R31697 n_16_22_15 amb 1511.673530772607
R31698 n_16_23_4 amb 1511.6735307724994
R31699 n_16_23_15 amb 1511.6735307724994
R31700 n_16_24_15 amb 68.54575553099906
R31701 n_16_25_15 amb 68.54575553099929
R31702 n_16_26_15 amb 68.54575553099906
R31703 n_16_27_15 amb 68.54575553099906
R31704 n_17_0_15 amb 68.5457496278497
R31705 n_17_1_15 amb 68.5457496278497
R31706 n_17_2_15 amb 68.5457496278497
R31707 n_17_3_15 amb 68.5457496278497
R31708 n_17_4_4 amb 1511.6764018144156
R31709 n_17_4_15 amb 1511.6764018144156
R31710 n_17_5_4 amb 1511.6764018143892
R31711 n_17_5_15 amb 1511.6764018143892
R31712 n_17_6_4 amb 1511.6764018143892
R31713 n_17_6_15 amb 1511.6764018143892
R31714 n_17_7_4 amb 1511.6764018144156
R31715 n_17_7_15 amb 1511.6764018144156
R31716 n_17_8_15 amb 26.313590552674004
R31717 n_17_9_15 amb 26.313590552673983
R31718 n_17_10_15 amb 26.313590552674004
R31719 n_17_11_15 amb 26.313590552674004
R31720 n_17_12_4 amb 1511.6738070741683
R31721 n_17_12_15 amb 1511.6738070741683
R31722 n_17_13_4 amb 1511.6738070741683
R31723 n_17_13_15 amb 1511.6738070741683
R31724 n_17_14_4 amb 1511.6738070741683
R31725 n_17_14_15 amb 1511.6738070741683
R31726 n_17_15_4 amb 1511.6738070741683
R31727 n_17_15_15 amb 1511.6738070741683
R31728 n_17_16_15 amb 26.31359055267402
R31729 n_17_17_15 amb 26.313590552673983
R31730 n_17_18_15 amb 26.313590552673983
R31731 n_17_19_15 amb 26.31359055267402
R31732 n_17_20_4 amb 1511.6735307725005
R31733 n_17_20_15 amb 1511.6735307725005
R31734 n_17_21_4 amb 1511.6735307725005
R31735 n_17_21_15 amb 1511.6735307725005
R31736 n_17_22_4 amb 1511.6735307726083
R31737 n_17_22_15 amb 1511.6735307726083
R31738 n_17_23_4 amb 1511.6735307725005
R31739 n_17_23_15 amb 1511.6735307725005
R31740 n_17_24_15 amb 68.54575553099912
R31741 n_17_25_15 amb 68.54575553099934
R31742 n_17_26_15 amb 68.54575553099912
R31743 n_17_27_15 amb 68.54575553099912
R31744 n_18_0_15 amb 68.5457496278497
R31745 n_18_1_15 amb 68.5457496278497
R31746 n_18_2_15 amb 68.5457496278497
R31747 n_18_3_15 amb 68.5457496278497
R31748 n_18_4_4 amb 1511.6764018144156
R31749 n_18_4_15 amb 1511.6764018144156
R31750 n_18_5_4 amb 1511.6764018143892
R31751 n_18_5_15 amb 1511.6764018143892
R31752 n_18_6_4 amb 1511.6764018143892
R31753 n_18_6_15 amb 1511.6764018143892
R31754 n_18_7_4 amb 1511.6764018144156
R31755 n_18_7_15 amb 1511.6764018144156
R31756 n_18_8_15 amb 26.313590552674004
R31757 n_18_9_15 amb 26.313590552673983
R31758 n_18_10_15 amb 26.313590552674004
R31759 n_18_11_15 amb 26.313590552674004
R31760 n_18_12_4 amb 1511.6738070741683
R31761 n_18_12_15 amb 1511.6738070741683
R31762 n_18_13_4 amb 1511.6738070741683
R31763 n_18_13_15 amb 1511.6738070741683
R31764 n_18_14_4 amb 1511.6738070741683
R31765 n_18_14_15 amb 1511.6738070741683
R31766 n_18_15_4 amb 1511.6738070741683
R31767 n_18_15_15 amb 1511.6738070741683
R31768 n_18_16_15 amb 26.31359055267402
R31769 n_18_17_15 amb 26.313590552673983
R31770 n_18_18_15 amb 26.313590552673983
R31771 n_18_19_15 amb 26.31359055267402
R31772 n_18_20_4 amb 1511.6735307725005
R31773 n_18_20_15 amb 1511.6735307725005
R31774 n_18_21_4 amb 1511.6735307725005
R31775 n_18_21_15 amb 1511.6735307725005
R31776 n_18_22_4 amb 1511.6735307726083
R31777 n_18_22_15 amb 1511.6735307726083
R31778 n_18_23_4 amb 1511.6735307725005
R31779 n_18_23_15 amb 1511.6735307725005
R31780 n_18_24_15 amb 68.54575553099912
R31781 n_18_25_15 amb 68.54575553099934
R31782 n_18_26_15 amb 68.54575553099912
R31783 n_18_27_15 amb 68.54575553099912
R31784 n_19_0_15 amb 68.54574962784964
R31785 n_19_1_15 amb 68.54574962784964
R31786 n_19_2_15 amb 68.54574962784964
R31787 n_19_3_15 amb 68.54574962784964
R31788 n_19_4_4 amb 1511.6764018144145
R31789 n_19_4_15 amb 1511.6764018144145
R31790 n_19_5_4 amb 1511.6764018143876
R31791 n_19_5_15 amb 1511.6764018143876
R31792 n_19_6_4 amb 1511.6764018143876
R31793 n_19_6_15 amb 1511.6764018143876
R31794 n_19_7_4 amb 1511.6764018144145
R31795 n_19_7_15 amb 1511.6764018144145
R31796 n_19_8_15 amb 26.31359055267398
R31797 n_19_9_15 amb 26.31359055267396
R31798 n_19_10_15 amb 26.31359055267398
R31799 n_19_11_15 amb 26.31359055267398
R31800 n_19_12_4 amb 1511.6738070741667
R31801 n_19_12_15 amb 1511.6738070741667
R31802 n_19_13_4 amb 1511.6738070741667
R31803 n_19_13_15 amb 1511.6738070741667
R31804 n_19_14_4 amb 1511.6738070741667
R31805 n_19_14_15 amb 1511.6738070741667
R31806 n_19_15_4 amb 1511.6738070741667
R31807 n_19_15_15 amb 1511.6738070741667
R31808 n_19_16_15 amb 26.313590552673993
R31809 n_19_17_15 amb 26.31359055267396
R31810 n_19_18_15 amb 26.31359055267396
R31811 n_19_19_15 amb 26.313590552673993
R31812 n_19_20_4 amb 1511.6735307724994
R31813 n_19_20_15 amb 1511.6735307724994
R31814 n_19_21_4 amb 1511.6735307724994
R31815 n_19_21_15 amb 1511.6735307724994
R31816 n_19_22_4 amb 1511.673530772607
R31817 n_19_22_15 amb 1511.673530772607
R31818 n_19_23_4 amb 1511.6735307724994
R31819 n_19_23_15 amb 1511.6735307724994
R31820 n_19_24_15 amb 68.54575553099906
R31821 n_19_25_15 amb 68.54575553099929
R31822 n_19_26_15 amb 68.54575553099906
R31823 n_19_27_15 amb 68.54575553099906
R31824 n_20_0_15 amb 2591.101307970193
R31825 n_20_1_15 amb 2591.101307970193
R31826 n_20_2_15 amb 2591.101307970193
R31827 n_20_3_15 amb 2591.101307970193
R31828 n_20_4_4 amb 57142.95522676133
R31829 n_20_4_15 amb 57142.95522676133
R31830 n_20_5_4 amb 57142.95522676032
R31831 n_20_5_15 amb 57142.95522676032
R31832 n_20_6_4 amb 57142.95522676032
R31833 n_20_6_15 amb 57142.95522676032
R31834 n_20_7_4 amb 57142.95522676133
R31835 n_20_7_15 amb 57142.95522676133
R31836 n_20_8_4 amb 994.6813517774141
R31837 n_20_8_15 amb 994.6813517774141
R31838 n_20_9_4 amb 994.6813517774134
R31839 n_20_9_15 amb 994.6813517774134
R31840 n_20_10_4 amb 994.6813517774141
R31841 n_20_10_15 amb 994.6813517774141
R31842 n_20_11_4 amb 994.6813517774141
R31843 n_20_11_15 amb 994.6813517774141
R31844 n_20_12_4 amb 57142.85714285551
R31845 n_20_12_15 amb 57142.85714285551
R31846 n_20_13_4 amb 57142.85714285551
R31847 n_20_13_15 amb 57142.85714285551
R31848 n_20_14_4 amb 57142.85714285551
R31849 n_20_14_15 amb 57142.85714285551
R31850 n_20_15_4 amb 57142.85714285551
R31851 n_20_15_15 amb 57142.85714285551
R31852 n_20_16_4 amb 994.6813517774146
R31853 n_20_16_15 amb 994.6813517774146
R31854 n_20_17_4 amb 994.6813517774134
R31855 n_20_17_15 amb 994.6813517774134
R31856 n_20_18_4 amb 994.6813517774134
R31857 n_20_18_15 amb 994.6813517774134
R31858 n_20_19_4 amb 994.6813517774146
R31859 n_20_19_15 amb 994.6813517774146
R31860 n_20_20_4 amb 57142.84669836238
R31861 n_20_20_15 amb 57142.84669836238
R31862 n_20_21_4 amb 57142.84669836238
R31863 n_20_21_15 amb 57142.84669836238
R31864 n_20_22_4 amb 57142.84669836644
R31865 n_20_22_15 amb 57142.84669836644
R31866 n_20_23_4 amb 57142.84669836238
R31867 n_20_23_15 amb 57142.84669836238
R31868 n_20_24_15 amb 2591.1015311154392
R31869 n_20_25_15 amb 2591.1015311154474
R31870 n_20_26_15 amb 2591.1015311154392
R31871 n_20_27_15 amb 2591.1015311154392
R31872 n_21_0_15 amb 2591.101307970193
R31873 n_21_1_15 amb 2591.101307970193
R31874 n_21_2_15 amb 2591.101307970193
R31875 n_21_3_15 amb 2591.101307970193
R31876 n_21_4_4 amb 57142.95522676133
R31877 n_21_4_15 amb 57142.95522676133
R31878 n_21_5_4 amb 57142.95522676032
R31879 n_21_5_15 amb 57142.95522676032
R31880 n_21_6_4 amb 57142.95522676032
R31881 n_21_6_15 amb 57142.95522676032
R31882 n_21_7_4 amb 57142.95522676133
R31883 n_21_7_15 amb 57142.95522676133
R31884 n_21_8_4 amb 994.6813517774141
R31885 n_21_8_15 amb 994.6813517774141
R31886 n_21_9_4 amb 994.6813517774134
R31887 n_21_9_15 amb 994.6813517774134
R31888 n_21_10_4 amb 994.6813517774141
R31889 n_21_10_15 amb 994.6813517774141
R31890 n_21_11_4 amb 994.6813517774141
R31891 n_21_11_15 amb 994.6813517774141
R31892 n_21_12_4 amb 57142.85714285551
R31893 n_21_12_15 amb 57142.85714285551
R31894 n_21_13_4 amb 57142.85714285551
R31895 n_21_13_15 amb 57142.85714285551
R31896 n_21_14_4 amb 57142.85714285551
R31897 n_21_14_15 amb 57142.85714285551
R31898 n_21_15_4 amb 57142.85714285551
R31899 n_21_15_15 amb 57142.85714285551
R31900 n_21_16_4 amb 994.6813517774146
R31901 n_21_16_15 amb 994.6813517774146
R31902 n_21_17_4 amb 994.6813517774134
R31903 n_21_17_15 amb 994.6813517774134
R31904 n_21_18_4 amb 994.6813517774134
R31905 n_21_18_15 amb 994.6813517774134
R31906 n_21_19_4 amb 994.6813517774146
R31907 n_21_19_15 amb 994.6813517774146
R31908 n_21_20_4 amb 57142.84669836238
R31909 n_21_20_15 amb 57142.84669836238
R31910 n_21_21_4 amb 57142.84669836238
R31911 n_21_21_15 amb 57142.84669836238
R31912 n_21_22_4 amb 57142.84669836644
R31913 n_21_22_15 amb 57142.84669836644
R31914 n_21_23_4 amb 57142.84669836238
R31915 n_21_23_15 amb 57142.84669836238
R31916 n_21_24_15 amb 2591.1015311154392
R31917 n_21_25_15 amb 2591.1015311154474
R31918 n_21_26_15 amb 2591.1015311154392
R31919 n_21_27_15 amb 2591.1015311154392
R31920 n_22_0_15 amb 2591.101307970193
R31921 n_22_1_15 amb 2591.101307970193
R31922 n_22_2_15 amb 2591.101307970193
R31923 n_22_3_15 amb 2591.101307970193
R31924 n_22_4_4 amb 57142.95522676133
R31925 n_22_4_15 amb 57142.95522676133
R31926 n_22_5_4 amb 57142.95522676032
R31927 n_22_5_15 amb 57142.95522676032
R31928 n_22_6_4 amb 57142.95522676032
R31929 n_22_6_15 amb 57142.95522676032
R31930 n_22_7_4 amb 57142.95522676133
R31931 n_22_7_15 amb 57142.95522676133
R31932 n_22_8_4 amb 994.6813517774141
R31933 n_22_8_15 amb 994.6813517774141
R31934 n_22_9_4 amb 994.6813517774134
R31935 n_22_9_15 amb 994.6813517774134
R31936 n_22_10_4 amb 994.6813517774141
R31937 n_22_10_15 amb 994.6813517774141
R31938 n_22_11_4 amb 994.6813517774141
R31939 n_22_11_15 amb 994.6813517774141
R31940 n_22_12_4 amb 57142.85714285551
R31941 n_22_12_15 amb 57142.85714285551
R31942 n_22_13_4 amb 57142.85714285551
R31943 n_22_13_15 amb 57142.85714285551
R31944 n_22_14_4 amb 57142.85714285551
R31945 n_22_14_15 amb 57142.85714285551
R31946 n_22_15_4 amb 57142.85714285551
R31947 n_22_15_15 amb 57142.85714285551
R31948 n_22_16_4 amb 994.6813517774146
R31949 n_22_16_15 amb 994.6813517774146
R31950 n_22_17_4 amb 994.6813517774134
R31951 n_22_17_15 amb 994.6813517774134
R31952 n_22_18_4 amb 994.6813517774134
R31953 n_22_18_15 amb 994.6813517774134
R31954 n_22_19_4 amb 994.6813517774146
R31955 n_22_19_15 amb 994.6813517774146
R31956 n_22_20_4 amb 57142.84669836238
R31957 n_22_20_15 amb 57142.84669836238
R31958 n_22_21_4 amb 57142.84669836238
R31959 n_22_21_15 amb 57142.84669836238
R31960 n_22_22_4 amb 57142.84669836644
R31961 n_22_22_15 amb 57142.84669836644
R31962 n_22_23_4 amb 57142.84669836238
R31963 n_22_23_15 amb 57142.84669836238
R31964 n_22_24_15 amb 2591.1015311154392
R31965 n_22_25_15 amb 2591.1015311154474
R31966 n_22_26_15 amb 2591.1015311154392
R31967 n_22_27_15 amb 2591.1015311154392
R31968 n_23_0_15 amb 2591.101307970193
R31969 n_23_1_15 amb 2591.101307970193
R31970 n_23_2_15 amb 2591.101307970193
R31971 n_23_3_15 amb 2591.101307970193
R31972 n_23_4_4 amb 57142.95522676133
R31973 n_23_4_15 amb 57142.95522676133
R31974 n_23_5_4 amb 57142.95522676032
R31975 n_23_5_15 amb 57142.95522676032
R31976 n_23_6_4 amb 57142.95522676032
R31977 n_23_6_15 amb 57142.95522676032
R31978 n_23_7_4 amb 57142.95522676133
R31979 n_23_7_15 amb 57142.95522676133
R31980 n_23_8_4 amb 994.6813517774141
R31981 n_23_8_15 amb 994.6813517774141
R31982 n_23_9_4 amb 994.6813517774134
R31983 n_23_9_15 amb 994.6813517774134
R31984 n_23_10_4 amb 994.6813517774141
R31985 n_23_10_15 amb 994.6813517774141
R31986 n_23_11_4 amb 994.6813517774141
R31987 n_23_11_15 amb 994.6813517774141
R31988 n_23_12_4 amb 57142.85714285551
R31989 n_23_12_15 amb 57142.85714285551
R31990 n_23_13_4 amb 57142.85714285551
R31991 n_23_13_15 amb 57142.85714285551
R31992 n_23_14_4 amb 57142.85714285551
R31993 n_23_14_15 amb 57142.85714285551
R31994 n_23_15_4 amb 57142.85714285551
R31995 n_23_15_15 amb 57142.85714285551
R31996 n_23_16_4 amb 994.6813517774146
R31997 n_23_16_15 amb 994.6813517774146
R31998 n_23_17_4 amb 994.6813517774134
R31999 n_23_17_15 amb 994.6813517774134
R32000 n_23_18_4 amb 994.6813517774134
R32001 n_23_18_15 amb 994.6813517774134
R32002 n_23_19_4 amb 994.6813517774146
R32003 n_23_19_15 amb 994.6813517774146
R32004 n_23_20_4 amb 57142.84669836238
R32005 n_23_20_15 amb 57142.84669836238
R32006 n_23_21_4 amb 57142.84669836238
R32007 n_23_21_15 amb 57142.84669836238
R32008 n_23_22_4 amb 57142.84669836644
R32009 n_23_22_15 amb 57142.84669836644
R32010 n_23_23_4 amb 57142.84669836238
R32011 n_23_23_15 amb 57142.84669836238
R32012 n_23_24_15 amb 2591.1015311154392
R32013 n_23_25_15 amb 2591.1015311154474
R32014 n_23_26_15 amb 2591.1015311154392
R32015 n_23_27_15 amb 2591.1015311154392
R32016 n_24_0_15 amb 68.54574962784964
R32017 n_24_1_15 amb 68.54574962784964
R32018 n_24_2_15 amb 68.54574962784964
R32019 n_24_3_15 amb 68.54574962784964
R32020 n_24_4_4 amb 1511.6764018144145
R32021 n_24_4_15 amb 1511.6764018144145
R32022 n_24_5_4 amb 1511.6764018143876
R32023 n_24_5_15 amb 1511.6764018143876
R32024 n_24_6_4 amb 1511.6764018143876
R32025 n_24_6_15 amb 1511.6764018143876
R32026 n_24_7_4 amb 1511.6764018144145
R32027 n_24_7_15 amb 1511.6764018144145
R32028 n_24_8_15 amb 26.31359055267398
R32029 n_24_9_15 amb 26.31359055267396
R32030 n_24_10_15 amb 26.31359055267398
R32031 n_24_11_15 amb 26.31359055267398
R32032 n_24_12_4 amb 1511.6738070741667
R32033 n_24_12_15 amb 1511.6738070741667
R32034 n_24_13_4 amb 1511.6738070741667
R32035 n_24_13_15 amb 1511.6738070741667
R32036 n_24_14_4 amb 1511.6738070741667
R32037 n_24_14_15 amb 1511.6738070741667
R32038 n_24_15_4 amb 1511.6738070741667
R32039 n_24_15_15 amb 1511.6738070741667
R32040 n_24_16_15 amb 26.313590552673993
R32041 n_24_17_15 amb 26.31359055267396
R32042 n_24_18_15 amb 26.31359055267396
R32043 n_24_19_15 amb 26.313590552673993
R32044 n_24_20_4 amb 1511.6735307724994
R32045 n_24_20_15 amb 1511.6735307724994
R32046 n_24_21_4 amb 1511.6735307724994
R32047 n_24_21_15 amb 1511.6735307724994
R32048 n_24_22_4 amb 1511.673530772607
R32049 n_24_22_15 amb 1511.673530772607
R32050 n_24_23_4 amb 1511.6735307724994
R32051 n_24_23_15 amb 1511.6735307724994
R32052 n_24_24_15 amb 68.54575553099906
R32053 n_24_25_15 amb 68.54575553099929
R32054 n_24_26_15 amb 68.54575553099906
R32055 n_24_27_15 amb 68.54575553099906
R32056 n_25_0_15 amb 68.54574962784964
R32057 n_25_1_15 amb 68.54574962784964
R32058 n_25_2_15 amb 68.54574962784964
R32059 n_25_3_15 amb 68.54574962784964
R32060 n_25_4_4 amb 1511.6764018144145
R32061 n_25_4_15 amb 1511.6764018144145
R32062 n_25_5_4 amb 1511.6764018143876
R32063 n_25_5_15 amb 1511.6764018143876
R32064 n_25_6_4 amb 1511.6764018143876
R32065 n_25_6_15 amb 1511.6764018143876
R32066 n_25_7_4 amb 1511.6764018144145
R32067 n_25_7_15 amb 1511.6764018144145
R32068 n_25_8_15 amb 26.31359055267398
R32069 n_25_9_15 amb 26.31359055267396
R32070 n_25_10_15 amb 26.31359055267398
R32071 n_25_11_15 amb 26.31359055267398
R32072 n_25_12_4 amb 1511.6738070741667
R32073 n_25_12_15 amb 1511.6738070741667
R32074 n_25_13_4 amb 1511.6738070741667
R32075 n_25_13_15 amb 1511.6738070741667
R32076 n_25_14_4 amb 1511.6738070741667
R32077 n_25_14_15 amb 1511.6738070741667
R32078 n_25_15_4 amb 1511.6738070741667
R32079 n_25_15_15 amb 1511.6738070741667
R32080 n_25_16_15 amb 26.313590552673993
R32081 n_25_17_15 amb 26.31359055267396
R32082 n_25_18_15 amb 26.31359055267396
R32083 n_25_19_15 amb 26.313590552673993
R32084 n_25_20_4 amb 1511.6735307724994
R32085 n_25_20_15 amb 1511.6735307724994
R32086 n_25_21_4 amb 1511.6735307724994
R32087 n_25_21_15 amb 1511.6735307724994
R32088 n_25_22_4 amb 1511.673530772607
R32089 n_25_22_15 amb 1511.673530772607
R32090 n_25_23_4 amb 1511.6735307724994
R32091 n_25_23_15 amb 1511.6735307724994
R32092 n_25_24_15 amb 68.54575553099906
R32093 n_25_25_15 amb 68.54575553099929
R32094 n_25_26_15 amb 68.54575553099906
R32095 n_25_27_15 amb 68.54575553099906
R32096 n_26_0_15 amb 68.54574962784977
R32097 n_26_1_15 amb 68.54574962784977
R32098 n_26_2_15 amb 68.54574962784977
R32099 n_26_3_15 amb 68.54574962784977
R32100 n_26_4_4 amb 1511.6764018144174
R32101 n_26_4_15 amb 1511.6764018144174
R32102 n_26_5_4 amb 1511.6764018143906
R32103 n_26_5_15 amb 1511.6764018143906
R32104 n_26_6_4 amb 1511.6764018143906
R32105 n_26_6_15 amb 1511.6764018143906
R32106 n_26_7_4 amb 1511.6764018144174
R32107 n_26_7_15 amb 1511.6764018144174
R32108 n_26_8_15 amb 26.313590552674032
R32109 n_26_9_15 amb 26.313590552674007
R32110 n_26_10_15 amb 26.313590552674032
R32111 n_26_11_15 amb 26.313590552674032
R32112 n_26_12_4 amb 1511.6738070741696
R32113 n_26_12_15 amb 1511.6738070741696
R32114 n_26_13_4 amb 1511.6738070741696
R32115 n_26_13_15 amb 1511.6738070741696
R32116 n_26_14_4 amb 1511.6738070741696
R32117 n_26_14_15 amb 1511.6738070741696
R32118 n_26_15_4 amb 1511.6738070741696
R32119 n_26_15_15 amb 1511.6738070741696
R32120 n_26_16_15 amb 26.313590552674043
R32121 n_26_17_15 amb 26.313590552674007
R32122 n_26_18_15 amb 26.313590552674007
R32123 n_26_19_15 amb 26.313590552674043
R32124 n_26_20_4 amb 1511.673530772502
R32125 n_26_20_15 amb 1511.673530772502
R32126 n_26_21_4 amb 1511.673530772502
R32127 n_26_21_15 amb 1511.673530772502
R32128 n_26_22_4 amb 1511.6735307726099
R32129 n_26_22_15 amb 1511.6735307726099
R32130 n_26_23_4 amb 1511.673530772502
R32131 n_26_23_15 amb 1511.673530772502
R32132 n_26_24_15 amb 68.54575553099919
R32133 n_26_25_15 amb 68.54575553099941
R32134 n_26_26_15 amb 68.54575553099919
R32135 n_26_27_15 amb 68.54575553099919
R32136 n_27_0_15 amb 68.54574962784964
R32137 n_27_1_15 amb 68.54574962784964
R32138 n_27_2_15 amb 68.54574962784964
R32139 n_27_3_15 amb 68.54574962784964
R32140 n_27_4_4 amb 1511.6764018144145
R32141 n_27_4_15 amb 1511.6764018144145
R32142 n_27_5_4 amb 1511.6764018143876
R32143 n_27_5_15 amb 1511.6764018143876
R32144 n_27_6_4 amb 1511.6764018143876
R32145 n_27_6_15 amb 1511.6764018143876
R32146 n_27_7_4 amb 1511.6764018144145
R32147 n_27_7_15 amb 1511.6764018144145
R32148 n_27_8_15 amb 26.31359055267398
R32149 n_27_9_15 amb 26.31359055267396
R32150 n_27_10_15 amb 26.31359055267398
R32151 n_27_11_15 amb 26.31359055267398
R32152 n_27_12_4 amb 1511.6738070741667
R32153 n_27_12_15 amb 1511.6738070741667
R32154 n_27_13_4 amb 1511.6738070741667
R32155 n_27_13_15 amb 1511.6738070741667
R32156 n_27_14_4 amb 1511.6738070741667
R32157 n_27_14_15 amb 1511.6738070741667
R32158 n_27_15_4 amb 1511.6738070741667
R32159 n_27_15_15 amb 1511.6738070741667
R32160 n_27_16_15 amb 26.313590552673993
R32161 n_27_17_15 amb 26.31359055267396
R32162 n_27_18_15 amb 26.31359055267396
R32163 n_27_19_15 amb 26.313590552673993
R32164 n_27_20_4 amb 1511.6735307724994
R32165 n_27_20_15 amb 1511.6735307724994
R32166 n_27_21_4 amb 1511.6735307724994
R32167 n_27_21_15 amb 1511.6735307724994
R32168 n_27_22_4 amb 1511.673530772607
R32169 n_27_22_15 amb 1511.673530772607
R32170 n_27_23_4 amb 1511.6735307724994
R32171 n_27_23_15 amb 1511.6735307724994
R32172 n_27_24_15 amb 68.54575553099906
R32173 n_27_25_15 amb 68.54575553099929
R32174 n_27_26_15 amb 68.54575553099906
R32175 n_27_27_15 amb 68.54575553099906
R32176 n_28_0_15 amb 2591.101307970193
R32177 n_28_1_15 amb 2591.101307970193
R32178 n_28_2_15 amb 2591.101307970193
R32179 n_28_3_15 amb 2591.101307970193
R32180 n_28_4_4 amb 57142.95522676133
R32181 n_28_4_15 amb 57142.95522676133
R32182 n_28_5_4 amb 57142.95522676032
R32183 n_28_5_15 amb 57142.95522676032
R32184 n_28_6_4 amb 57142.95522676032
R32185 n_28_6_15 amb 57142.95522676032
R32186 n_28_7_4 amb 57142.95522676133
R32187 n_28_7_15 amb 57142.95522676133
R32188 n_28_8_4 amb 994.6813517774141
R32189 n_28_8_15 amb 994.6813517774141
R32190 n_28_9_4 amb 994.6813517774134
R32191 n_28_9_15 amb 994.6813517774134
R32192 n_28_10_4 amb 994.6813517774141
R32193 n_28_10_15 amb 994.6813517774141
R32194 n_28_11_4 amb 994.6813517774141
R32195 n_28_11_15 amb 994.6813517774141
R32196 n_28_12_4 amb 57142.85714285551
R32197 n_28_12_15 amb 57142.85714285551
R32198 n_28_13_4 amb 57142.85714285551
R32199 n_28_13_15 amb 57142.85714285551
R32200 n_28_14_4 amb 57142.85714285551
R32201 n_28_14_15 amb 57142.85714285551
R32202 n_28_15_4 amb 57142.85714285551
R32203 n_28_15_15 amb 57142.85714285551
R32204 n_28_16_4 amb 994.6813517774146
R32205 n_28_16_15 amb 994.6813517774146
R32206 n_28_17_4 amb 994.6813517774134
R32207 n_28_17_15 amb 994.6813517774134
R32208 n_28_18_4 amb 994.6813517774134
R32209 n_28_18_15 amb 994.6813517774134
R32210 n_28_19_4 amb 994.6813517774146
R32211 n_28_19_15 amb 994.6813517774146
R32212 n_28_20_4 amb 57142.84669836238
R32213 n_28_20_15 amb 57142.84669836238
R32214 n_28_21_4 amb 57142.84669836238
R32215 n_28_21_15 amb 57142.84669836238
R32216 n_28_22_4 amb 57142.84669836644
R32217 n_28_22_15 amb 57142.84669836644
R32218 n_28_23_4 amb 57142.84669836238
R32219 n_28_23_15 amb 57142.84669836238
R32220 n_28_24_15 amb 2591.1015311154392
R32221 n_28_25_15 amb 2591.1015311154474
R32222 n_28_26_15 amb 2591.1015311154392
R32223 n_28_27_15 amb 2591.1015311154392
R32224 n_29_0_15 amb 2591.101307970377
R32225 n_29_1_15 amb 2591.101307970377
R32226 n_29_2_15 amb 2591.101307970377
R32227 n_29_3_15 amb 2591.101307970377
R32228 n_29_4_4 amb 57142.95522676539
R32229 n_29_4_15 amb 57142.95522676539
R32230 n_29_5_4 amb 57142.95522676438
R32231 n_29_5_15 amb 57142.95522676438
R32232 n_29_6_4 amb 57142.95522676438
R32233 n_29_6_15 amb 57142.95522676438
R32234 n_29_7_4 amb 57142.95522676539
R32235 n_29_7_15 amb 57142.95522676539
R32236 n_29_8_4 amb 994.6813517774848
R32237 n_29_8_15 amb 994.6813517774848
R32238 n_29_9_4 amb 994.681351777484
R32239 n_29_9_15 amb 994.681351777484
R32240 n_29_10_4 amb 994.6813517774848
R32241 n_29_10_15 amb 994.6813517774848
R32242 n_29_11_4 amb 994.6813517774848
R32243 n_29_11_15 amb 994.6813517774848
R32244 n_29_12_4 amb 57142.85714285958
R32245 n_29_12_15 amb 57142.85714285958
R32246 n_29_13_4 amb 57142.85714285958
R32247 n_29_13_15 amb 57142.85714285958
R32248 n_29_14_4 amb 57142.85714285958
R32249 n_29_14_15 amb 57142.85714285958
R32250 n_29_15_4 amb 57142.85714285958
R32251 n_29_15_15 amb 57142.85714285958
R32252 n_29_16_4 amb 994.6813517774852
R32253 n_29_16_15 amb 994.6813517774852
R32254 n_29_17_4 amb 994.681351777484
R32255 n_29_17_15 amb 994.681351777484
R32256 n_29_18_4 amb 994.681351777484
R32257 n_29_18_15 amb 994.681351777484
R32258 n_29_19_4 amb 994.6813517774852
R32259 n_29_19_15 amb 994.6813517774852
R32260 n_29_20_4 amb 57142.84669836644
R32261 n_29_20_15 amb 57142.84669836644
R32262 n_29_21_4 amb 57142.84669836644
R32263 n_29_21_15 amb 57142.84669836644
R32264 n_29_22_4 amb 57142.8466983705
R32265 n_29_22_15 amb 57142.8466983705
R32266 n_29_23_4 amb 57142.84669836644
R32267 n_29_23_15 amb 57142.84669836644
R32268 n_29_24_15 amb 2591.101531115623
R32269 n_29_25_15 amb 2591.1015311156316
R32270 n_29_26_15 amb 2591.101531115623
R32271 n_29_27_15 amb 2591.101531115623
R32272 n_30_0_15 amb 2591.101307970193
R32273 n_30_1_15 amb 2591.101307970193
R32274 n_30_2_15 amb 2591.101307970193
R32275 n_30_3_15 amb 2591.101307970193
R32276 n_30_4_4 amb 57142.95522676133
R32277 n_30_4_15 amb 57142.95522676133
R32278 n_30_5_4 amb 57142.95522676032
R32279 n_30_5_15 amb 57142.95522676032
R32280 n_30_6_4 amb 57142.95522676032
R32281 n_30_6_15 amb 57142.95522676032
R32282 n_30_7_4 amb 57142.95522676133
R32283 n_30_7_15 amb 57142.95522676133
R32284 n_30_8_4 amb 994.6813517774141
R32285 n_30_8_15 amb 994.6813517774141
R32286 n_30_9_4 amb 994.6813517774134
R32287 n_30_9_15 amb 994.6813517774134
R32288 n_30_10_4 amb 994.6813517774141
R32289 n_30_10_15 amb 994.6813517774141
R32290 n_30_11_4 amb 994.6813517774141
R32291 n_30_11_15 amb 994.6813517774141
R32292 n_30_12_4 amb 57142.85714285551
R32293 n_30_12_15 amb 57142.85714285551
R32294 n_30_13_4 amb 57142.85714285551
R32295 n_30_13_15 amb 57142.85714285551
R32296 n_30_14_4 amb 57142.85714285551
R32297 n_30_14_15 amb 57142.85714285551
R32298 n_30_15_4 amb 57142.85714285551
R32299 n_30_15_15 amb 57142.85714285551
R32300 n_30_16_4 amb 994.6813517774146
R32301 n_30_16_15 amb 994.6813517774146
R32302 n_30_17_4 amb 994.6813517774134
R32303 n_30_17_15 amb 994.6813517774134
R32304 n_30_18_4 amb 994.6813517774134
R32305 n_30_18_15 amb 994.6813517774134
R32306 n_30_19_4 amb 994.6813517774146
R32307 n_30_19_15 amb 994.6813517774146
R32308 n_30_20_4 amb 57142.84669836238
R32309 n_30_20_15 amb 57142.84669836238
R32310 n_30_21_4 amb 57142.84669836238
R32311 n_30_21_15 amb 57142.84669836238
R32312 n_30_22_4 amb 57142.84669836644
R32313 n_30_22_15 amb 57142.84669836644
R32314 n_30_23_4 amb 57142.84669836238
R32315 n_30_23_15 amb 57142.84669836238
R32316 n_30_24_15 amb 2591.1015311154392
R32317 n_30_25_15 amb 2591.1015311154474
R32318 n_30_26_15 amb 2591.1015311154392
R32319 n_30_27_15 amb 2591.1015311154392
R32320 n_31_0_15 amb 2591.101307970193
R32321 n_31_1_15 amb 2591.101307970193
R32322 n_31_2_15 amb 2591.101307970193
R32323 n_31_3_15 amb 2591.101307970193
R32324 n_31_4_4 amb 57142.95522676133
R32325 n_31_4_15 amb 57142.95522676133
R32326 n_31_5_4 amb 57142.95522676032
R32327 n_31_5_15 amb 57142.95522676032
R32328 n_31_6_4 amb 57142.95522676032
R32329 n_31_6_15 amb 57142.95522676032
R32330 n_31_7_4 amb 57142.95522676133
R32331 n_31_7_15 amb 57142.95522676133
R32332 n_31_8_4 amb 994.6813517774141
R32333 n_31_8_15 amb 994.6813517774141
R32334 n_31_9_4 amb 994.6813517774134
R32335 n_31_9_15 amb 994.6813517774134
R32336 n_31_10_4 amb 994.6813517774141
R32337 n_31_10_15 amb 994.6813517774141
R32338 n_31_11_4 amb 994.6813517774141
R32339 n_31_11_15 amb 994.6813517774141
R32340 n_31_12_4 amb 57142.85714285551
R32341 n_31_12_15 amb 57142.85714285551
R32342 n_31_13_4 amb 57142.85714285551
R32343 n_31_13_15 amb 57142.85714285551
R32344 n_31_14_4 amb 57142.85714285551
R32345 n_31_14_15 amb 57142.85714285551
R32346 n_31_15_4 amb 57142.85714285551
R32347 n_31_15_15 amb 57142.85714285551
R32348 n_31_16_4 amb 994.6813517774146
R32349 n_31_16_15 amb 994.6813517774146
R32350 n_31_17_4 amb 994.6813517774134
R32351 n_31_17_15 amb 994.6813517774134
R32352 n_31_18_4 amb 994.6813517774134
R32353 n_31_18_15 amb 994.6813517774134
R32354 n_31_19_4 amb 994.6813517774146
R32355 n_31_19_15 amb 994.6813517774146
R32356 n_31_20_4 amb 57142.84669836238
R32357 n_31_20_15 amb 57142.84669836238
R32358 n_31_21_4 amb 57142.84669836238
R32359 n_31_21_15 amb 57142.84669836238
R32360 n_31_22_4 amb 57142.84669836644
R32361 n_31_22_15 amb 57142.84669836644
R32362 n_31_23_4 amb 57142.84669836238
R32363 n_31_23_15 amb 57142.84669836238
R32364 n_31_24_15 amb 2591.1015311154392
R32365 n_31_25_15 amb 2591.1015311154474
R32366 n_31_26_15 amb 2591.1015311154392
R32367 n_31_27_15 amb 2591.1015311154392
R32368 n_32_0_15 amb 513.4019835444592
R32369 n_32_1_15 amb 513.4019835444592
R32370 n_32_2_15 amb 513.4019835444592
R32371 n_32_3_15 amb 513.4019835444592
R32372 n_32_4_15 amb 11322.330959723702
R32373 n_32_5_15 amb 11322.3309597235
R32374 n_32_6_15 amb 11322.3309597235
R32375 n_32_7_15 amb 11322.330959723702
R32376 n_32_8_15 amb 197.08661233213462
R32377 n_32_9_15 amb 197.0866123321345
R32378 n_32_10_15 amb 197.08661233213462
R32379 n_32_11_15 amb 197.08661233213462
R32380 n_32_12_15 amb 11322.3115253343
R32381 n_32_13_15 amb 11322.3115253343
R32382 n_32_14_15 amb 11322.3115253343
R32383 n_32_15_15 amb 11322.3115253343
R32384 n_32_16_15 amb 197.08661233213473
R32385 n_32_17_15 amb 197.0866123321345
R32386 n_32_18_15 amb 197.0866123321345
R32387 n_32_19_15 amb 197.08661233213473
R32388 n_32_20_15 amb 11322.309455857712
R32389 n_32_21_15 amb 11322.309455857712
R32390 n_32_22_15 amb 11322.309455858518
R32391 n_32_23_15 amb 11322.309455857712
R32392 n_32_24_15 amb 513.4020277585593
R32393 n_32_25_15 amb 513.4020277585608
R32394 n_32_26_15 amb 513.4020277585593
R32395 n_32_27_15 amb 513.4020277585593
R32396 n_33_0_15 amb 513.4019835444592
R32397 n_33_1_15 amb 513.4019835444592
R32398 n_33_2_15 amb 513.4019835444592
R32399 n_33_3_15 amb 513.4019835444592
R32400 n_33_4_15 amb 11322.330959723702
R32401 n_33_5_15 amb 11322.3309597235
R32402 n_33_6_15 amb 11322.3309597235
R32403 n_33_7_15 amb 11322.330959723702
R32404 n_33_8_15 amb 197.08661233213462
R32405 n_33_9_15 amb 197.0866123321345
R32406 n_33_10_15 amb 197.08661233213462
R32407 n_33_11_15 amb 197.08661233213462
R32408 n_33_12_15 amb 11322.3115253343
R32409 n_33_13_15 amb 11322.3115253343
R32410 n_33_14_15 amb 11322.3115253343
R32411 n_33_15_15 amb 11322.3115253343
R32412 n_33_16_15 amb 197.08661233213473
R32413 n_33_17_15 amb 197.0866123321345
R32414 n_33_18_15 amb 197.0866123321345
R32415 n_33_19_15 amb 197.08661233213473
R32416 n_33_20_15 amb 11322.309455857712
R32417 n_33_21_15 amb 11322.309455857712
R32418 n_33_22_15 amb 11322.309455858518
R32419 n_33_23_15 amb 11322.309455857712
R32420 n_33_24_15 amb 513.4020277585593
R32421 n_33_25_15 amb 513.4020277585608
R32422 n_33_26_15 amb 513.4020277585593
R32423 n_33_27_15 amb 513.4020277585593
R32424 n_34_0_15 amb 513.4019835444665
R32425 n_34_1_15 amb 513.4019835444665
R32426 n_34_2_15 amb 513.4019835444665
R32427 n_34_3_15 amb 513.4019835444665
R32428 n_34_4_15 amb 11322.330959723862
R32429 n_34_5_15 amb 11322.330959723658
R32430 n_34_6_15 amb 11322.330959723658
R32431 n_34_7_15 amb 11322.330959723862
R32432 n_34_8_15 amb 197.0866123321374
R32433 n_34_9_15 amb 197.08661233213726
R32434 n_34_10_15 amb 197.0866123321374
R32435 n_34_11_15 amb 197.0866123321374
R32436 n_34_12_15 amb 11322.31152533446
R32437 n_34_13_15 amb 11322.31152533446
R32438 n_34_14_15 amb 11322.31152533446
R32439 n_34_15_15 amb 11322.31152533446
R32440 n_34_16_15 amb 197.08661233213752
R32441 n_34_17_15 amb 197.08661233213726
R32442 n_34_18_15 amb 197.08661233213726
R32443 n_34_19_15 amb 197.08661233213752
R32444 n_34_20_15 amb 11322.309455857874
R32445 n_34_21_15 amb 11322.309455857874
R32446 n_34_22_15 amb 11322.309455858676
R32447 n_34_23_15 amb 11322.309455857874
R32448 n_34_24_15 amb 513.4020277585663
R32449 n_34_25_15 amb 513.402027758568
R32450 n_34_26_15 amb 513.4020277585663
R32451 n_34_27_15 amb 513.4020277585663
R32452 n_35_0_15 amb 513.4019835444592
R32453 n_35_1_15 amb 513.4019835444592
R32454 n_35_2_15 amb 513.4019835444592
R32455 n_35_3_15 amb 513.4019835444592
R32456 n_35_4_15 amb 11322.330959723702
R32457 n_35_5_15 amb 11322.3309597235
R32458 n_35_6_15 amb 11322.3309597235
R32459 n_35_7_15 amb 11322.330959723702
R32460 n_35_8_15 amb 197.08661233213462
R32461 n_35_9_15 amb 197.0866123321345
R32462 n_35_10_15 amb 197.08661233213462
R32463 n_35_11_15 amb 197.08661233213462
R32464 n_35_12_15 amb 11322.3115253343
R32465 n_35_13_15 amb 11322.3115253343
R32466 n_35_14_15 amb 11322.3115253343
R32467 n_35_15_15 amb 11322.3115253343
R32468 n_35_16_15 amb 197.08661233213473
R32469 n_35_17_15 amb 197.0866123321345
R32470 n_35_18_15 amb 197.0866123321345
R32471 n_35_19_15 amb 197.08661233213473
R32472 n_35_20_15 amb 11322.309455857712
R32473 n_35_21_15 amb 11322.309455857712
R32474 n_35_22_15 amb 11322.309455858518
R32475 n_35_23_15 amb 11322.309455857712
R32476 n_35_24_15 amb 513.4020277585593
R32477 n_35_25_15 amb 513.4020277585608
R32478 n_35_26_15 amb 513.4020277585593
R32479 n_35_27_15 amb 513.4020277585593
I0 0 n_0_0_4 0.09093330927160069
I1 0 n_0_1_4 0.09093330927160069
I2 0 n_0_2_4 0.09093330927160069
I3 0 n_0_3_4 0.09093330927160069
I4 0 n_0_4_4 0.0041232977128448835
I5 0 n_0_5_4 0.004123297712844956
I6 0 n_0_6_4 0.004123297712844956
I7 0 n_0_7_4 0.0041232977128448835
I8 0 n_0_8_4 0.2368772835347456
I9 0 n_0_9_4 0.2368772835347458
I10 0 n_0_10_4 0.2368772835347456
I11 0 n_0_11_4 0.2368772835347456
I12 0 n_0_12_4 0.004123304790354911
I13 0 n_0_13_4 0.004123304790354911
I14 0 n_0_14_4 0.004123304790354911
I15 0 n_0_15_4 0.004123304790354911
I16 0 n_0_16_4 0.2368772835347455
I17 0 n_0_17_4 0.2368772835347458
I18 0 n_0_18_4 0.2368772835347458
I19 0 n_0_19_4 0.2368772835347455
I20 0 n_0_20_4 0.00412330554400705
I21 0 n_0_21_4 0.00412330554400705
I22 0 n_0_22_4 0.004123305544006756
I23 0 n_0_23_4 0.00412330554400705
I24 0 n_0_24_4 0.09093330144043872
I25 0 n_0_25_4 0.09093330144043843
I26 0 n_0_26_4 0.09093330144043872
I27 0 n_0_27_4 0.09093330144043872
I28 0 n_1_0_4 0.09093330927160069
I29 0 n_1_1_4 0.09093330927160069
I30 0 n_1_2_4 0.09093330927160069
I31 0 n_1_3_4 0.09093330927160069
I32 0 n_1_4_4 0.0041232977128448835
I33 0 n_1_5_4 0.004123297712844956
I34 0 n_1_6_4 0.004123297712844956
I35 0 n_1_7_4 0.0041232977128448835
I36 0 n_1_8_4 0.2368772835347456
I37 0 n_1_9_4 0.2368772835347458
I38 0 n_1_10_4 0.2368772835347456
I39 0 n_1_11_4 0.2368772835347456
I40 0 n_1_12_4 0.004123304790354911
I41 0 n_1_13_4 0.004123304790354911
I42 0 n_1_14_4 0.004123304790354911
I43 0 n_1_15_4 0.004123304790354911
I44 0 n_1_16_4 0.2368772835347455
I45 0 n_1_17_4 0.2368772835347458
I46 0 n_1_18_4 0.2368772835347458
I47 0 n_1_19_4 0.2368772835347455
I48 0 n_1_20_4 0.00412330554400705
I49 0 n_1_21_4 0.00412330554400705
I50 0 n_1_22_4 0.004123305544006756
I51 0 n_1_23_4 0.00412330554400705
I52 0 n_1_24_4 0.09093330144043872
I53 0 n_1_25_4 0.09093330144043843
I54 0 n_1_26_4 0.09093330144043872
I55 0 n_1_27_4 0.09093330144043872
I56 0 n_2_0_4 0.09093330927160066
I57 0 n_2_1_4 0.09093330927160066
I58 0 n_2_2_4 0.09093330927160066
I59 0 n_2_3_4 0.09093330927160066
I60 0 n_2_4_4 0.004123297712844883
I61 0 n_2_5_4 0.004123297712844955
I62 0 n_2_6_4 0.004123297712844955
I63 0 n_2_7_4 0.004123297712844883
I64 0 n_2_8_4 0.23687728353474555
I65 0 n_2_9_4 0.23687728353474574
I66 0 n_2_10_4 0.23687728353474555
I67 0 n_2_11_4 0.23687728353474555
I68 0 n_2_12_4 0.00412330479035491
I69 0 n_2_13_4 0.00412330479035491
I70 0 n_2_14_4 0.00412330479035491
I71 0 n_2_15_4 0.00412330479035491
I72 0 n_2_16_4 0.23687728353474544
I73 0 n_2_17_4 0.23687728353474574
I74 0 n_2_18_4 0.23687728353474574
I75 0 n_2_19_4 0.23687728353474544
I76 0 n_2_20_4 0.0041233055440070485
I77 0 n_2_21_4 0.0041233055440070485
I78 0 n_2_22_4 0.004123305544006755
I79 0 n_2_23_4 0.0041233055440070485
I80 0 n_2_24_4 0.0909333014404387
I81 0 n_2_25_4 0.09093330144043842
I82 0 n_2_26_4 0.0909333014404387
I83 0 n_2_27_4 0.0909333014404387
I84 0 n_3_0_4 0.09093330927160069
I85 0 n_3_1_4 0.09093330927160069
I86 0 n_3_2_4 0.09093330927160069
I87 0 n_3_3_4 0.09093330927160069
I88 0 n_3_4_4 0.0041232977128448835
I89 0 n_3_5_4 0.004123297712844956
I90 0 n_3_6_4 0.004123297712844956
I91 0 n_3_7_4 0.0041232977128448835
I92 0 n_3_8_4 0.23687728353474571
I93 0 n_3_9_4 0.23687728353474582
I94 0 n_3_10_4 0.23687728353474571
I95 0 n_3_11_4 0.23687728353474571
I96 0 n_3_12_4 0.004123304790354911
I97 0 n_3_13_4 0.004123304790354911
I98 0 n_3_14_4 0.004123304790354911
I99 0 n_3_15_4 0.004123304790354911
I100 0 n_3_16_4 0.23687728353474552
I101 0 n_3_17_4 0.23687728353474582
I102 0 n_3_18_4 0.23687728353474582
I103 0 n_3_19_4 0.23687728353474552
I104 0 n_3_20_4 0.004123305544007051
I105 0 n_3_21_4 0.004123305544007051
I106 0 n_3_22_4 0.004123305544006758
I107 0 n_3_23_4 0.004123305544007051
I108 0 n_3_24_4 0.09093330144043874
I109 0 n_3_25_4 0.09093330144043844
I110 0 n_3_26_4 0.09093330144043874
I111 0 n_3_27_4 0.09093330144043874
I112 0 n_4_0_4 0.018017566896887514
I113 0 n_4_1_4 0.018017566896887514
I114 0 n_4_2_4 0.018017566896887514
I115 0 n_4_3_4 0.018017566896887514
I116 0 n_4_4_4 0.0008169920678358946
I117 0 n_4_5_4 0.0008169920678359093
I118 0 n_4_6_4 0.0008169920678359093
I119 0 n_4_7_4 0.0008169920678358946
I120 0 n_4_8_4 0.0469349717570786
I121 0 n_4_9_4 0.04693497175707862
I122 0 n_4_10_4 0.0469349717570786
I123 0 n_4_11_4 0.0469349717570786
I124 0 n_4_12_4 0.0008169934701769227
I125 0 n_4_13_4 0.0008169934701769227
I126 0 n_4_14_4 0.0008169934701769227
I127 0 n_4_15_4 0.0008169934701769227
I128 0 n_4_16_4 0.04693497175707857
I129 0 n_4_17_4 0.04693497175707862
I130 0 n_4_18_4 0.04693497175707862
I131 0 n_4_19_4 0.04693497175707857
I132 0 n_4_20_4 0.000816993619505897
I133 0 n_4_21_4 0.000816993619505897
I134 0 n_4_22_4 0.0008169936195058392
I135 0 n_4_23_4 0.000816993619505897
I136 0 n_4_24_4 0.01801756534521756
I137 0 n_4_25_4 0.0180175653452175
I138 0 n_4_26_4 0.01801756534521756
I139 0 n_4_27_4 0.01801756534521756
I140 0 n_5_0_4 0.018017566896887514
I141 0 n_5_1_4 0.018017566896887514
I142 0 n_5_2_4 0.018017566896887514
I143 0 n_5_3_4 0.018017566896887514
I144 0 n_5_4_4 0.0008169920678358946
I145 0 n_5_5_4 0.0008169920678359093
I146 0 n_5_6_4 0.0008169920678359093
I147 0 n_5_7_4 0.0008169920678358946
I148 0 n_5_8_4 0.0469349717570786
I149 0 n_5_9_4 0.04693497175707862
I150 0 n_5_10_4 0.0469349717570786
I151 0 n_5_11_4 0.0469349717570786
I152 0 n_5_12_4 0.0008169934701769227
I153 0 n_5_13_4 0.0008169934701769227
I154 0 n_5_14_4 0.0008169934701769227
I155 0 n_5_15_4 0.0008169934701769227
I156 0 n_5_16_4 0.04693497175707857
I157 0 n_5_17_4 0.04693497175707862
I158 0 n_5_18_4 0.04693497175707862
I159 0 n_5_19_4 0.04693497175707857
I160 0 n_5_20_4 0.000816993619505897
I161 0 n_5_21_4 0.000816993619505897
I162 0 n_5_22_4 0.0008169936195058392
I163 0 n_5_23_4 0.000816993619505897
I164 0 n_5_24_4 0.01801756534521756
I165 0 n_5_25_4 0.0180175653452175
I166 0 n_5_26_4 0.01801756534521756
I167 0 n_5_27_4 0.01801756534521756
I168 0 n_6_0_4 0.018017566896887514
I169 0 n_6_1_4 0.018017566896887514
I170 0 n_6_2_4 0.018017566896887514
I171 0 n_6_3_4 0.018017566896887514
I172 0 n_6_4_4 0.0008169920678358946
I173 0 n_6_5_4 0.0008169920678359093
I174 0 n_6_6_4 0.0008169920678359093
I175 0 n_6_7_4 0.0008169920678358946
I176 0 n_6_8_4 0.0469349717570786
I177 0 n_6_9_4 0.04693497175707862
I178 0 n_6_10_4 0.0469349717570786
I179 0 n_6_11_4 0.0469349717570786
I180 0 n_6_12_4 0.0008169934701769227
I181 0 n_6_13_4 0.0008169934701769227
I182 0 n_6_14_4 0.0008169934701769227
I183 0 n_6_15_4 0.0008169934701769227
I184 0 n_6_16_4 0.04693497175707857
I185 0 n_6_17_4 0.04693497175707862
I186 0 n_6_18_4 0.04693497175707862
I187 0 n_6_19_4 0.04693497175707857
I188 0 n_6_20_4 0.000816993619505897
I189 0 n_6_21_4 0.000816993619505897
I190 0 n_6_22_4 0.0008169936195058392
I191 0 n_6_23_4 0.000816993619505897
I192 0 n_6_24_4 0.01801756534521756
I193 0 n_6_25_4 0.0180175653452175
I194 0 n_6_26_4 0.01801756534521756
I195 0 n_6_27_4 0.01801756534521756
I196 0 n_7_0_4 0.018017566896887514
I197 0 n_7_1_4 0.018017566896887514
I198 0 n_7_2_4 0.018017566896887514
I199 0 n_7_3_4 0.018017566896887514
I200 0 n_7_4_4 0.0008169920678358946
I201 0 n_7_5_4 0.0008169920678359093
I202 0 n_7_6_4 0.0008169920678359093
I203 0 n_7_7_4 0.0008169920678358946
I204 0 n_7_8_4 0.0469349717570786
I205 0 n_7_9_4 0.04693497175707862
I206 0 n_7_10_4 0.0469349717570786
I207 0 n_7_11_4 0.0469349717570786
I208 0 n_7_12_4 0.0008169934701769227
I209 0 n_7_13_4 0.0008169934701769227
I210 0 n_7_14_4 0.0008169934701769227
I211 0 n_7_15_4 0.0008169934701769227
I212 0 n_7_16_4 0.04693497175707857
I213 0 n_7_17_4 0.04693497175707862
I214 0 n_7_18_4 0.04693497175707862
I215 0 n_7_19_4 0.04693497175707857
I216 0 n_7_20_4 0.000816993619505897
I217 0 n_7_21_4 0.000816993619505897
I218 0 n_7_22_4 0.0008169936195058392
I219 0 n_7_23_4 0.000816993619505897
I220 0 n_7_24_4 0.01801756534521756
I221 0 n_7_25_4 0.0180175653452175
I222 0 n_7_26_4 0.01801756534521756
I223 0 n_7_27_4 0.01801756534521756
I224 0 n_8_0_4 0.6810829498398829
I225 0 n_8_1_4 0.6810829498398829
I226 0 n_8_2_4 0.6810829498398829
I227 0 n_8_3_4 0.6810829498398829
I228 0 n_8_4_4 0.030883158127947914
I229 0 n_8_5_4 0.03088315812794846
I230 0 n_8_6_4 0.03088315812794846
I231 0 n_8_7_4 0.030883158127947914
I232 0 n_8_8_4 1.7741912211512216
I233 0 n_8_8_6 0.062499999999999986
I234 0 n_8_8_7 0.03124999999999999
I235 0 n_8_8_8 0.03124999999999999
I236 0 n_8_8_9 0.03124999999999999
I237 0 n_8_8_10 0.03124999999999999
I238 0 n_8_8_11 0.03125000000000001
I239 0 n_8_8_12 0.03124999999999999
I240 0 n_8_8_13 0.031249999999999997
I241 0 n_8_8_14 0.031249999999999986
I242 0 n_8_9_4 1.7741912211512227
I243 0 n_8_9_6 0.06250000000000003
I244 0 n_8_9_7 0.03125000000000001
I245 0 n_8_9_8 0.03125000000000001
I246 0 n_8_9_9 0.03125000000000001
I247 0 n_8_9_10 0.03125000000000001
I248 0 n_8_9_11 0.03125000000000002
I249 0 n_8_9_12 0.03125000000000001
I250 0 n_8_9_13 0.031250000000000014
I251 0 n_8_9_14 0.03125000000000001
I252 0 n_8_10_4 1.7741912211512216
I253 0 n_8_10_6 0.062499999999999986
I254 0 n_8_10_7 0.03124999999999999
I255 0 n_8_10_8 0.03124999999999999
I256 0 n_8_10_9 0.03124999999999999
I257 0 n_8_10_10 0.03124999999999999
I258 0 n_8_10_11 0.03125000000000001
I259 0 n_8_10_12 0.03124999999999999
I260 0 n_8_10_13 0.031249999999999997
I261 0 n_8_10_14 0.031249999999999986
I262 0 n_8_11_4 1.7741912211512216
I263 0 n_8_11_6 0.062499999999999986
I264 0 n_8_11_7 0.03124999999999999
I265 0 n_8_11_8 0.03124999999999999
I266 0 n_8_11_9 0.03124999999999999
I267 0 n_8_11_10 0.03124999999999999
I268 0 n_8_11_11 0.03125000000000001
I269 0 n_8_11_12 0.03124999999999999
I270 0 n_8_11_13 0.031249999999999997
I271 0 n_8_11_14 0.031249999999999986
I272 0 n_8_12_4 0.03088321113791144
I273 0 n_8_13_4 0.03088321113791144
I274 0 n_8_14_4 0.03088321113791144
I275 0 n_8_15_4 0.03088321113791144
I276 0 n_8_16_4 1.7741912211512205
I277 0 n_8_16_6 0.06249999999999996
I278 0 n_8_16_7 0.031249999999999976
I279 0 n_8_16_8 0.031249999999999976
I280 0 n_8_16_9 0.031249999999999976
I281 0 n_8_16_10 0.031249999999999976
I282 0 n_8_16_11 0.031249999999999983
I283 0 n_8_16_12 0.031249999999999976
I284 0 n_8_16_13 0.031249999999999976
I285 0 n_8_16_14 0.03124999999999998
I286 0 n_8_17_4 1.7741912211512227
I287 0 n_8_17_6 0.06250000000000003
I288 0 n_8_17_7 0.031250000000000014
I289 0 n_8_17_8 0.031250000000000014
I290 0 n_8_17_9 0.031250000000000014
I291 0 n_8_17_10 0.031250000000000014
I292 0 n_8_17_11 0.03125000000000002
I293 0 n_8_17_12 0.031250000000000014
I294 0 n_8_17_13 0.031250000000000014
I295 0 n_8_17_14 0.031250000000000014
I296 0 n_8_18_4 1.7741912211512227
I297 0 n_8_18_6 0.06250000000000003
I298 0 n_8_18_7 0.031250000000000014
I299 0 n_8_18_8 0.031250000000000014
I300 0 n_8_18_9 0.031250000000000014
I301 0 n_8_18_10 0.031250000000000014
I302 0 n_8_18_11 0.03125000000000002
I303 0 n_8_18_12 0.031250000000000014
I304 0 n_8_18_13 0.031250000000000014
I305 0 n_8_18_14 0.031250000000000014
I306 0 n_8_19_4 1.7741912211512205
I307 0 n_8_19_6 0.06249999999999996
I308 0 n_8_19_7 0.031249999999999976
I309 0 n_8_19_8 0.031249999999999976
I310 0 n_8_19_9 0.031249999999999976
I311 0 n_8_19_10 0.031249999999999976
I312 0 n_8_19_11 0.031249999999999983
I313 0 n_8_19_12 0.031249999999999976
I314 0 n_8_19_13 0.031249999999999976
I315 0 n_8_19_14 0.03124999999999998
I316 0 n_8_20_4 0.030883216782703487
I317 0 n_8_21_4 0.030883216782703487
I318 0 n_8_22_4 0.030883216782701294
I319 0 n_8_23_4 0.030883216782703487
I320 0 n_8_24_4 0.681082891185129
I321 0 n_8_25_4 0.6810828911851269
I322 0 n_8_26_4 0.681082891185129
I323 0 n_8_27_4 0.681082891185129
I324 0 n_9_0_4 0.6810829498398829
I325 0 n_9_1_4 0.6810829498398829
I326 0 n_9_2_4 0.6810829498398829
I327 0 n_9_3_4 0.6810829498398829
I328 0 n_9_4_4 0.03088315812794791
I329 0 n_9_5_4 0.030883158127948455
I330 0 n_9_6_4 0.030883158127948455
I331 0 n_9_7_4 0.03088315812794791
I332 0 n_9_8_4 1.7741912211512214
I333 0 n_9_8_6 0.06249999999999998
I334 0 n_9_8_7 0.031249999999999986
I335 0 n_9_8_8 0.031249999999999986
I336 0 n_9_8_9 0.031249999999999986
I337 0 n_9_8_10 0.031249999999999986
I338 0 n_9_8_11 0.03125
I339 0 n_9_8_12 0.031249999999999986
I340 0 n_9_8_13 0.03124999999999999
I341 0 n_9_8_14 0.031249999999999983
I342 0 n_9_9_4 1.7741912211512227
I343 0 n_9_9_6 0.06250000000000003
I344 0 n_9_9_7 0.03125000000000001
I345 0 n_9_9_8 0.03125000000000001
I346 0 n_9_9_9 0.03125000000000001
I347 0 n_9_9_10 0.03125000000000001
I348 0 n_9_9_11 0.03125000000000002
I349 0 n_9_9_12 0.03125000000000001
I350 0 n_9_9_13 0.031250000000000014
I351 0 n_9_9_14 0.03125000000000001
I352 0 n_9_10_4 1.7741912211512214
I353 0 n_9_10_6 0.06249999999999998
I354 0 n_9_10_7 0.031249999999999986
I355 0 n_9_10_8 0.031249999999999986
I356 0 n_9_10_9 0.031249999999999986
I357 0 n_9_10_10 0.031249999999999986
I358 0 n_9_10_11 0.03125
I359 0 n_9_10_12 0.031249999999999986
I360 0 n_9_10_13 0.03124999999999999
I361 0 n_9_10_14 0.031249999999999983
I362 0 n_9_11_4 1.7741912211512214
I363 0 n_9_11_6 0.06249999999999998
I364 0 n_9_11_7 0.031249999999999986
I365 0 n_9_11_8 0.031249999999999986
I366 0 n_9_11_9 0.031249999999999986
I367 0 n_9_11_10 0.031249999999999986
I368 0 n_9_11_11 0.03125
I369 0 n_9_11_12 0.031249999999999986
I370 0 n_9_11_13 0.03124999999999999
I371 0 n_9_11_14 0.031249999999999983
I372 0 n_9_12_4 0.030883211137911436
I373 0 n_9_13_4 0.030883211137911436
I374 0 n_9_14_4 0.030883211137911436
I375 0 n_9_15_4 0.030883211137911436
I376 0 n_9_16_4 1.7741912211512203
I377 0 n_9_16_6 0.062499999999999944
I378 0 n_9_16_7 0.031249999999999972
I379 0 n_9_16_8 0.031249999999999972
I380 0 n_9_16_9 0.031249999999999972
I381 0 n_9_16_10 0.031249999999999972
I382 0 n_9_16_11 0.031249999999999976
I383 0 n_9_16_12 0.031249999999999972
I384 0 n_9_16_13 0.031249999999999972
I385 0 n_9_16_14 0.031249999999999976
I386 0 n_9_17_4 1.7741912211512227
I387 0 n_9_17_6 0.06250000000000003
I388 0 n_9_17_7 0.031250000000000014
I389 0 n_9_17_8 0.031250000000000014
I390 0 n_9_17_9 0.031250000000000014
I391 0 n_9_17_10 0.031250000000000014
I392 0 n_9_17_11 0.03125000000000002
I393 0 n_9_17_12 0.031250000000000014
I394 0 n_9_17_13 0.031250000000000014
I395 0 n_9_17_14 0.031250000000000014
I396 0 n_9_18_4 1.7741912211512227
I397 0 n_9_18_6 0.06250000000000003
I398 0 n_9_18_7 0.031250000000000014
I399 0 n_9_18_8 0.031250000000000014
I400 0 n_9_18_9 0.031250000000000014
I401 0 n_9_18_10 0.031250000000000014
I402 0 n_9_18_11 0.03125000000000002
I403 0 n_9_18_12 0.031250000000000014
I404 0 n_9_18_13 0.031250000000000014
I405 0 n_9_18_14 0.031250000000000014
I406 0 n_9_19_4 1.7741912211512203
I407 0 n_9_19_6 0.062499999999999944
I408 0 n_9_19_7 0.031249999999999972
I409 0 n_9_19_8 0.031249999999999972
I410 0 n_9_19_9 0.031249999999999972
I411 0 n_9_19_10 0.031249999999999972
I412 0 n_9_19_11 0.031249999999999976
I413 0 n_9_19_12 0.031249999999999972
I414 0 n_9_19_13 0.031249999999999972
I415 0 n_9_19_14 0.031249999999999976
I416 0 n_9_20_4 0.030883216782703487
I417 0 n_9_21_4 0.030883216782703487
I418 0 n_9_22_4 0.03088321678270129
I419 0 n_9_23_4 0.030883216782703487
I420 0 n_9_24_4 0.681082891185129
I421 0 n_9_25_4 0.6810828911851269
I422 0 n_9_26_4 0.681082891185129
I423 0 n_9_27_4 0.681082891185129
I424 0 n_10_0_4 0.6810829498398833
I425 0 n_10_1_4 0.6810829498398833
I426 0 n_10_2_4 0.6810829498398833
I427 0 n_10_3_4 0.6810829498398833
I428 0 n_10_4_4 0.030883158127947924
I429 0 n_10_5_4 0.03088315812794848
I430 0 n_10_6_4 0.03088315812794848
I431 0 n_10_7_4 0.030883158127947924
I432 0 n_10_8_4 1.7741912211512223
I433 0 n_10_8_6 0.06250000000000001
I434 0 n_10_8_7 0.03125
I435 0 n_10_8_8 0.03125
I436 0 n_10_8_9 0.03125
I437 0 n_10_8_10 0.03125
I438 0 n_10_8_11 0.031250000000000014
I439 0 n_10_8_12 0.03125000000000001
I440 0 n_10_8_13 0.03125000000000001
I441 0 n_10_8_14 0.03125
I442 0 n_10_9_4 1.7741912211512236
I443 0 n_10_9_6 0.06250000000000006
I444 0 n_10_9_7 0.03125000000000002
I445 0 n_10_9_8 0.03125000000000002
I446 0 n_10_9_9 0.03125000000000002
I447 0 n_10_9_10 0.03125000000000002
I448 0 n_10_9_11 0.031250000000000035
I449 0 n_10_9_12 0.03125000000000002
I450 0 n_10_9_13 0.03125000000000003
I451 0 n_10_9_14 0.03125000000000002
I452 0 n_10_10_4 1.7741912211512223
I453 0 n_10_10_6 0.06250000000000001
I454 0 n_10_10_7 0.03125
I455 0 n_10_10_8 0.03125
I456 0 n_10_10_9 0.03125
I457 0 n_10_10_10 0.03125
I458 0 n_10_10_11 0.031250000000000014
I459 0 n_10_10_12 0.03125000000000001
I460 0 n_10_10_13 0.03125000000000001
I461 0 n_10_10_14 0.03125
I462 0 n_10_11_4 1.7741912211512223
I463 0 n_10_11_6 0.06250000000000001
I464 0 n_10_11_7 0.03125
I465 0 n_10_11_8 0.03125
I466 0 n_10_11_9 0.03125
I467 0 n_10_11_10 0.03125
I468 0 n_10_11_11 0.031250000000000014
I469 0 n_10_11_12 0.03125000000000001
I470 0 n_10_11_13 0.03125000000000001
I471 0 n_10_11_14 0.03125
I472 0 n_10_12_4 0.03088321113791145
I473 0 n_10_13_4 0.03088321113791145
I474 0 n_10_14_4 0.03088321113791145
I475 0 n_10_15_4 0.03088321113791145
I476 0 n_10_16_4 1.7741912211512214
I477 0 n_10_16_6 0.062499999999999965
I478 0 n_10_16_7 0.03124999999999999
I479 0 n_10_16_8 0.03124999999999999
I480 0 n_10_16_9 0.03124999999999999
I481 0 n_10_16_10 0.03124999999999999
I482 0 n_10_16_11 0.031249999999999997
I483 0 n_10_16_12 0.031249999999999986
I484 0 n_10_16_13 0.031249999999999986
I485 0 n_10_16_14 0.031249999999999993
I486 0 n_10_17_4 1.7741912211512236
I487 0 n_10_17_6 0.06250000000000006
I488 0 n_10_17_7 0.03125000000000003
I489 0 n_10_17_8 0.03125000000000003
I490 0 n_10_17_9 0.03125000000000003
I491 0 n_10_17_10 0.03125000000000003
I492 0 n_10_17_11 0.031250000000000035
I493 0 n_10_17_12 0.03125000000000003
I494 0 n_10_17_13 0.03125000000000003
I495 0 n_10_17_14 0.031250000000000035
I496 0 n_10_18_4 1.7741912211512236
I497 0 n_10_18_6 0.06250000000000006
I498 0 n_10_18_7 0.03125000000000003
I499 0 n_10_18_8 0.03125000000000003
I500 0 n_10_18_9 0.03125000000000003
I501 0 n_10_18_10 0.03125000000000003
I502 0 n_10_18_11 0.031250000000000035
I503 0 n_10_18_12 0.03125000000000003
I504 0 n_10_18_13 0.03125000000000003
I505 0 n_10_18_14 0.031250000000000035
I506 0 n_10_19_4 1.7741912211512214
I507 0 n_10_19_6 0.062499999999999965
I508 0 n_10_19_7 0.03124999999999999
I509 0 n_10_19_8 0.03124999999999999
I510 0 n_10_19_9 0.03124999999999999
I511 0 n_10_19_10 0.03124999999999999
I512 0 n_10_19_11 0.031249999999999997
I513 0 n_10_19_12 0.031249999999999986
I514 0 n_10_19_13 0.031249999999999986
I515 0 n_10_19_14 0.031249999999999993
I516 0 n_10_20_4 0.0308832167827035
I517 0 n_10_21_4 0.0308832167827035
I518 0 n_10_22_4 0.030883216782701308
I519 0 n_10_23_4 0.0308832167827035
I520 0 n_10_24_4 0.6810828911851293
I521 0 n_10_25_4 0.6810828911851271
I522 0 n_10_26_4 0.6810828911851293
I523 0 n_10_27_4 0.6810828911851293
I524 0 n_11_0_4 0.6810829498398829
I525 0 n_11_1_4 0.6810829498398829
I526 0 n_11_2_4 0.6810829498398829
I527 0 n_11_3_4 0.6810829498398829
I528 0 n_11_4_4 0.03088315812794791
I529 0 n_11_5_4 0.030883158127948455
I530 0 n_11_6_4 0.030883158127948455
I531 0 n_11_7_4 0.03088315812794791
I532 0 n_11_8_4 1.7741912211512214
I533 0 n_11_8_6 0.06249999999999998
I534 0 n_11_8_7 0.031249999999999986
I535 0 n_11_8_8 0.031249999999999986
I536 0 n_11_8_9 0.031249999999999986
I537 0 n_11_8_10 0.031249999999999986
I538 0 n_11_8_11 0.03125
I539 0 n_11_8_12 0.031249999999999986
I540 0 n_11_8_13 0.03124999999999999
I541 0 n_11_8_14 0.031249999999999983
I542 0 n_11_9_4 1.7741912211512227
I543 0 n_11_9_6 0.06250000000000003
I544 0 n_11_9_7 0.03125000000000001
I545 0 n_11_9_8 0.03125000000000001
I546 0 n_11_9_9 0.03125000000000001
I547 0 n_11_9_10 0.03125000000000001
I548 0 n_11_9_11 0.03125000000000002
I549 0 n_11_9_12 0.03125000000000001
I550 0 n_11_9_13 0.031250000000000014
I551 0 n_11_9_14 0.03125000000000001
I552 0 n_11_10_4 1.7741912211512214
I553 0 n_11_10_6 0.06249999999999998
I554 0 n_11_10_7 0.031249999999999986
I555 0 n_11_10_8 0.031249999999999986
I556 0 n_11_10_9 0.031249999999999986
I557 0 n_11_10_10 0.031249999999999986
I558 0 n_11_10_11 0.03125
I559 0 n_11_10_12 0.031249999999999986
I560 0 n_11_10_13 0.03124999999999999
I561 0 n_11_10_14 0.031249999999999983
I562 0 n_11_11_4 1.7741912211512214
I563 0 n_11_11_6 0.06249999999999998
I564 0 n_11_11_7 0.031249999999999986
I565 0 n_11_11_8 0.031249999999999986
I566 0 n_11_11_9 0.031249999999999986
I567 0 n_11_11_10 0.031249999999999986
I568 0 n_11_11_11 0.03125
I569 0 n_11_11_12 0.031249999999999986
I570 0 n_11_11_13 0.03124999999999999
I571 0 n_11_11_14 0.031249999999999983
I572 0 n_11_12_4 0.030883211137911436
I573 0 n_11_13_4 0.030883211137911436
I574 0 n_11_14_4 0.030883211137911436
I575 0 n_11_15_4 0.030883211137911436
I576 0 n_11_16_4 1.7741912211512203
I577 0 n_11_16_6 0.062499999999999944
I578 0 n_11_16_7 0.031249999999999972
I579 0 n_11_16_8 0.031249999999999972
I580 0 n_11_16_9 0.031249999999999972
I581 0 n_11_16_10 0.031249999999999972
I582 0 n_11_16_11 0.031249999999999976
I583 0 n_11_16_12 0.031249999999999972
I584 0 n_11_16_13 0.031249999999999972
I585 0 n_11_16_14 0.031249999999999976
I586 0 n_11_17_4 1.7741912211512227
I587 0 n_11_17_6 0.06250000000000003
I588 0 n_11_17_7 0.031250000000000014
I589 0 n_11_17_8 0.031250000000000014
I590 0 n_11_17_9 0.031250000000000014
I591 0 n_11_17_10 0.031250000000000014
I592 0 n_11_17_11 0.03125000000000002
I593 0 n_11_17_12 0.031250000000000014
I594 0 n_11_17_13 0.031250000000000014
I595 0 n_11_17_14 0.031250000000000014
I596 0 n_11_18_4 1.7741912211512227
I597 0 n_11_18_6 0.06250000000000003
I598 0 n_11_18_7 0.031250000000000014
I599 0 n_11_18_8 0.031250000000000014
I600 0 n_11_18_9 0.031250000000000014
I601 0 n_11_18_10 0.031250000000000014
I602 0 n_11_18_11 0.03125000000000002
I603 0 n_11_18_12 0.031250000000000014
I604 0 n_11_18_13 0.031250000000000014
I605 0 n_11_18_14 0.031250000000000014
I606 0 n_11_19_4 1.7741912211512203
I607 0 n_11_19_6 0.062499999999999944
I608 0 n_11_19_7 0.031249999999999972
I609 0 n_11_19_8 0.031249999999999972
I610 0 n_11_19_9 0.031249999999999972
I611 0 n_11_19_10 0.031249999999999972
I612 0 n_11_19_11 0.031249999999999976
I613 0 n_11_19_12 0.031249999999999972
I614 0 n_11_19_13 0.031249999999999972
I615 0 n_11_19_14 0.031249999999999976
I616 0 n_11_20_4 0.030883216782703487
I617 0 n_11_21_4 0.030883216782703487
I618 0 n_11_22_4 0.03088321678270129
I619 0 n_11_23_4 0.030883216782703487
I620 0 n_11_24_4 0.681082891185129
I621 0 n_11_25_4 0.6810828911851269
I622 0 n_11_26_4 0.681082891185129
I623 0 n_11_27_4 0.681082891185129
I624 0 n_12_0_4 0.018017566973046586
I625 0 n_12_1_4 0.018017566973046586
I626 0 n_12_2_4 0.018017566973046586
I627 0 n_12_3_4 0.018017566973046586
I628 0 n_12_4_4 0.0008169920712892665
I629 0 n_12_5_4 0.000816992071289281
I630 0 n_12_6_4 0.000816992071289281
I631 0 n_12_7_4 0.0008169920712892665
I632 0 n_12_8_4 0.04693497195546964
I633 0 n_12_9_4 0.046934971955469675
I634 0 n_12_10_4 0.04693497195546964
I635 0 n_12_11_4 0.04693497195546964
I636 0 n_12_12_4 0.0008169934736303006
I637 0 n_12_13_4 0.0008169934736303006
I638 0 n_12_14_4 0.0008169934736303006
I639 0 n_12_15_4 0.0008169934736303006
I640 0 n_12_16_4 0.04693497195546961
I641 0 n_12_17_4 0.046934971955469675
I642 0 n_12_18_4 0.046934971955469675
I643 0 n_12_19_4 0.04693497195546961
I644 0 n_12_20_4 0.0008169936229592754
I645 0 n_12_21_4 0.0008169936229592754
I646 0 n_12_22_4 0.0008169936229592174
I647 0 n_12_23_4 0.0008169936229592754
I648 0 n_12_24_4 0.018017565421376624
I649 0 n_12_25_4 0.018017565421376565
I650 0 n_12_26_4 0.018017565421376624
I651 0 n_12_27_4 0.018017565421376624
I652 0 n_13_0_4 0.018017566973045948
I653 0 n_13_1_4 0.018017566973045948
I654 0 n_13_2_4 0.018017566973045948
I655 0 n_13_3_4 0.018017566973045948
I656 0 n_13_4_4 0.0008169920712892375
I657 0 n_13_5_4 0.0008169920712892523
I658 0 n_13_6_4 0.0008169920712892523
I659 0 n_13_7_4 0.0008169920712892375
I660 0 n_13_8_4 0.04693497195546797
I661 0 n_13_9_4 0.046934971955468
I662 0 n_13_10_4 0.04693497195546797
I663 0 n_13_11_4 0.04693497195546797
I664 0 n_13_12_4 0.0008169934736302714
I665 0 n_13_13_4 0.0008169934736302714
I666 0 n_13_14_4 0.0008169934736302714
I667 0 n_13_15_4 0.0008169934736302714
I668 0 n_13_16_4 0.04693497195546794
I669 0 n_13_17_4 0.046934971955468
I670 0 n_13_18_4 0.046934971955468
I671 0 n_13_19_4 0.04693497195546794
I672 0 n_13_20_4 0.0008169936229592465
I673 0 n_13_21_4 0.0008169936229592465
I674 0 n_13_22_4 0.0008169936229591883
I675 0 n_13_23_4 0.0008169936229592465
I676 0 n_13_24_4 0.018017565421375982
I677 0 n_13_25_4 0.018017565421375926
I678 0 n_13_26_4 0.018017565421375982
I679 0 n_13_27_4 0.018017565421375982
I680 0 n_14_0_4 0.018017566973045948
I681 0 n_14_1_4 0.018017566973045948
I682 0 n_14_2_4 0.018017566973045948
I683 0 n_14_3_4 0.018017566973045948
I684 0 n_14_4_4 0.0008169920712892375
I685 0 n_14_5_4 0.0008169920712892523
I686 0 n_14_6_4 0.0008169920712892523
I687 0 n_14_7_4 0.0008169920712892375
I688 0 n_14_8_4 0.04693497195546797
I689 0 n_14_9_4 0.046934971955468
I690 0 n_14_10_4 0.04693497195546797
I691 0 n_14_11_4 0.04693497195546797
I692 0 n_14_12_4 0.0008169934736302714
I693 0 n_14_13_4 0.0008169934736302714
I694 0 n_14_14_4 0.0008169934736302714
I695 0 n_14_15_4 0.0008169934736302714
I696 0 n_14_16_4 0.04693497195546794
I697 0 n_14_17_4 0.046934971955468
I698 0 n_14_18_4 0.046934971955468
I699 0 n_14_19_4 0.04693497195546794
I700 0 n_14_20_4 0.0008169936229592465
I701 0 n_14_21_4 0.0008169936229592465
I702 0 n_14_22_4 0.0008169936229591883
I703 0 n_14_23_4 0.0008169936229592465
I704 0 n_14_24_4 0.018017565421375982
I705 0 n_14_25_4 0.018017565421375926
I706 0 n_14_26_4 0.018017565421375982
I707 0 n_14_27_4 0.018017565421375982
I708 0 n_15_0_4 0.018017566973046586
I709 0 n_15_1_4 0.018017566973046586
I710 0 n_15_2_4 0.018017566973046586
I711 0 n_15_3_4 0.018017566973046586
I712 0 n_15_4_4 0.0008169920712892665
I713 0 n_15_5_4 0.000816992071289281
I714 0 n_15_6_4 0.000816992071289281
I715 0 n_15_7_4 0.0008169920712892665
I716 0 n_15_8_4 0.04693497195546964
I717 0 n_15_9_4 0.046934971955469675
I718 0 n_15_10_4 0.04693497195546964
I719 0 n_15_11_4 0.04693497195546964
I720 0 n_15_12_4 0.0008169934736303006
I721 0 n_15_13_4 0.0008169934736303006
I722 0 n_15_14_4 0.0008169934736303006
I723 0 n_15_15_4 0.0008169934736303006
I724 0 n_15_16_4 0.04693497195546961
I725 0 n_15_17_4 0.046934971955469675
I726 0 n_15_18_4 0.046934971955469675
I727 0 n_15_19_4 0.04693497195546961
I728 0 n_15_20_4 0.0008169936229592754
I729 0 n_15_21_4 0.0008169936229592754
I730 0 n_15_22_4 0.0008169936229592174
I731 0 n_15_23_4 0.0008169936229592754
I732 0 n_15_24_4 0.018017565421376624
I733 0 n_15_25_4 0.018017565421376565
I734 0 n_15_26_4 0.018017565421376624
I735 0 n_15_27_4 0.018017565421376624
I736 0 n_16_0_4 0.6810829497637246
I737 0 n_16_1_4 0.6810829497637246
I738 0 n_16_2_4 0.6810829497637246
I739 0 n_16_3_4 0.6810829497637246
I740 0 n_16_4_4 0.030883158124494575
I741 0 n_16_5_4 0.03088315812449512
I742 0 n_16_6_4 0.03088315812449512
I743 0 n_16_7_4 0.030883158124494575
I744 0 n_16_8_4 1.7741912209528325
I745 0 n_16_8_6 0.06250000000000003
I746 0 n_16_8_7 0.03125000000000001
I747 0 n_16_8_8 0.03125000000000001
I748 0 n_16_8_9 0.03125000000000001
I749 0 n_16_8_10 0.03125000000000001
I750 0 n_16_8_11 0.03125000000000002
I751 0 n_16_8_12 0.03125000000000001
I752 0 n_16_8_13 0.03125000000000001
I753 0 n_16_8_14 0.031250000000000014
I754 0 n_16_9_4 1.7741912209528334
I755 0 n_16_9_6 0.06250000000000007
I756 0 n_16_9_7 0.03125000000000002
I757 0 n_16_9_8 0.03125000000000002
I758 0 n_16_9_9 0.03125000000000002
I759 0 n_16_9_10 0.03125000000000002
I760 0 n_16_9_11 0.031250000000000035
I761 0 n_16_9_12 0.031250000000000035
I762 0 n_16_9_13 0.03125000000000003
I763 0 n_16_9_14 0.031250000000000035
I764 0 n_16_10_4 1.7741912209528325
I765 0 n_16_10_6 0.06250000000000003
I766 0 n_16_10_7 0.03125000000000001
I767 0 n_16_10_8 0.03125000000000001
I768 0 n_16_10_9 0.03125000000000001
I769 0 n_16_10_10 0.03125000000000001
I770 0 n_16_10_11 0.03125000000000002
I771 0 n_16_10_12 0.03125000000000001
I772 0 n_16_10_13 0.03125000000000001
I773 0 n_16_10_14 0.031250000000000014
I774 0 n_16_11_4 1.7741912209528325
I775 0 n_16_11_6 0.06250000000000003
I776 0 n_16_11_7 0.03125000000000001
I777 0 n_16_11_8 0.03125000000000001
I778 0 n_16_11_9 0.03125000000000001
I779 0 n_16_11_10 0.03125000000000001
I780 0 n_16_11_11 0.03125000000000002
I781 0 n_16_11_12 0.03125000000000001
I782 0 n_16_11_13 0.03125000000000001
I783 0 n_16_11_14 0.031250000000000014
I784 0 n_16_12_4 0.030883211134458095
I785 0 n_16_13_4 0.030883211134458095
I786 0 n_16_14_4 0.030883211134458095
I787 0 n_16_15_4 0.030883211134458095
I788 0 n_16_16_4 1.7741912209528312
I789 0 n_16_16_6 0.06249999999999998
I790 0 n_16_16_7 0.031249999999999997
I791 0 n_16_16_8 0.031249999999999997
I792 0 n_16_16_9 0.031249999999999997
I793 0 n_16_16_10 0.031249999999999997
I794 0 n_16_16_11 0.03125
I795 0 n_16_16_12 0.031249999999999997
I796 0 n_16_16_13 0.03124999999999999
I797 0 n_16_16_14 0.031249999999999997
I798 0 n_16_17_4 1.7741912209528334
I799 0 n_16_17_6 0.06250000000000006
I800 0 n_16_17_7 0.031250000000000035
I801 0 n_16_17_8 0.031250000000000035
I802 0 n_16_17_9 0.031250000000000035
I803 0 n_16_17_10 0.031250000000000035
I804 0 n_16_17_11 0.03125000000000004
I805 0 n_16_17_12 0.031250000000000035
I806 0 n_16_17_13 0.031250000000000035
I807 0 n_16_17_14 0.031250000000000035
I808 0 n_16_18_4 1.7741912209528334
I809 0 n_16_18_6 0.06250000000000006
I810 0 n_16_18_7 0.031250000000000035
I811 0 n_16_18_8 0.031250000000000035
I812 0 n_16_18_9 0.031250000000000035
I813 0 n_16_18_10 0.031250000000000035
I814 0 n_16_18_11 0.03125000000000004
I815 0 n_16_18_12 0.031250000000000035
I816 0 n_16_18_13 0.031250000000000035
I817 0 n_16_18_14 0.031250000000000035
I818 0 n_16_19_4 1.7741912209528312
I819 0 n_16_19_6 0.06249999999999998
I820 0 n_16_19_7 0.031249999999999997
I821 0 n_16_19_8 0.031249999999999997
I822 0 n_16_19_9 0.031249999999999997
I823 0 n_16_19_10 0.031249999999999997
I824 0 n_16_19_11 0.03125
I825 0 n_16_19_12 0.031249999999999997
I826 0 n_16_19_13 0.03124999999999999
I827 0 n_16_19_14 0.031249999999999997
I828 0 n_16_20_4 0.03088321677925014
I829 0 n_16_21_4 0.03088321677925014
I830 0 n_16_22_4 0.030883216779247945
I831 0 n_16_23_4 0.03088321677925014
I832 0 n_16_24_4 0.6810828911089707
I833 0 n_16_25_4 0.6810828911089685
I834 0 n_16_26_4 0.6810828911089707
I835 0 n_16_27_4 0.6810828911089707
I836 0 n_17_0_4 0.6810829497637241
I837 0 n_17_1_4 0.6810829497637241
I838 0 n_17_2_4 0.6810829497637241
I839 0 n_17_3_4 0.6810829497637241
I840 0 n_17_4_4 0.030883158124494544
I841 0 n_17_5_4 0.030883158124495096
I842 0 n_17_6_4 0.030883158124495096
I843 0 n_17_7_4 0.030883158124494544
I844 0 n_17_8_4 1.7741912209528303
I845 0 n_17_8_6 0.062499999999999965
I846 0 n_17_8_7 0.031249999999999972
I847 0 n_17_8_8 0.031249999999999972
I848 0 n_17_8_9 0.031249999999999972
I849 0 n_17_8_10 0.031249999999999972
I850 0 n_17_8_11 0.031249999999999986
I851 0 n_17_8_12 0.031249999999999976
I852 0 n_17_8_13 0.031249999999999976
I853 0 n_17_8_14 0.03124999999999998
I854 0 n_17_9_4 1.7741912209528319
I855 0 n_17_9_6 0.06250000000000001
I856 0 n_17_9_7 0.03124999999999999
I857 0 n_17_9_8 0.03124999999999999
I858 0 n_17_9_9 0.03124999999999999
I859 0 n_17_9_10 0.03124999999999999
I860 0 n_17_9_11 0.03125000000000001
I861 0 n_17_9_12 0.03125
I862 0 n_17_9_13 0.03125
I863 0 n_17_9_14 0.03125
I864 0 n_17_10_4 1.7741912209528303
I865 0 n_17_10_6 0.062499999999999965
I866 0 n_17_10_7 0.031249999999999972
I867 0 n_17_10_8 0.031249999999999972
I868 0 n_17_10_9 0.031249999999999972
I869 0 n_17_10_10 0.031249999999999972
I870 0 n_17_10_11 0.031249999999999986
I871 0 n_17_10_12 0.031249999999999976
I872 0 n_17_10_13 0.031249999999999976
I873 0 n_17_10_14 0.03124999999999998
I874 0 n_17_11_4 1.7741912209528303
I875 0 n_17_11_6 0.062499999999999965
I876 0 n_17_11_7 0.031249999999999972
I877 0 n_17_11_8 0.031249999999999972
I878 0 n_17_11_9 0.031249999999999972
I879 0 n_17_11_10 0.031249999999999972
I880 0 n_17_11_11 0.031249999999999986
I881 0 n_17_11_12 0.031249999999999976
I882 0 n_17_11_13 0.031249999999999976
I883 0 n_17_11_14 0.03124999999999998
I884 0 n_17_12_4 0.03088321113445806
I885 0 n_17_13_4 0.03088321113445806
I886 0 n_17_14_4 0.03088321113445806
I887 0 n_17_15_4 0.03088321113445806
I888 0 n_17_16_4 1.7741912209528294
I889 0 n_17_16_6 0.06249999999999992
I890 0 n_17_16_7 0.031249999999999962
I891 0 n_17_16_8 0.031249999999999962
I892 0 n_17_16_9 0.031249999999999962
I893 0 n_17_16_10 0.031249999999999962
I894 0 n_17_16_11 0.03124999999999997
I895 0 n_17_16_12 0.031249999999999962
I896 0 n_17_16_13 0.031249999999999962
I897 0 n_17_16_14 0.031249999999999962
I898 0 n_17_17_4 1.7741912209528319
I899 0 n_17_17_6 0.0625
I900 0 n_17_17_7 0.03125000000000001
I901 0 n_17_17_8 0.03125000000000001
I902 0 n_17_17_9 0.03125000000000001
I903 0 n_17_17_10 0.03125000000000001
I904 0 n_17_17_11 0.03125000000000001
I905 0 n_17_17_12 0.03125000000000001
I906 0 n_17_17_13 0.03125000000000001
I907 0 n_17_17_14 0.03125000000000001
I908 0 n_17_18_4 1.7741912209528319
I909 0 n_17_18_6 0.0625
I910 0 n_17_18_7 0.03125000000000001
I911 0 n_17_18_8 0.03125000000000001
I912 0 n_17_18_9 0.03125000000000001
I913 0 n_17_18_10 0.03125000000000001
I914 0 n_17_18_11 0.03125000000000001
I915 0 n_17_18_12 0.03125000000000001
I916 0 n_17_18_13 0.03125000000000001
I917 0 n_17_18_14 0.03125000000000001
I918 0 n_17_19_4 1.7741912209528294
I919 0 n_17_19_6 0.06249999999999992
I920 0 n_17_19_7 0.031249999999999962
I921 0 n_17_19_8 0.031249999999999962
I922 0 n_17_19_9 0.031249999999999962
I923 0 n_17_19_10 0.031249999999999962
I924 0 n_17_19_11 0.03124999999999997
I925 0 n_17_19_12 0.031249999999999962
I926 0 n_17_19_13 0.031249999999999962
I927 0 n_17_19_14 0.031249999999999962
I928 0 n_17_20_4 0.030883216779250117
I929 0 n_17_21_4 0.030883216779250117
I930 0 n_17_22_4 0.03088321677924792
I931 0 n_17_23_4 0.030883216779250117
I932 0 n_17_24_4 0.6810828911089701
I933 0 n_17_25_4 0.6810828911089679
I934 0 n_17_26_4 0.6810828911089701
I935 0 n_17_27_4 0.6810828911089701
I936 0 n_18_0_4 0.6810829497637241
I937 0 n_18_1_4 0.6810829497637241
I938 0 n_18_2_4 0.6810829497637241
I939 0 n_18_3_4 0.6810829497637241
I940 0 n_18_4_4 0.030883158124494544
I941 0 n_18_5_4 0.030883158124495096
I942 0 n_18_6_4 0.030883158124495096
I943 0 n_18_7_4 0.030883158124494544
I944 0 n_18_8_4 1.7741912209528303
I945 0 n_18_8_6 0.062499999999999965
I946 0 n_18_8_7 0.031249999999999972
I947 0 n_18_8_8 0.031249999999999972
I948 0 n_18_8_9 0.031249999999999972
I949 0 n_18_8_10 0.031249999999999972
I950 0 n_18_8_11 0.031249999999999986
I951 0 n_18_8_12 0.031249999999999976
I952 0 n_18_8_13 0.031249999999999976
I953 0 n_18_8_14 0.03124999999999998
I954 0 n_18_9_4 1.7741912209528319
I955 0 n_18_9_6 0.06250000000000001
I956 0 n_18_9_7 0.03124999999999999
I957 0 n_18_9_8 0.03124999999999999
I958 0 n_18_9_9 0.03124999999999999
I959 0 n_18_9_10 0.03124999999999999
I960 0 n_18_9_11 0.03125000000000001
I961 0 n_18_9_12 0.03125
I962 0 n_18_9_13 0.03125
I963 0 n_18_9_14 0.03125
I964 0 n_18_10_4 1.7741912209528303
I965 0 n_18_10_6 0.062499999999999965
I966 0 n_18_10_7 0.031249999999999972
I967 0 n_18_10_8 0.031249999999999972
I968 0 n_18_10_9 0.031249999999999972
I969 0 n_18_10_10 0.031249999999999972
I970 0 n_18_10_11 0.031249999999999986
I971 0 n_18_10_12 0.031249999999999976
I972 0 n_18_10_13 0.031249999999999976
I973 0 n_18_10_14 0.03124999999999998
I974 0 n_18_11_4 1.7741912209528303
I975 0 n_18_11_6 0.062499999999999965
I976 0 n_18_11_7 0.031249999999999972
I977 0 n_18_11_8 0.031249999999999972
I978 0 n_18_11_9 0.031249999999999972
I979 0 n_18_11_10 0.031249999999999972
I980 0 n_18_11_11 0.031249999999999986
I981 0 n_18_11_12 0.031249999999999976
I982 0 n_18_11_13 0.031249999999999976
I983 0 n_18_11_14 0.03124999999999998
I984 0 n_18_12_4 0.03088321113445806
I985 0 n_18_13_4 0.03088321113445806
I986 0 n_18_14_4 0.03088321113445806
I987 0 n_18_15_4 0.03088321113445806
I988 0 n_18_16_4 1.7741912209528294
I989 0 n_18_16_6 0.06249999999999992
I990 0 n_18_16_7 0.031249999999999962
I991 0 n_18_16_8 0.031249999999999962
I992 0 n_18_16_9 0.031249999999999962
I993 0 n_18_16_10 0.031249999999999962
I994 0 n_18_16_11 0.03124999999999997
I995 0 n_18_16_12 0.031249999999999962
I996 0 n_18_16_13 0.031249999999999962
I997 0 n_18_16_14 0.031249999999999962
I998 0 n_18_17_4 1.7741912209528319
I999 0 n_18_17_6 0.0625
I1000 0 n_18_17_7 0.03125000000000001
I1001 0 n_18_17_8 0.03125000000000001
I1002 0 n_18_17_9 0.03125000000000001
I1003 0 n_18_17_10 0.03125000000000001
I1004 0 n_18_17_11 0.03125000000000001
I1005 0 n_18_17_12 0.03125000000000001
I1006 0 n_18_17_13 0.03125000000000001
I1007 0 n_18_17_14 0.03125000000000001
I1008 0 n_18_18_4 1.7741912209528319
I1009 0 n_18_18_6 0.0625
I1010 0 n_18_18_7 0.03125000000000001
I1011 0 n_18_18_8 0.03125000000000001
I1012 0 n_18_18_9 0.03125000000000001
I1013 0 n_18_18_10 0.03125000000000001
I1014 0 n_18_18_11 0.03125000000000001
I1015 0 n_18_18_12 0.03125000000000001
I1016 0 n_18_18_13 0.03125000000000001
I1017 0 n_18_18_14 0.03125000000000001
I1018 0 n_18_19_4 1.7741912209528294
I1019 0 n_18_19_6 0.06249999999999992
I1020 0 n_18_19_7 0.031249999999999962
I1021 0 n_18_19_8 0.031249999999999962
I1022 0 n_18_19_9 0.031249999999999962
I1023 0 n_18_19_10 0.031249999999999962
I1024 0 n_18_19_11 0.03124999999999997
I1025 0 n_18_19_12 0.031249999999999962
I1026 0 n_18_19_13 0.031249999999999962
I1027 0 n_18_19_14 0.031249999999999962
I1028 0 n_18_20_4 0.030883216779250117
I1029 0 n_18_21_4 0.030883216779250117
I1030 0 n_18_22_4 0.03088321677924792
I1031 0 n_18_23_4 0.030883216779250117
I1032 0 n_18_24_4 0.6810828911089701
I1033 0 n_18_25_4 0.6810828911089679
I1034 0 n_18_26_4 0.6810828911089701
I1035 0 n_18_27_4 0.6810828911089701
I1036 0 n_19_0_4 0.6810829497637246
I1037 0 n_19_1_4 0.6810829497637246
I1038 0 n_19_2_4 0.6810829497637246
I1039 0 n_19_3_4 0.6810829497637246
I1040 0 n_19_4_4 0.030883158124494575
I1041 0 n_19_5_4 0.03088315812449512
I1042 0 n_19_6_4 0.03088315812449512
I1043 0 n_19_7_4 0.030883158124494575
I1044 0 n_19_8_4 1.7741912209528325
I1045 0 n_19_8_6 0.06250000000000003
I1046 0 n_19_8_7 0.03125000000000001
I1047 0 n_19_8_8 0.03125000000000001
I1048 0 n_19_8_9 0.03125000000000001
I1049 0 n_19_8_10 0.03125000000000001
I1050 0 n_19_8_11 0.03125000000000002
I1051 0 n_19_8_12 0.03125000000000001
I1052 0 n_19_8_13 0.03125000000000001
I1053 0 n_19_8_14 0.031250000000000014
I1054 0 n_19_9_4 1.7741912209528334
I1055 0 n_19_9_6 0.06250000000000007
I1056 0 n_19_9_7 0.03125000000000002
I1057 0 n_19_9_8 0.03125000000000002
I1058 0 n_19_9_9 0.03125000000000002
I1059 0 n_19_9_10 0.03125000000000002
I1060 0 n_19_9_11 0.031250000000000035
I1061 0 n_19_9_12 0.031250000000000035
I1062 0 n_19_9_13 0.03125000000000003
I1063 0 n_19_9_14 0.031250000000000035
I1064 0 n_19_10_4 1.7741912209528325
I1065 0 n_19_10_6 0.06250000000000003
I1066 0 n_19_10_7 0.03125000000000001
I1067 0 n_19_10_8 0.03125000000000001
I1068 0 n_19_10_9 0.03125000000000001
I1069 0 n_19_10_10 0.03125000000000001
I1070 0 n_19_10_11 0.03125000000000002
I1071 0 n_19_10_12 0.03125000000000001
I1072 0 n_19_10_13 0.03125000000000001
I1073 0 n_19_10_14 0.031250000000000014
I1074 0 n_19_11_4 1.7741912209528325
I1075 0 n_19_11_6 0.06250000000000003
I1076 0 n_19_11_7 0.03125000000000001
I1077 0 n_19_11_8 0.03125000000000001
I1078 0 n_19_11_9 0.03125000000000001
I1079 0 n_19_11_10 0.03125000000000001
I1080 0 n_19_11_11 0.03125000000000002
I1081 0 n_19_11_12 0.03125000000000001
I1082 0 n_19_11_13 0.03125000000000001
I1083 0 n_19_11_14 0.031250000000000014
I1084 0 n_19_12_4 0.030883211134458095
I1085 0 n_19_13_4 0.030883211134458095
I1086 0 n_19_14_4 0.030883211134458095
I1087 0 n_19_15_4 0.030883211134458095
I1088 0 n_19_16_4 1.7741912209528312
I1089 0 n_19_16_6 0.06249999999999998
I1090 0 n_19_16_7 0.031249999999999997
I1091 0 n_19_16_8 0.031249999999999997
I1092 0 n_19_16_9 0.031249999999999997
I1093 0 n_19_16_10 0.031249999999999997
I1094 0 n_19_16_11 0.03125
I1095 0 n_19_16_12 0.031249999999999997
I1096 0 n_19_16_13 0.03124999999999999
I1097 0 n_19_16_14 0.031249999999999997
I1098 0 n_19_17_4 1.7741912209528334
I1099 0 n_19_17_6 0.06250000000000006
I1100 0 n_19_17_7 0.031250000000000035
I1101 0 n_19_17_8 0.031250000000000035
I1102 0 n_19_17_9 0.031250000000000035
I1103 0 n_19_17_10 0.031250000000000035
I1104 0 n_19_17_11 0.03125000000000004
I1105 0 n_19_17_12 0.031250000000000035
I1106 0 n_19_17_13 0.031250000000000035
I1107 0 n_19_17_14 0.031250000000000035
I1108 0 n_19_18_4 1.7741912209528334
I1109 0 n_19_18_6 0.06250000000000006
I1110 0 n_19_18_7 0.031250000000000035
I1111 0 n_19_18_8 0.031250000000000035
I1112 0 n_19_18_9 0.031250000000000035
I1113 0 n_19_18_10 0.031250000000000035
I1114 0 n_19_18_11 0.03125000000000004
I1115 0 n_19_18_12 0.031250000000000035
I1116 0 n_19_18_13 0.031250000000000035
I1117 0 n_19_18_14 0.031250000000000035
I1118 0 n_19_19_4 1.7741912209528312
I1119 0 n_19_19_6 0.06249999999999998
I1120 0 n_19_19_7 0.031249999999999997
I1121 0 n_19_19_8 0.031249999999999997
I1122 0 n_19_19_9 0.031249999999999997
I1123 0 n_19_19_10 0.031249999999999997
I1124 0 n_19_19_11 0.03125
I1125 0 n_19_19_12 0.031249999999999997
I1126 0 n_19_19_13 0.03124999999999999
I1127 0 n_19_19_14 0.031249999999999997
I1128 0 n_19_20_4 0.03088321677925014
I1129 0 n_19_21_4 0.03088321677925014
I1130 0 n_19_22_4 0.030883216779247945
I1131 0 n_19_23_4 0.03088321677925014
I1132 0 n_19_24_4 0.6810828911089707
I1133 0 n_19_25_4 0.6810828911089685
I1134 0 n_19_26_4 0.6810828911089707
I1135 0 n_19_27_4 0.6810828911089707
I1136 0 n_20_0_4 0.018017566973046586
I1137 0 n_20_1_4 0.018017566973046586
I1138 0 n_20_2_4 0.018017566973046586
I1139 0 n_20_3_4 0.018017566973046586
I1140 0 n_20_4_4 0.0008169920712892665
I1141 0 n_20_5_4 0.000816992071289281
I1142 0 n_20_6_4 0.000816992071289281
I1143 0 n_20_7_4 0.0008169920712892665
I1144 0 n_20_8_4 0.04693497195546964
I1145 0 n_20_9_4 0.046934971955469675
I1146 0 n_20_10_4 0.04693497195546964
I1147 0 n_20_11_4 0.04693497195546964
I1148 0 n_20_12_4 0.0008169934736303006
I1149 0 n_20_13_4 0.0008169934736303006
I1150 0 n_20_14_4 0.0008169934736303006
I1151 0 n_20_15_4 0.0008169934736303006
I1152 0 n_20_16_4 0.04693497195546961
I1153 0 n_20_17_4 0.046934971955469675
I1154 0 n_20_18_4 0.046934971955469675
I1155 0 n_20_19_4 0.04693497195546961
I1156 0 n_20_20_4 0.0008169936229592754
I1157 0 n_20_21_4 0.0008169936229592754
I1158 0 n_20_22_4 0.0008169936229592174
I1159 0 n_20_23_4 0.0008169936229592754
I1160 0 n_20_24_4 0.018017565421376624
I1161 0 n_20_25_4 0.018017565421376565
I1162 0 n_20_26_4 0.018017565421376624
I1163 0 n_20_27_4 0.018017565421376624
I1164 0 n_21_0_4 0.018017566973046586
I1165 0 n_21_1_4 0.018017566973046586
I1166 0 n_21_2_4 0.018017566973046586
I1167 0 n_21_3_4 0.018017566973046586
I1168 0 n_21_4_4 0.0008169920712892665
I1169 0 n_21_5_4 0.000816992071289281
I1170 0 n_21_6_4 0.000816992071289281
I1171 0 n_21_7_4 0.0008169920712892665
I1172 0 n_21_8_4 0.04693497195546964
I1173 0 n_21_9_4 0.046934971955469675
I1174 0 n_21_10_4 0.04693497195546964
I1175 0 n_21_11_4 0.04693497195546964
I1176 0 n_21_12_4 0.0008169934736303006
I1177 0 n_21_13_4 0.0008169934736303006
I1178 0 n_21_14_4 0.0008169934736303006
I1179 0 n_21_15_4 0.0008169934736303006
I1180 0 n_21_16_4 0.04693497195546961
I1181 0 n_21_17_4 0.046934971955469675
I1182 0 n_21_18_4 0.046934971955469675
I1183 0 n_21_19_4 0.04693497195546961
I1184 0 n_21_20_4 0.0008169936229592754
I1185 0 n_21_21_4 0.0008169936229592754
I1186 0 n_21_22_4 0.0008169936229592174
I1187 0 n_21_23_4 0.0008169936229592754
I1188 0 n_21_24_4 0.018017565421376624
I1189 0 n_21_25_4 0.018017565421376565
I1190 0 n_21_26_4 0.018017565421376624
I1191 0 n_21_27_4 0.018017565421376624
I1192 0 n_22_0_4 0.018017566973046586
I1193 0 n_22_1_4 0.018017566973046586
I1194 0 n_22_2_4 0.018017566973046586
I1195 0 n_22_3_4 0.018017566973046586
I1196 0 n_22_4_4 0.0008169920712892665
I1197 0 n_22_5_4 0.000816992071289281
I1198 0 n_22_6_4 0.000816992071289281
I1199 0 n_22_7_4 0.0008169920712892665
I1200 0 n_22_8_4 0.04693497195546964
I1201 0 n_22_9_4 0.046934971955469675
I1202 0 n_22_10_4 0.04693497195546964
I1203 0 n_22_11_4 0.04693497195546964
I1204 0 n_22_12_4 0.0008169934736303006
I1205 0 n_22_13_4 0.0008169934736303006
I1206 0 n_22_14_4 0.0008169934736303006
I1207 0 n_22_15_4 0.0008169934736303006
I1208 0 n_22_16_4 0.04693497195546961
I1209 0 n_22_17_4 0.046934971955469675
I1210 0 n_22_18_4 0.046934971955469675
I1211 0 n_22_19_4 0.04693497195546961
I1212 0 n_22_20_4 0.0008169936229592754
I1213 0 n_22_21_4 0.0008169936229592754
I1214 0 n_22_22_4 0.0008169936229592174
I1215 0 n_22_23_4 0.0008169936229592754
I1216 0 n_22_24_4 0.018017565421376624
I1217 0 n_22_25_4 0.018017565421376565
I1218 0 n_22_26_4 0.018017565421376624
I1219 0 n_22_27_4 0.018017565421376624
I1220 0 n_23_0_4 0.018017566973046586
I1221 0 n_23_1_4 0.018017566973046586
I1222 0 n_23_2_4 0.018017566973046586
I1223 0 n_23_3_4 0.018017566973046586
I1224 0 n_23_4_4 0.0008169920712892665
I1225 0 n_23_5_4 0.000816992071289281
I1226 0 n_23_6_4 0.000816992071289281
I1227 0 n_23_7_4 0.0008169920712892665
I1228 0 n_23_8_4 0.04693497195546964
I1229 0 n_23_9_4 0.046934971955469675
I1230 0 n_23_10_4 0.04693497195546964
I1231 0 n_23_11_4 0.04693497195546964
I1232 0 n_23_12_4 0.0008169934736303006
I1233 0 n_23_13_4 0.0008169934736303006
I1234 0 n_23_14_4 0.0008169934736303006
I1235 0 n_23_15_4 0.0008169934736303006
I1236 0 n_23_16_4 0.04693497195546961
I1237 0 n_23_17_4 0.046934971955469675
I1238 0 n_23_18_4 0.046934971955469675
I1239 0 n_23_19_4 0.04693497195546961
I1240 0 n_23_20_4 0.0008169936229592754
I1241 0 n_23_21_4 0.0008169936229592754
I1242 0 n_23_22_4 0.0008169936229592174
I1243 0 n_23_23_4 0.0008169936229592754
I1244 0 n_23_24_4 0.018017565421376624
I1245 0 n_23_25_4 0.018017565421376565
I1246 0 n_23_26_4 0.018017565421376624
I1247 0 n_23_27_4 0.018017565421376624
I1248 0 n_24_0_4 0.6810829497637246
I1249 0 n_24_1_4 0.6810829497637246
I1250 0 n_24_2_4 0.6810829497637246
I1251 0 n_24_3_4 0.6810829497637246
I1252 0 n_24_4_4 0.030883158124494575
I1253 0 n_24_5_4 0.03088315812449512
I1254 0 n_24_6_4 0.03088315812449512
I1255 0 n_24_7_4 0.030883158124494575
I1256 0 n_24_8_4 1.7741912209528325
I1257 0 n_24_8_6 0.06250000000000003
I1258 0 n_24_8_7 0.03125000000000001
I1259 0 n_24_8_8 0.03125000000000001
I1260 0 n_24_8_9 0.03125000000000001
I1261 0 n_24_8_10 0.03125000000000001
I1262 0 n_24_8_11 0.03125000000000002
I1263 0 n_24_8_12 0.03125000000000001
I1264 0 n_24_8_13 0.03125000000000002
I1265 0 n_24_8_14 0.03125000000000001
I1266 0 n_24_9_4 1.7741912209528334
I1267 0 n_24_9_6 0.06250000000000007
I1268 0 n_24_9_7 0.03125000000000002
I1269 0 n_24_9_8 0.03125000000000002
I1270 0 n_24_9_9 0.03125000000000002
I1271 0 n_24_9_10 0.03125000000000002
I1272 0 n_24_9_11 0.031250000000000035
I1273 0 n_24_9_12 0.03125000000000003
I1274 0 n_24_9_13 0.031250000000000035
I1275 0 n_24_9_14 0.03125000000000003
I1276 0 n_24_10_4 1.7741912209528325
I1277 0 n_24_10_6 0.06250000000000003
I1278 0 n_24_10_7 0.03125000000000001
I1279 0 n_24_10_8 0.03125000000000001
I1280 0 n_24_10_9 0.03125000000000001
I1281 0 n_24_10_10 0.03125000000000001
I1282 0 n_24_10_11 0.03125000000000002
I1283 0 n_24_10_12 0.03125000000000001
I1284 0 n_24_10_13 0.03125000000000002
I1285 0 n_24_10_14 0.03125000000000001
I1286 0 n_24_11_4 1.7741912209528325
I1287 0 n_24_11_6 0.06250000000000003
I1288 0 n_24_11_7 0.03125000000000001
I1289 0 n_24_11_8 0.03125000000000001
I1290 0 n_24_11_9 0.03125000000000001
I1291 0 n_24_11_10 0.03125000000000001
I1292 0 n_24_11_11 0.03125000000000002
I1293 0 n_24_11_12 0.03125000000000001
I1294 0 n_24_11_13 0.03125000000000002
I1295 0 n_24_11_14 0.03125000000000001
I1296 0 n_24_12_4 0.030883211134458095
I1297 0 n_24_13_4 0.030883211134458095
I1298 0 n_24_14_4 0.030883211134458095
I1299 0 n_24_15_4 0.030883211134458095
I1300 0 n_24_16_4 1.7741912209528312
I1301 0 n_24_16_6 0.062499999999999986
I1302 0 n_24_16_7 0.03124999999999999
I1303 0 n_24_16_8 0.03124999999999999
I1304 0 n_24_16_9 0.03124999999999999
I1305 0 n_24_16_10 0.03124999999999999
I1306 0 n_24_16_11 0.031249999999999997
I1307 0 n_24_16_12 0.031249999999999997
I1308 0 n_24_16_13 0.03124999999999999
I1309 0 n_24_16_14 0.031249999999999997
I1310 0 n_24_17_4 1.7741912209528334
I1311 0 n_24_17_6 0.06250000000000007
I1312 0 n_24_17_7 0.031250000000000035
I1313 0 n_24_17_8 0.031250000000000035
I1314 0 n_24_17_9 0.031250000000000035
I1315 0 n_24_17_10 0.031250000000000035
I1316 0 n_24_17_11 0.031250000000000035
I1317 0 n_24_17_12 0.031250000000000035
I1318 0 n_24_17_13 0.031250000000000035
I1319 0 n_24_17_14 0.031250000000000035
I1320 0 n_24_18_4 1.7741912209528334
I1321 0 n_24_18_6 0.06250000000000007
I1322 0 n_24_18_7 0.031250000000000035
I1323 0 n_24_18_8 0.031250000000000035
I1324 0 n_24_18_9 0.031250000000000035
I1325 0 n_24_18_10 0.031250000000000035
I1326 0 n_24_18_11 0.031250000000000035
I1327 0 n_24_18_12 0.031250000000000035
I1328 0 n_24_18_13 0.031250000000000035
I1329 0 n_24_18_14 0.031250000000000035
I1330 0 n_24_19_4 1.7741912209528312
I1331 0 n_24_19_6 0.062499999999999986
I1332 0 n_24_19_7 0.03124999999999999
I1333 0 n_24_19_8 0.03124999999999999
I1334 0 n_24_19_9 0.03124999999999999
I1335 0 n_24_19_10 0.03124999999999999
I1336 0 n_24_19_11 0.031249999999999997
I1337 0 n_24_19_12 0.031249999999999997
I1338 0 n_24_19_13 0.03124999999999999
I1339 0 n_24_19_14 0.031249999999999997
I1340 0 n_24_20_4 0.03088321677925014
I1341 0 n_24_21_4 0.03088321677925014
I1342 0 n_24_22_4 0.030883216779247945
I1343 0 n_24_23_4 0.03088321677925014
I1344 0 n_24_24_4 0.6810828911089707
I1345 0 n_24_25_4 0.6810828911089685
I1346 0 n_24_26_4 0.6810828911089707
I1347 0 n_24_27_4 0.6810828911089707
I1348 0 n_25_0_4 0.6810829497637246
I1349 0 n_25_1_4 0.6810829497637246
I1350 0 n_25_2_4 0.6810829497637246
I1351 0 n_25_3_4 0.6810829497637246
I1352 0 n_25_4_4 0.030883158124494575
I1353 0 n_25_5_4 0.03088315812449512
I1354 0 n_25_6_4 0.03088315812449512
I1355 0 n_25_7_4 0.030883158124494575
I1356 0 n_25_8_4 1.7741912209528325
I1357 0 n_25_8_6 0.06250000000000003
I1358 0 n_25_8_7 0.03125000000000001
I1359 0 n_25_8_8 0.03125000000000001
I1360 0 n_25_8_9 0.03125000000000001
I1361 0 n_25_8_10 0.03125000000000001
I1362 0 n_25_8_11 0.03125000000000002
I1363 0 n_25_8_12 0.03125000000000001
I1364 0 n_25_8_13 0.03125000000000002
I1365 0 n_25_8_14 0.03125000000000001
I1366 0 n_25_9_4 1.7741912209528334
I1367 0 n_25_9_6 0.06250000000000007
I1368 0 n_25_9_7 0.03125000000000002
I1369 0 n_25_9_8 0.03125000000000002
I1370 0 n_25_9_9 0.03125000000000002
I1371 0 n_25_9_10 0.03125000000000002
I1372 0 n_25_9_11 0.031250000000000035
I1373 0 n_25_9_12 0.03125000000000003
I1374 0 n_25_9_13 0.031250000000000035
I1375 0 n_25_9_14 0.03125000000000003
I1376 0 n_25_10_4 1.7741912209528325
I1377 0 n_25_10_6 0.06250000000000003
I1378 0 n_25_10_7 0.03125000000000001
I1379 0 n_25_10_8 0.03125000000000001
I1380 0 n_25_10_9 0.03125000000000001
I1381 0 n_25_10_10 0.03125000000000001
I1382 0 n_25_10_11 0.03125000000000002
I1383 0 n_25_10_12 0.03125000000000001
I1384 0 n_25_10_13 0.03125000000000002
I1385 0 n_25_10_14 0.03125000000000001
I1386 0 n_25_11_4 1.7741912209528325
I1387 0 n_25_11_6 0.06250000000000003
I1388 0 n_25_11_7 0.03125000000000001
I1389 0 n_25_11_8 0.03125000000000001
I1390 0 n_25_11_9 0.03125000000000001
I1391 0 n_25_11_10 0.03125000000000001
I1392 0 n_25_11_11 0.03125000000000002
I1393 0 n_25_11_12 0.03125000000000001
I1394 0 n_25_11_13 0.03125000000000002
I1395 0 n_25_11_14 0.03125000000000001
I1396 0 n_25_12_4 0.030883211134458095
I1397 0 n_25_13_4 0.030883211134458095
I1398 0 n_25_14_4 0.030883211134458095
I1399 0 n_25_15_4 0.030883211134458095
I1400 0 n_25_16_4 1.7741912209528312
I1401 0 n_25_16_6 0.062499999999999986
I1402 0 n_25_16_7 0.03124999999999999
I1403 0 n_25_16_8 0.03124999999999999
I1404 0 n_25_16_9 0.03124999999999999
I1405 0 n_25_16_10 0.03124999999999999
I1406 0 n_25_16_11 0.031249999999999997
I1407 0 n_25_16_12 0.031249999999999997
I1408 0 n_25_16_13 0.03124999999999999
I1409 0 n_25_16_14 0.031249999999999997
I1410 0 n_25_17_4 1.7741912209528334
I1411 0 n_25_17_6 0.06250000000000007
I1412 0 n_25_17_7 0.031250000000000035
I1413 0 n_25_17_8 0.031250000000000035
I1414 0 n_25_17_9 0.031250000000000035
I1415 0 n_25_17_10 0.031250000000000035
I1416 0 n_25_17_11 0.031250000000000035
I1417 0 n_25_17_12 0.031250000000000035
I1418 0 n_25_17_13 0.031250000000000035
I1419 0 n_25_17_14 0.031250000000000035
I1420 0 n_25_18_4 1.7741912209528334
I1421 0 n_25_18_6 0.06250000000000007
I1422 0 n_25_18_7 0.031250000000000035
I1423 0 n_25_18_8 0.031250000000000035
I1424 0 n_25_18_9 0.031250000000000035
I1425 0 n_25_18_10 0.031250000000000035
I1426 0 n_25_18_11 0.031250000000000035
I1427 0 n_25_18_12 0.031250000000000035
I1428 0 n_25_18_13 0.031250000000000035
I1429 0 n_25_18_14 0.031250000000000035
I1430 0 n_25_19_4 1.7741912209528312
I1431 0 n_25_19_6 0.062499999999999986
I1432 0 n_25_19_7 0.03124999999999999
I1433 0 n_25_19_8 0.03124999999999999
I1434 0 n_25_19_9 0.03124999999999999
I1435 0 n_25_19_10 0.03124999999999999
I1436 0 n_25_19_11 0.031249999999999997
I1437 0 n_25_19_12 0.031249999999999997
I1438 0 n_25_19_13 0.03124999999999999
I1439 0 n_25_19_14 0.031249999999999997
I1440 0 n_25_20_4 0.03088321677925014
I1441 0 n_25_21_4 0.03088321677925014
I1442 0 n_25_22_4 0.030883216779247945
I1443 0 n_25_23_4 0.03088321677925014
I1444 0 n_25_24_4 0.6810828911089707
I1445 0 n_25_25_4 0.6810828911089685
I1446 0 n_25_26_4 0.6810828911089707
I1447 0 n_25_27_4 0.6810828911089707
I1448 0 n_26_0_4 0.6810829497637232
I1449 0 n_26_1_4 0.6810829497637232
I1450 0 n_26_2_4 0.6810829497637232
I1451 0 n_26_3_4 0.6810829497637232
I1452 0 n_26_4_4 0.030883158124494513
I1453 0 n_26_5_4 0.03088315812449506
I1454 0 n_26_6_4 0.03088315812449506
I1455 0 n_26_7_4 0.030883158124494513
I1456 0 n_26_8_4 1.7741912209528288
I1457 0 n_26_8_6 0.0624999999999999
I1458 0 n_26_8_7 0.03124999999999994
I1459 0 n_26_8_8 0.03124999999999994
I1460 0 n_26_8_9 0.03124999999999994
I1461 0 n_26_8_10 0.03124999999999994
I1462 0 n_26_8_11 0.031249999999999955
I1463 0 n_26_8_12 0.031249999999999944
I1464 0 n_26_8_13 0.03124999999999996
I1465 0 n_26_8_14 0.031249999999999948
I1466 0 n_26_9_4 1.77419122095283
I1467 0 n_26_9_6 0.062499999999999944
I1468 0 n_26_9_7 0.031249999999999962
I1469 0 n_26_9_8 0.031249999999999962
I1470 0 n_26_9_9 0.031249999999999962
I1471 0 n_26_9_10 0.031249999999999962
I1472 0 n_26_9_11 0.031249999999999976
I1473 0 n_26_9_12 0.031249999999999962
I1474 0 n_26_9_13 0.031249999999999976
I1475 0 n_26_9_14 0.03124999999999997
I1476 0 n_26_10_4 1.7741912209528288
I1477 0 n_26_10_6 0.0624999999999999
I1478 0 n_26_10_7 0.03124999999999994
I1479 0 n_26_10_8 0.03124999999999994
I1480 0 n_26_10_9 0.03124999999999994
I1481 0 n_26_10_10 0.03124999999999994
I1482 0 n_26_10_11 0.031249999999999955
I1483 0 n_26_10_12 0.031249999999999944
I1484 0 n_26_10_13 0.03124999999999996
I1485 0 n_26_10_14 0.031249999999999948
I1486 0 n_26_11_4 1.7741912209528288
I1487 0 n_26_11_6 0.0624999999999999
I1488 0 n_26_11_7 0.03124999999999994
I1489 0 n_26_11_8 0.03124999999999994
I1490 0 n_26_11_9 0.03124999999999994
I1491 0 n_26_11_10 0.03124999999999994
I1492 0 n_26_11_11 0.031249999999999955
I1493 0 n_26_11_12 0.031249999999999944
I1494 0 n_26_11_13 0.03124999999999996
I1495 0 n_26_11_14 0.031249999999999948
I1496 0 n_26_12_4 0.030883211134458032
I1497 0 n_26_13_4 0.030883211134458032
I1498 0 n_26_14_4 0.030883211134458032
I1499 0 n_26_15_4 0.030883211134458032
I1500 0 n_26_16_4 1.7741912209528279
I1501 0 n_26_16_6 0.062499999999999875
I1502 0 n_26_16_7 0.031249999999999938
I1503 0 n_26_16_8 0.031249999999999938
I1504 0 n_26_16_9 0.031249999999999938
I1505 0 n_26_16_10 0.031249999999999938
I1506 0 n_26_16_11 0.03124999999999994
I1507 0 n_26_16_12 0.031249999999999938
I1508 0 n_26_16_13 0.031249999999999938
I1509 0 n_26_16_14 0.031249999999999938
I1510 0 n_26_17_4 1.77419122095283
I1511 0 n_26_17_6 0.062499999999999944
I1512 0 n_26_17_7 0.031249999999999972
I1513 0 n_26_17_8 0.031249999999999972
I1514 0 n_26_17_9 0.031249999999999972
I1515 0 n_26_17_10 0.031249999999999972
I1516 0 n_26_17_11 0.031249999999999976
I1517 0 n_26_17_12 0.031249999999999972
I1518 0 n_26_17_13 0.031249999999999972
I1519 0 n_26_17_14 0.031249999999999976
I1520 0 n_26_18_4 1.77419122095283
I1521 0 n_26_18_6 0.062499999999999944
I1522 0 n_26_18_7 0.031249999999999972
I1523 0 n_26_18_8 0.031249999999999972
I1524 0 n_26_18_9 0.031249999999999972
I1525 0 n_26_18_10 0.031249999999999972
I1526 0 n_26_18_11 0.031249999999999976
I1527 0 n_26_18_12 0.031249999999999972
I1528 0 n_26_18_13 0.031249999999999972
I1529 0 n_26_18_14 0.031249999999999976
I1530 0 n_26_19_4 1.7741912209528279
I1531 0 n_26_19_6 0.062499999999999875
I1532 0 n_26_19_7 0.031249999999999938
I1533 0 n_26_19_8 0.031249999999999938
I1534 0 n_26_19_9 0.031249999999999938
I1535 0 n_26_19_10 0.031249999999999938
I1536 0 n_26_19_11 0.03124999999999994
I1537 0 n_26_19_12 0.031249999999999938
I1538 0 n_26_19_13 0.031249999999999938
I1539 0 n_26_19_14 0.031249999999999938
I1540 0 n_26_20_4 0.030883216779250083
I1541 0 n_26_21_4 0.030883216779250083
I1542 0 n_26_22_4 0.030883216779247886
I1543 0 n_26_23_4 0.030883216779250083
I1544 0 n_26_24_4 0.6810828911089692
I1545 0 n_26_25_4 0.6810828911089671
I1546 0 n_26_26_4 0.6810828911089692
I1547 0 n_26_27_4 0.6810828911089692
I1548 0 n_27_0_4 0.6810829497637246
I1549 0 n_27_1_4 0.6810829497637246
I1550 0 n_27_2_4 0.6810829497637246
I1551 0 n_27_3_4 0.6810829497637246
I1552 0 n_27_4_4 0.030883158124494575
I1553 0 n_27_5_4 0.03088315812449512
I1554 0 n_27_6_4 0.03088315812449512
I1555 0 n_27_7_4 0.030883158124494575
I1556 0 n_27_8_4 1.7741912209528325
I1557 0 n_27_8_6 0.06250000000000003
I1558 0 n_27_8_7 0.03125000000000001
I1559 0 n_27_8_8 0.03125000000000001
I1560 0 n_27_8_9 0.03125000000000001
I1561 0 n_27_8_10 0.03125000000000001
I1562 0 n_27_8_11 0.03125000000000002
I1563 0 n_27_8_12 0.03125000000000001
I1564 0 n_27_8_13 0.03125000000000002
I1565 0 n_27_8_14 0.03125000000000001
I1566 0 n_27_9_4 1.7741912209528334
I1567 0 n_27_9_6 0.06250000000000007
I1568 0 n_27_9_7 0.03125000000000002
I1569 0 n_27_9_8 0.03125000000000002
I1570 0 n_27_9_9 0.03125000000000002
I1571 0 n_27_9_10 0.03125000000000002
I1572 0 n_27_9_11 0.031250000000000035
I1573 0 n_27_9_12 0.03125000000000003
I1574 0 n_27_9_13 0.031250000000000035
I1575 0 n_27_9_14 0.03125000000000003
I1576 0 n_27_10_4 1.7741912209528325
I1577 0 n_27_10_6 0.06250000000000003
I1578 0 n_27_10_7 0.03125000000000001
I1579 0 n_27_10_8 0.03125000000000001
I1580 0 n_27_10_9 0.03125000000000001
I1581 0 n_27_10_10 0.03125000000000001
I1582 0 n_27_10_11 0.03125000000000002
I1583 0 n_27_10_12 0.03125000000000001
I1584 0 n_27_10_13 0.03125000000000002
I1585 0 n_27_10_14 0.03125000000000001
I1586 0 n_27_11_4 1.7741912209528325
I1587 0 n_27_11_6 0.06250000000000003
I1588 0 n_27_11_7 0.03125000000000001
I1589 0 n_27_11_8 0.03125000000000001
I1590 0 n_27_11_9 0.03125000000000001
I1591 0 n_27_11_10 0.03125000000000001
I1592 0 n_27_11_11 0.03125000000000002
I1593 0 n_27_11_12 0.03125000000000001
I1594 0 n_27_11_13 0.03125000000000002
I1595 0 n_27_11_14 0.03125000000000001
I1596 0 n_27_12_4 0.030883211134458095
I1597 0 n_27_13_4 0.030883211134458095
I1598 0 n_27_14_4 0.030883211134458095
I1599 0 n_27_15_4 0.030883211134458095
I1600 0 n_27_16_4 1.7741912209528312
I1601 0 n_27_16_6 0.062499999999999986
I1602 0 n_27_16_7 0.03124999999999999
I1603 0 n_27_16_8 0.03124999999999999
I1604 0 n_27_16_9 0.03124999999999999
I1605 0 n_27_16_10 0.03124999999999999
I1606 0 n_27_16_11 0.031249999999999997
I1607 0 n_27_16_12 0.031249999999999997
I1608 0 n_27_16_13 0.03124999999999999
I1609 0 n_27_16_14 0.031249999999999997
I1610 0 n_27_17_4 1.7741912209528334
I1611 0 n_27_17_6 0.06250000000000007
I1612 0 n_27_17_7 0.031250000000000035
I1613 0 n_27_17_8 0.031250000000000035
I1614 0 n_27_17_9 0.031250000000000035
I1615 0 n_27_17_10 0.031250000000000035
I1616 0 n_27_17_11 0.031250000000000035
I1617 0 n_27_17_12 0.031250000000000035
I1618 0 n_27_17_13 0.031250000000000035
I1619 0 n_27_17_14 0.031250000000000035
I1620 0 n_27_18_4 1.7741912209528334
I1621 0 n_27_18_6 0.06250000000000007
I1622 0 n_27_18_7 0.031250000000000035
I1623 0 n_27_18_8 0.031250000000000035
I1624 0 n_27_18_9 0.031250000000000035
I1625 0 n_27_18_10 0.031250000000000035
I1626 0 n_27_18_11 0.031250000000000035
I1627 0 n_27_18_12 0.031250000000000035
I1628 0 n_27_18_13 0.031250000000000035
I1629 0 n_27_18_14 0.031250000000000035
I1630 0 n_27_19_4 1.7741912209528312
I1631 0 n_27_19_6 0.062499999999999986
I1632 0 n_27_19_7 0.03124999999999999
I1633 0 n_27_19_8 0.03124999999999999
I1634 0 n_27_19_9 0.03124999999999999
I1635 0 n_27_19_10 0.03124999999999999
I1636 0 n_27_19_11 0.031249999999999997
I1637 0 n_27_19_12 0.031249999999999997
I1638 0 n_27_19_13 0.03124999999999999
I1639 0 n_27_19_14 0.031249999999999997
I1640 0 n_27_20_4 0.03088321677925014
I1641 0 n_27_21_4 0.03088321677925014
I1642 0 n_27_22_4 0.030883216779247945
I1643 0 n_27_23_4 0.03088321677925014
I1644 0 n_27_24_4 0.6810828911089707
I1645 0 n_27_25_4 0.6810828911089685
I1646 0 n_27_26_4 0.6810828911089707
I1647 0 n_27_27_4 0.6810828911089707
I1648 0 n_28_0_4 0.018017566973046586
I1649 0 n_28_1_4 0.018017566973046586
I1650 0 n_28_2_4 0.018017566973046586
I1651 0 n_28_3_4 0.018017566973046586
I1652 0 n_28_4_4 0.0008169920712892665
I1653 0 n_28_5_4 0.000816992071289281
I1654 0 n_28_6_4 0.000816992071289281
I1655 0 n_28_7_4 0.0008169920712892665
I1656 0 n_28_8_4 0.04693497195546964
I1657 0 n_28_9_4 0.046934971955469675
I1658 0 n_28_10_4 0.04693497195546964
I1659 0 n_28_11_4 0.04693497195546964
I1660 0 n_28_12_4 0.0008169934736303006
I1661 0 n_28_13_4 0.0008169934736303006
I1662 0 n_28_14_4 0.0008169934736303006
I1663 0 n_28_15_4 0.0008169934736303006
I1664 0 n_28_16_4 0.04693497195546961
I1665 0 n_28_17_4 0.046934971955469675
I1666 0 n_28_18_4 0.046934971955469675
I1667 0 n_28_19_4 0.04693497195546961
I1668 0 n_28_20_4 0.0008169936229592754
I1669 0 n_28_21_4 0.0008169936229592754
I1670 0 n_28_22_4 0.0008169936229592174
I1671 0 n_28_23_4 0.0008169936229592754
I1672 0 n_28_24_4 0.018017565421376624
I1673 0 n_28_25_4 0.018017565421376565
I1674 0 n_28_26_4 0.018017565421376624
I1675 0 n_28_27_4 0.018017565421376624
I1676 0 n_29_0_4 0.01801756697304531
I1677 0 n_29_1_4 0.01801756697304531
I1678 0 n_29_2_4 0.01801756697304531
I1679 0 n_29_3_4 0.01801756697304531
I1680 0 n_29_4_4 0.0008169920712892086
I1681 0 n_29_5_4 0.0008169920712892231
I1682 0 n_29_6_4 0.0008169920712892231
I1683 0 n_29_7_4 0.0008169920712892086
I1684 0 n_29_8_4 0.0469349719554663
I1685 0 n_29_9_4 0.046934971955466344
I1686 0 n_29_10_4 0.0469349719554663
I1687 0 n_29_11_4 0.0469349719554663
I1688 0 n_29_12_4 0.0008169934736302424
I1689 0 n_29_13_4 0.0008169934736302424
I1690 0 n_29_14_4 0.0008169934736302424
I1691 0 n_29_15_4 0.0008169934736302424
I1692 0 n_29_16_4 0.046934971955466274
I1693 0 n_29_17_4 0.046934971955466344
I1694 0 n_29_18_4 0.046934971955466344
I1695 0 n_29_19_4 0.046934971955466274
I1696 0 n_29_20_4 0.0008169936229592174
I1697 0 n_29_21_4 0.0008169936229592174
I1698 0 n_29_22_4 0.0008169936229591594
I1699 0 n_29_23_4 0.0008169936229592174
I1700 0 n_29_24_4 0.018017565421375344
I1701 0 n_29_25_4 0.01801756542137528
I1702 0 n_29_26_4 0.018017565421375344
I1703 0 n_29_27_4 0.018017565421375344
I1704 0 n_30_0_4 0.018017566973046586
I1705 0 n_30_1_4 0.018017566973046586
I1706 0 n_30_2_4 0.018017566973046586
I1707 0 n_30_3_4 0.018017566973046586
I1708 0 n_30_4_4 0.0008169920712892665
I1709 0 n_30_5_4 0.000816992071289281
I1710 0 n_30_6_4 0.000816992071289281
I1711 0 n_30_7_4 0.0008169920712892665
I1712 0 n_30_8_4 0.04693497195546964
I1713 0 n_30_9_4 0.046934971955469675
I1714 0 n_30_10_4 0.04693497195546964
I1715 0 n_30_11_4 0.04693497195546964
I1716 0 n_30_12_4 0.0008169934736303006
I1717 0 n_30_13_4 0.0008169934736303006
I1718 0 n_30_14_4 0.0008169934736303006
I1719 0 n_30_15_4 0.0008169934736303006
I1720 0 n_30_16_4 0.04693497195546961
I1721 0 n_30_17_4 0.046934971955469675
I1722 0 n_30_18_4 0.046934971955469675
I1723 0 n_30_19_4 0.04693497195546961
I1724 0 n_30_20_4 0.0008169936229592754
I1725 0 n_30_21_4 0.0008169936229592754
I1726 0 n_30_22_4 0.0008169936229592174
I1727 0 n_30_23_4 0.0008169936229592754
I1728 0 n_30_24_4 0.018017565421376624
I1729 0 n_30_25_4 0.018017565421376565
I1730 0 n_30_26_4 0.018017565421376624
I1731 0 n_30_27_4 0.018017565421376624
I1732 0 n_31_0_4 0.018017566973046586
I1733 0 n_31_1_4 0.018017566973046586
I1734 0 n_31_2_4 0.018017566973046586
I1735 0 n_31_3_4 0.018017566973046586
I1736 0 n_31_4_4 0.0008169920712892665
I1737 0 n_31_5_4 0.000816992071289281
I1738 0 n_31_6_4 0.000816992071289281
I1739 0 n_31_7_4 0.0008169920712892665
I1740 0 n_31_8_4 0.04693497195546964
I1741 0 n_31_9_4 0.046934971955469675
I1742 0 n_31_10_4 0.04693497195546964
I1743 0 n_31_11_4 0.04693497195546964
I1744 0 n_31_12_4 0.0008169934736303006
I1745 0 n_31_13_4 0.0008169934736303006
I1746 0 n_31_14_4 0.0008169934736303006
I1747 0 n_31_15_4 0.0008169934736303006
I1748 0 n_31_16_4 0.04693497195546961
I1749 0 n_31_17_4 0.046934971955469675
I1750 0 n_31_18_4 0.046934971955469675
I1751 0 n_31_19_4 0.04693497195546961
I1752 0 n_31_20_4 0.0008169936229592754
I1753 0 n_31_21_4 0.0008169936229592754
I1754 0 n_31_22_4 0.0008169936229592174
I1755 0 n_31_23_4 0.0008169936229592754
I1756 0 n_31_24_4 0.018017565421376624
I1757 0 n_31_25_4 0.018017565421376565
I1758 0 n_31_26_4 0.018017565421376624
I1759 0 n_31_27_4 0.018017565421376624
I1760 0 n_32_0_4 0.09093330927160069
I1761 0 n_32_1_4 0.09093330927160069
I1762 0 n_32_2_4 0.09093330927160069
I1763 0 n_32_3_4 0.09093330927160069
I1764 0 n_32_4_4 0.0041232977128448835
I1765 0 n_32_5_4 0.004123297712844956
I1766 0 n_32_6_4 0.004123297712844956
I1767 0 n_32_7_4 0.0041232977128448835
I1768 0 n_32_8_4 0.23687728353474571
I1769 0 n_32_9_4 0.23687728353474582
I1770 0 n_32_10_4 0.23687728353474571
I1771 0 n_32_11_4 0.23687728353474571
I1772 0 n_32_12_4 0.004123304790354911
I1773 0 n_32_13_4 0.004123304790354911
I1774 0 n_32_14_4 0.004123304790354911
I1775 0 n_32_15_4 0.004123304790354911
I1776 0 n_32_16_4 0.23687728353474552
I1777 0 n_32_17_4 0.23687728353474582
I1778 0 n_32_18_4 0.23687728353474582
I1779 0 n_32_19_4 0.23687728353474552
I1780 0 n_32_20_4 0.004123305544007051
I1781 0 n_32_21_4 0.004123305544007051
I1782 0 n_32_22_4 0.004123305544006758
I1783 0 n_32_23_4 0.004123305544007051
I1784 0 n_32_24_4 0.09093330144043874
I1785 0 n_32_25_4 0.09093330144043844
I1786 0 n_32_26_4 0.09093330144043874
I1787 0 n_32_27_4 0.09093330144043874
I1788 0 n_33_0_4 0.09093330927160069
I1789 0 n_33_1_4 0.09093330927160069
I1790 0 n_33_2_4 0.09093330927160069
I1791 0 n_33_3_4 0.09093330927160069
I1792 0 n_33_4_4 0.0041232977128448835
I1793 0 n_33_5_4 0.004123297712844956
I1794 0 n_33_6_4 0.004123297712844956
I1795 0 n_33_7_4 0.0041232977128448835
I1796 0 n_33_8_4 0.23687728353474571
I1797 0 n_33_9_4 0.23687728353474582
I1798 0 n_33_10_4 0.23687728353474571
I1799 0 n_33_11_4 0.23687728353474571
I1800 0 n_33_12_4 0.004123304790354911
I1801 0 n_33_13_4 0.004123304790354911
I1802 0 n_33_14_4 0.004123304790354911
I1803 0 n_33_15_4 0.004123304790354911
I1804 0 n_33_16_4 0.23687728353474552
I1805 0 n_33_17_4 0.23687728353474582
I1806 0 n_33_18_4 0.23687728353474582
I1807 0 n_33_19_4 0.23687728353474552
I1808 0 n_33_20_4 0.004123305544007051
I1809 0 n_33_21_4 0.004123305544007051
I1810 0 n_33_22_4 0.004123305544006758
I1811 0 n_33_23_4 0.004123305544007051
I1812 0 n_33_24_4 0.09093330144043874
I1813 0 n_33_25_4 0.09093330144043844
I1814 0 n_33_26_4 0.09093330144043874
I1815 0 n_33_27_4 0.09093330144043874
I1816 0 n_34_0_4 0.0909333092715994
I1817 0 n_34_1_4 0.0909333092715994
I1818 0 n_34_2_4 0.0909333092715994
I1819 0 n_34_3_4 0.0909333092715994
I1820 0 n_34_4_4 0.004123297712844826
I1821 0 n_34_5_4 0.004123297712844899
I1822 0 n_34_6_4 0.004123297712844899
I1823 0 n_34_7_4 0.004123297712844826
I1824 0 n_34_8_4 0.23687728353474236
I1825 0 n_34_9_4 0.23687728353474247
I1826 0 n_34_10_4 0.23687728353474236
I1827 0 n_34_11_4 0.23687728353474236
I1828 0 n_34_12_4 0.004123304790354855
I1829 0 n_34_13_4 0.004123304790354855
I1830 0 n_34_14_4 0.004123304790354855
I1831 0 n_34_15_4 0.004123304790354855
I1832 0 n_34_16_4 0.2368772835347422
I1833 0 n_34_17_4 0.23687728353474247
I1834 0 n_34_18_4 0.23687728353474247
I1835 0 n_34_19_4 0.2368772835347422
I1836 0 n_34_20_4 0.004123305544006992
I1837 0 n_34_21_4 0.004123305544006992
I1838 0 n_34_22_4 0.0041233055440067
I1839 0 n_34_23_4 0.004123305544006992
I1840 0 n_34_24_4 0.09093330144043747
I1841 0 n_34_25_4 0.09093330144043718
I1842 0 n_34_26_4 0.09093330144043747
I1843 0 n_34_27_4 0.09093330144043747
I1844 0 n_35_0_4 0.09093330927160069
I1845 0 n_35_1_4 0.09093330927160069
I1846 0 n_35_2_4 0.09093330927160069
I1847 0 n_35_3_4 0.09093330927160069
I1848 0 n_35_4_4 0.0041232977128448835
I1849 0 n_35_5_4 0.004123297712844956
I1850 0 n_35_6_4 0.004123297712844956
I1851 0 n_35_7_4 0.0041232977128448835
I1852 0 n_35_8_4 0.23687728353474571
I1853 0 n_35_9_4 0.23687728353474582
I1854 0 n_35_10_4 0.23687728353474571
I1855 0 n_35_11_4 0.23687728353474571
I1856 0 n_35_12_4 0.004123304790354911
I1857 0 n_35_13_4 0.004123304790354911
I1858 0 n_35_14_4 0.004123304790354911
I1859 0 n_35_15_4 0.004123304790354911
I1860 0 n_35_16_4 0.23687728353474552
I1861 0 n_35_17_4 0.23687728353474582
I1862 0 n_35_18_4 0.23687728353474582
I1863 0 n_35_19_4 0.23687728353474552
I1864 0 n_35_20_4 0.004123305544007051
I1865 0 n_35_21_4 0.004123305544007051
I1866 0 n_35_22_4 0.004123305544006758
I1867 0 n_35_23_4 0.004123305544007051
I1868 0 n_35_24_4 0.09093330144043874
I1869 0 n_35_25_4 0.09093330144043844
I1870 0 n_35_26_4 0.09093330144043874
I1871 0 n_35_27_4 0.09093330144043874
.control
set filetype=ascii
op
write thermal_op.raw all
quit
.endc
.end
