* thermal network
.option numdgt=6
Vamb amb 0 45.0
R0 n_0_0_0 n_1_0_0 19.58524409587235
R1 n_0_0_0 n_0_1_0 326.2736359366226
R2 n_0_0_0 n_0_0_1 9.265301421778915
R3 n_0_0_1 n_1_0_1 27.419341734221284
R4 n_0_0_1 n_0_1_1 456.7830903112716
R5 n_0_0_1 n_0_0_2 40.71117291387704
R6 n_0_0_2 n_1_0_2 97.92622047936175
R7 n_0_0_2 n_0_1_2 1631.368179683113
R8 n_0_0_2 n_0_0_3 39.363492707072844
R9 n_0_0_3 n_1_0_3 685.4835433555315
R10 n_0_0_3 n_0_1_3 11419.57725778178
R11 n_0_0_3 n_0_0_4 0.3649967226761394
R12 n_0_0_4 n_1_0_4 31.158342879796887
R13 n_0_0_4 n_0_1_4 519.0716935355354
R14 n_0_0_4 n_0_0_5 0.3195392553831404
R15 n_0_0_5 n_1_0_5 130.56829397248217
R16 n_0_0_5 n_0_1_5 2175.157572910816
R17 n_0_0_5 n_0_0_6 0.07487112260023371
R18 n_0_0_6 n_1_0_6 21.761382328747036
R19 n_0_0_6 n_0_1_6 362.52626215180254
R20 n_0_0_6 n_0_0_7 0.10161080924317421
R21 n_0_0_7 n_1_0_7 37.30522684928074
R22 n_0_0_7 n_0_1_7 621.4735922602349
R23 n_0_0_7 n_0_0_8 0.07487112260023349
R24 n_0_0_8 n_1_0_8 37.30522684928074
R25 n_0_0_8 n_0_1_8 621.4735922602349
R26 n_0_0_8 n_0_0_9 0.07487112260023349
R27 n_0_0_9 n_1_0_9 37.30522684928074
R28 n_0_0_9 n_0_1_9 621.4735922602349
R29 n_0_0_9 n_0_0_10 0.07487112260023349
R30 n_0_0_10 n_1_0_10 37.30522684928074
R31 n_0_0_10 n_0_1_10 621.4735922602349
R32 n_0_0_10 n_0_0_11 0.07487112260023301
R33 n_0_0_11 n_1_0_11 37.30522684928122
R34 n_0_0_11 n_0_1_11 621.4735922602429
R35 n_0_0_11 n_0_0_12 0.07487112260023276
R36 n_0_0_12 n_1_0_12 37.30522684928099
R37 n_0_0_12 n_0_1_12 621.4735922602389
R38 n_0_0_12 n_0_0_13 0.07487112260023349
R39 n_0_0_13 n_1_0_13 37.30522684928051
R40 n_0_0_13 n_0_1_13 621.473592260231
R41 n_0_0_13 n_0_0_14 0.3743556130011684
R42 n_0_0_14 n_1_0_14 4.14502520547563
R43 n_0_0_14 n_0_1_14 69.05262136224819
R44 n_0_0_14 n_0_0_15 11.56758844173621
R45 n_0_0_15 n_1_0_15 1370.9670867110508
R46 n_0_0_15 n_0_1_15 22839.15451556336
R47 n_0_1_0 n_1_1_0 431.92395566823194
R48 n_0_1_0 n_0_2_0 827.213787668201
R49 n_0_1_0 n_0_1_1 204.33269153876188
R50 n_0_1_1 n_1_1_1 604.6935379355247
R51 n_0_1_1 n_0_2_1 1158.0993027354812
R52 n_0_1_1 n_0_1_2 897.8254628218327
R53 n_0_1_2 n_1_1_2 2159.6197783411603
R54 n_0_1_2 n_0_2_2 4136.068938341005
R55 n_0_1_2 n_0_1_3 868.1043440525582
R56 n_0_1_3 n_1_1_3 15117.338448388105
R57 n_0_1_3 n_0_2_3 28952.482568387008
R58 n_0_1_3 n_0_1_4 8.049469666678505
R59 n_0_1_4 n_1_1_4 687.1517476540047
R60 n_0_1_4 n_0_2_4 1316.021934926682
R61 n_0_1_4 n_0_1_5 7.046971612952977
R62 n_0_1_5 n_0_2_5 5514.758584454668
R63 n_0_1_5 n_0_1_6 1.6511732649596937
R64 n_0_1_6 n_0_2_6 919.1264307424447
R65 n_0_1_6 n_0_1_7 2.240878002445296
R66 n_0_1_7 n_0_2_7 1575.645309844196
R67 n_0_1_7 n_0_1_8 1.6511732649596884
R68 n_0_1_8 n_0_2_8 1575.645309844196
R69 n_0_1_8 n_0_1_9 1.6511732649596884
R70 n_0_1_9 n_0_2_9 1575.645309844196
R71 n_0_1_9 n_0_1_10 1.6511732649596884
R72 n_0_1_10 n_0_2_10 1575.645309844196
R73 n_0_1_10 n_0_1_11 1.6511732649596778
R74 n_0_1_11 n_0_2_11 1575.6453098442162
R75 n_0_1_11 n_0_1_12 1.6511732649596726
R76 n_0_1_12 n_0_2_12 1575.645309844206
R77 n_0_1_12 n_0_1_13 1.6511732649596884
R78 n_0_1_13 n_0_2_13 1575.645309844186
R79 n_0_1_13 n_0_1_14 8.255866324798463
R80 n_0_1_14 n_0_2_14 175.0717010937992
R81 n_0_1_14 n_0_1_15 255.10626943627489
R82 n_0_1_15 n_1_1_15 30234.676896775934
R83 n_0_1_15 n_0_2_15 57904.965136773506
R84 n_0_2_0 n_1_2_0 7.518454416370905
R85 n_0_2_0 n_0_3_0 827.2138119611459
R86 n_0_2_0 n_0_2_1 3.5567974569314926
R87 n_0_2_1 n_1_2_1 10.525836182919265
R88 n_0_2_1 n_0_3_1 1158.099336745604
R89 n_0_2_1 n_0_2_2 15.628352462274739
R90 n_0_2_2 n_1_2_2 37.59227208185452
R91 n_0_2_2 n_0_3_2 4136.06905980573
R92 n_0_2_2 n_0_2_3 15.111000104902885
R93 n_0_2_3 n_1_2_3 263.1459045729814
R94 n_0_2_3 n_0_3_3 28952.48341864008
R95 n_0_2_3 n_0_2_4 0.1401162634548771
R96 n_0_2_4 n_1_2_4 11.961177480590063
R97 n_0_2_4 n_0_3_4 1316.0219735745488
R98 n_0_2_4 n_0_2_5 0.12266588632130267
R99 n_0_2_5 n_0_3_5 5514.758746407634
R100 n_0_2_5 n_0_2_6 0.02874179763176966
R101 n_0_2_6 n_0_3_6 919.1264577346057
R102 n_0_2_6 n_0_2_7 0.039006725357401635
R103 n_0_2_7 n_0_3_7 1575.645356116472
R104 n_0_2_7 n_0_2_8 0.02874179763176957
R105 n_0_2_8 n_0_3_8 1575.645356116472
R106 n_0_2_8 n_0_2_9 0.02874179763176957
R107 n_0_2_9 n_0_3_9 1575.645356116472
R108 n_0_2_9 n_0_2_10 0.02874179763176957
R109 n_0_2_10 n_0_3_10 1575.645356116472
R110 n_0_2_10 n_0_2_11 0.028741797631769386
R111 n_0_2_11 n_0_3_11 1575.6453561164922
R112 n_0_2_11 n_0_2_12 0.028741797631769296
R113 n_0_2_12 n_0_3_12 1575.6453561164822
R114 n_0_2_12 n_0_2_13 0.02874179763176957
R115 n_0_2_13 n_0_3_13 1575.645356116462
R116 n_0_2_13 n_0_2_14 0.14370898815884822
R117 n_0_2_14 n_0_3_14 175.0717062351632
R118 n_0_2_14 n_0_2_15 4.44060773410845
R119 n_0_2_15 n_1_2_15 526.291809145958
R120 n_0_2_15 n_0_3_15 57904.96683727965
R121 n_0_3_0 n_1_3_0 431.9232142857081
R122 n_0_3_0 n_0_4_0 827.2138119611458
R123 n_0_3_0 n_0_3_1 204.33234080876747
R124 n_0_3_1 n_1_3_1 604.6924999999914
R125 n_0_3_1 n_0_4_1 1158.099336745604
R126 n_0_3_1 n_0_3_2 897.8239217354935
R127 n_0_3_2 n_1_3_2 2159.6160714285406
R128 n_0_3_2 n_0_4_2 4136.069059805729
R129 n_0_3_2 n_0_3_3 868.102853981491
R130 n_0_3_3 n_1_3_3 15117.31249999977
R131 n_0_3_3 n_0_4_3 28952.483418640077
R132 n_0_3_3 n_0_3_4 8.049455850042364
R133 n_0_3_4 n_1_3_4 687.1505681818079
R134 n_0_3_4 n_0_4_4 1316.0219735745486
R135 n_0_3_4 n_0_3_5 7.046959517070054
R136 n_0_3_5 n_0_4_5 5514.758746407633
R137 n_0_3_5 n_0_3_6 1.6511704307779205
R138 n_0_3_6 n_0_4_6 919.1264577346055
R139 n_0_3_6 n_0_3_7 2.240874156055747
R140 n_0_3_7 n_0_4_7 1575.6453561164717
R141 n_0_3_7 n_0_3_8 1.6511704307779154
R142 n_0_3_8 n_0_4_8 1575.6453561164717
R143 n_0_3_8 n_0_3_9 1.6511704307779154
R144 n_0_3_9 n_0_4_9 1575.6453561164717
R145 n_0_3_9 n_0_3_10 1.6511704307779154
R146 n_0_3_10 n_0_4_10 1575.6453561164717
R147 n_0_3_10 n_0_3_11 1.651170430777905
R148 n_0_3_11 n_0_4_11 1575.645356116492
R149 n_0_3_11 n_0_3_12 1.6511704307778996
R150 n_0_3_12 n_0_4_12 1575.6453561164817
R151 n_0_3_12 n_0_3_13 1.6511704307779156
R152 n_0_3_13 n_0_4_13 1575.6453561164617
R153 n_0_3_13 n_0_3_14 8.255852153889599
R154 n_0_3_14 n_0_4_14 175.07170623516316
R155 n_0_3_14 n_0_3_15 255.10583155519095
R156 n_0_3_15 n_1_3_15 30234.624999999272
R157 n_0_3_15 n_0_4_15 57904.966837279644
R158 n_0_4_0 n_1_4_0 7.518454416370906
R159 n_0_4_0 n_0_5_0 827.2138145479918
R160 n_0_4_0 n_0_4_1 3.556797456931493
R161 n_0_4_1 n_1_4_1 10.525836182919267
R162 n_0_4_1 n_0_5_1 1158.0993403671885
R163 n_0_4_1 n_0_4_2 15.628352462274743
R164 n_0_4_2 n_1_4_2 37.592272081854524
R165 n_0_4_2 n_0_5_2 4136.069072739959
R166 n_0_4_2 n_0_4_3 15.111000104902889
R167 n_0_4_3 n_1_4_3 263.1459045729814
R168 n_0_4_3 n_0_5_3 28952.483509179685
R169 n_0_4_3 n_0_4_4 0.14011626345487713
R170 n_0_4_4 n_1_4_4 11.961177480590065
R171 n_0_4_4 n_0_5_4 1316.0219776899853
R172 n_0_4_4 n_0_4_5 0.12266588632130268
R173 n_0_4_5 n_0_5_5 5514.7587636532735
R174 n_0_4_5 n_0_4_6 0.028741797631769667
R175 n_0_4_6 n_0_5_6 919.1264606088789
R176 n_0_4_6 n_0_4_7 0.03900672535740165
R177 n_0_4_7 n_0_5_7 1575.6453610437973
R178 n_0_4_7 n_0_4_8 0.028741797631769577
R179 n_0_4_8 n_0_5_8 1575.6453610437973
R180 n_0_4_8 n_0_4_9 0.028741797631769577
R181 n_0_4_9 n_0_5_9 1575.6453610437973
R182 n_0_4_9 n_0_4_10 0.028741797631769577
R183 n_0_4_10 n_0_5_10 1575.6453610437973
R184 n_0_4_10 n_0_4_11 0.028741797631769393
R185 n_0_4_11 n_0_5_11 1575.6453610438177
R186 n_0_4_11 n_0_4_12 0.028741797631769303
R187 n_0_4_12 n_0_5_12 1575.6453610438073
R188 n_0_4_12 n_0_4_13 0.028741797631769577
R189 n_0_4_13 n_0_5_13 1575.6453610437873
R190 n_0_4_13 n_0_4_14 0.14370898815884825
R191 n_0_4_14 n_0_5_14 175.0717067826438
R192 n_0_4_14 n_0_4_15 4.440607734108451
R193 n_0_4_15 n_1_4_15 526.2918091459583
R194 n_0_4_15 n_0_5_15 57904.96701835886
R195 n_0_5_0 n_1_5_0 431.9231353393825
R196 n_0_5_0 n_0_6_0 326.2736359366227
R197 n_0_5_0 n_0_5_1 204.33230346118583
R198 n_0_5_1 n_1_5_1 604.6923894751354
R199 n_0_5_1 n_0_6_1 456.78309031127174
R200 n_0_5_1 n_0_5_2 897.8237576324832
R201 n_0_5_2 n_1_5_2 2159.6156766969125
R202 n_0_5_2 n_0_6_2 1631.3681796831136
R203 n_0_5_2 n_0_5_3 868.1026953108562
R204 n_0_5_3 n_1_5_3 15117.309736878371
R205 n_0_5_3 n_0_6_3 11419.577257781784
R206 n_0_5_3 n_0_5_4 8.049454378773994
R207 n_0_5_4 n_1_5_4 687.1504425853806
R208 n_0_5_4 n_0_6_4 519.0716935355356
R209 n_0_5_4 n_0_5_5 7.046958229036575
R210 n_0_5_5 n_0_6_5 2175.1575729108163
R211 n_0_5_5 n_0_5_6 1.6511701289792808
R212 n_0_5_6 n_0_6_6 362.52626215180265
R213 n_0_5_6 n_0_5_7 2.2408737464718786
R214 n_0_5_7 n_0_6_7 621.473592260235
R215 n_0_5_7 n_0_5_8 1.6511701289792757
R216 n_0_5_8 n_0_6_8 621.473592260235
R217 n_0_5_8 n_0_5_9 1.6511701289792757
R218 n_0_5_9 n_0_6_9 621.473592260235
R219 n_0_5_9 n_0_5_10 1.6511701289792757
R220 n_0_5_10 n_0_6_10 621.473592260235
R221 n_0_5_10 n_0_5_11 1.651170128979265
R222 n_0_5_11 n_0_6_11 621.4735922602431
R223 n_0_5_11 n_0_5_12 1.65117012897926
R224 n_0_5_12 n_0_6_12 621.4735922602391
R225 n_0_5_12 n_0_5_13 1.6511701289792757
R226 n_0_5_13 n_0_6_13 621.4735922602313
R227 n_0_5_13 n_0_5_14 8.2558506448964
R228 n_0_5_14 n_0_6_14 69.05262136224822
R229 n_0_5_14 n_0_5_15 255.1057849273011
R230 n_0_5_15 n_1_5_15 30234.619473756477
R231 n_0_5_15 n_0_6_15 22839.15451556337
R232 n_0_6_0 n_1_6_0 19.585245782550576
R233 n_0_6_0 n_0_6_1 9.265302219705257
R234 n_0_6_1 n_1_6_1 27.419344095570803
R235 n_0_6_1 n_0_6_2 40.71117641991704
R236 n_0_6_2 n_1_6_2 97.92622891275288
R237 n_0_6_2 n_0_6_3 39.36349609705081
R238 n_0_6_3 n_1_6_3 685.4836023892695
R239 n_0_6_3 n_0_6_4 0.36499675410960136
R240 n_0_6_4 n_1_6_4 31.158345563148615
R241 n_0_6_4 n_0_6_5 0.31953928290181216
R242 n_0_6_5 n_1_6_5 130.56830521700374
R243 n_0_6_5 n_0_6_6 0.07487112904812335
R244 n_0_6_6 n_1_6_6 21.761384202833952
R245 n_0_6_6 n_0_6_7 0.10161081799388158
R246 n_0_6_7 n_1_6_7 37.305230062001186
R247 n_0_6_7 n_0_6_8 0.07487112904812313
R248 n_0_6_8 n_1_6_8 37.305230062001186
R249 n_0_6_8 n_0_6_9 0.07487112904812313
R250 n_0_6_9 n_1_6_9 37.305230062001186
R251 n_0_6_9 n_0_6_10 0.07487112904812313
R252 n_0_6_10 n_1_6_10 37.305230062001186
R253 n_0_6_10 n_0_6_11 0.07487112904812265
R254 n_0_6_11 n_1_6_11 37.30523006200165
R255 n_0_6_11 n_0_6_12 0.0748711290481224
R256 n_0_6_12 n_1_6_12 37.30523006200142
R257 n_0_6_12 n_0_6_13 0.07487112904812313
R258 n_0_6_13 n_1_6_13 37.305230062000945
R259 n_0_6_13 n_0_6_14 0.3743556452406166
R260 n_0_6_14 n_1_6_14 4.145025562444566
R261 n_0_6_14 n_0_6_15 11.567589437935158
R262 n_0_6_15 n_1_6_15 1370.9672047785268
R263 n_1_0_0 n_2_0_0 125.67181420979055
R264 n_1_0_0 n_1_1_0 1646.6785783889504
R265 n_1_0_0 n_1_0_1 46.761281614931434
R266 n_1_0_1 n_2_0_1 175.94053989370676
R267 n_1_0_1 n_1_1_1 2305.350009744531
R268 n_1_0_1 n_1_0_2 205.46623739894113
R269 n_1_0_2 n_2_0_2 628.3590710489527
R270 n_1_0_2 n_1_1_2 8233.392891944752
R271 n_1_0_2 n_1_0_3 198.6645964367693
R272 n_1_0_3 n_2_0_3 4398.513497342664
R273 n_1_0_3 n_1_1_3 57633.75024361321
R274 n_1_0_3 n_1_0_4 1.842111093921543
R275 n_1_0_4 n_2_0_4 199.9324316973939
R276 n_1_0_4 n_1_1_4 2619.7159201642366
R277 n_1_0_4 n_1_0_5 1.6126906646419368
R278 n_1_0_5 n_2_0_5 837.8120947319361
R279 n_1_0_5 n_1_0_6 0.37786894234288065
R280 n_1_0_6 n_2_0_6 139.63534912198935
R281 n_1_0_6 n_1_0_7 0.512822136036766
R282 n_1_0_7 n_2_0_7 239.37488420912536
R283 n_1_0_7 n_1_0_8 0.3778689423428795
R284 n_1_0_8 n_2_0_8 239.37488420912536
R285 n_1_0_8 n_1_0_9 0.3778689423428795
R286 n_1_0_9 n_2_0_9 239.37488420912536
R287 n_1_0_9 n_1_0_10 0.3778689423428795
R288 n_1_0_10 n_2_0_10 239.37488420912536
R289 n_1_0_10 n_1_0_11 0.37786894234287705
R290 n_1_0_11 n_2_0_11 239.37488420912842
R291 n_1_0_11 n_1_0_12 0.3778689423428758
R292 n_1_0_12 n_2_0_12 239.37488420912698
R293 n_1_0_12 n_1_0_13 0.3778689423428795
R294 n_1_0_13 n_2_0_13 239.37488420912388
R295 n_1_0_13 n_1_0_14 1.889344711714402
R296 n_1_0_14 n_2_0_14 26.59720935656943
R297 n_1_0_14 n_1_0_15 58.38075159197555
R298 n_1_0_15 n_2_0_15 8797.026994685251
R299 n_1_0_15 n_1_1_15 115267.50048722538
R300 n_1_1_0 n_2_1_0 2771.508327585035
R301 n_1_1_0 n_1_2_0 4174.885966470812
R302 n_1_1_0 n_1_1_1 1031.2517744669829
R303 n_1_1_1 n_2_1_1 3880.1116586190487
R304 n_1_1_1 n_1_2_1 5844.840353059135
R305 n_1_1_1 n_1_1_2 4531.257796900379
R306 n_1_1_2 n_2_1_2 13857.541637925178
R307 n_1_1_2 n_1_2_2 20874.429832354057
R308 n_1_1_2 n_1_1_3 4381.257538796091
R309 n_1_1_3 n_2_1_3 97002.79146547614
R310 n_1_1_3 n_1_2_3 146121.00882647827
R311 n_1_1_3 n_1_1_4 40.625069903244814
R312 n_1_1_4 n_2_1_4 4409.217793885279
R313 n_1_1_4 n_1_2_4 6641.864037567193
R314 n_1_1_15 n_2_1_15 194005.5829309505
R315 n_1_1_15 n_1_2_15 292242.0176529539
R316 n_1_2_0 n_2_2_0 48.24335106234776
R317 n_1_2_0 n_1_3_0 4174.886089075483
R318 n_1_2_0 n_1_2_1 17.95089009623525
R319 n_1_2_1 n_2_2_1 67.54069148728686
R320 n_1_2_1 n_1_3_1 5844.840524705675
R321 n_1_2_1 n_1_2_2 78.87512315012458
R322 n_1_2_2 n_2_2_2 241.21675531173878
R323 n_1_2_2 n_1_3_2 20874.430445377417
R324 n_1_2_2 n_1_2_3 76.26408459067217
R325 n_1_2_3 n_2_2_3 1688.5172871821699
R326 n_1_2_3 n_1_3_3 146121.0131176418
R327 n_1_2_3 n_1_2_4 0.7071562765183588
R328 n_1_2_4 n_2_2_4 76.75078578100772
R329 n_1_2_4 n_1_3_4 6641.86423262008
R330 n_1_2_15 n_2_2_15 3377.03457436431
R331 n_1_2_15 n_1_3_15 292242.0262352809
R332 n_1_3_0 n_2_3_0 2771.5035703868944
R333 n_1_3_0 n_1_4_0 4174.886089075483
R334 n_1_3_0 n_1_3_1 1031.2500043589969
R335 n_1_3_1 n_2_3_1 3880.104998541652
R336 n_1_3_1 n_1_4_1 5844.840524705674
R337 n_1_3_1 n_1_3_2 4531.250019153168
R338 n_1_3_2 n_2_3_2 13857.517851934474
R339 n_1_3_2 n_1_4_2 20874.430445377413
R340 n_1_3_2 n_1_3_3 4381.250018519132
R341 n_1_3_3 n_2_3_3 97002.62496354122
R342 n_1_3_3 n_1_4_3 146121.01311764176
R343 n_1_3_3 n_1_3_4 40.6250001717181
R344 n_1_3_4 n_2_3_4 4409.21022561551
R345 n_1_3_4 n_1_4_4 6641.864232620079
R346 n_1_3_15 n_2_3_15 194005.24992708076
R347 n_1_3_15 n_1_4_15 292242.02623528085
R348 n_1_4_0 n_2_4_0 48.24335106234777
R349 n_1_4_0 n_1_5_0 4174.8861021311
R350 n_1_4_0 n_1_4_1 17.95089009623525
R351 n_1_4_1 n_2_4_1 67.54069148728686
R352 n_1_4_1 n_1_5_1 5844.840542983539
R353 n_1_4_1 n_1_4_2 78.8751231501246
R354 n_1_4_2 n_2_4_2 241.21675531173884
R355 n_1_4_2 n_1_5_2 20874.4305106555
R356 n_1_4_2 n_1_4_3 76.26408459067218
R357 n_1_4_3 n_2_4_3 1688.51728718217
R358 n_1_4_3 n_1_5_3 146121.01357458837
R359 n_1_4_3 n_1_4_4 0.707156276518359
R360 n_1_4_4 n_2_4_4 76.75078578100774
R361 n_1_4_4 n_1_5_4 6641.864253390379
R362 n_1_4_15 n_2_4_15 3377.0345743643106
R363 n_1_4_15 n_1_5_15 292242.0271491741
R364 n_1_5_0 n_2_5_0 2771.5030638153185
R365 n_1_5_0 n_1_6_0 1646.6785783889509
R366 n_1_5_0 n_1_5_1 1031.2498158685523
R367 n_1_5_1 n_2_5_1 3880.1042893414456
R368 n_1_5_1 n_1_6_1 2305.3500097445312
R369 n_1_5_1 n_1_5_2 4531.249190937578
R370 n_1_5_2 n_2_5_2 13857.515319076592
R371 n_1_5_2 n_1_6_2 8233.392891944755
R372 n_1_5_2 n_1_5_3 4381.249217720334
R373 n_1_5_3 n_2_5_3 97002.60723353605
R374 n_1_5_3 n_1_6_3 57633.750243613234
R375 n_1_5_3 n_1_5_4 40.62499274633694
R376 n_1_5_4 n_2_5_4 4409.209419706185
R377 n_1_5_4 n_1_6_4 2619.7159201642376
R378 n_1_5_15 n_2_5_15 194005.2144670704
R379 n_1_5_15 n_1_6_15 115267.50048722542
R380 n_1_6_0 n_2_6_0 125.67182503262798
R381 n_1_6_0 n_1_6_1 46.761285642005866
R382 n_1_6_1 n_2_6_1 175.94055504567913
R383 n_1_6_1 n_1_6_2 205.4662550936621
R384 n_1_6_2 n_2_6_2 628.3591251631399
R385 n_1_6_2 n_1_6_3 198.664613545734
R386 n_1_6_3 n_2_6_3 4398.513876141975
R387 n_1_6_3 n_1_6_4 1.842111252563869
R388 n_1_6_4 n_2_6_4 199.9324489155443
R389 n_1_6_4 n_1_6_5 1.6126908035266108
R390 n_1_6_5 n_2_6_5 837.8121668841858
R391 n_1_6_5 n_1_6_6 0.3778689748848962
R392 n_1_6_6 n_2_6_6 139.63536114736428
R393 n_1_6_6 n_1_6_7 0.51282218020093
R394 n_1_6_7 n_2_6_7 239.37490482405386
R395 n_1_6_7 n_1_6_8 0.377868974884895
R396 n_1_6_8 n_2_6_8 239.37490482405386
R397 n_1_6_8 n_1_6_9 0.377868974884895
R398 n_1_6_9 n_2_6_9 239.37490482405386
R399 n_1_6_9 n_1_6_10 0.377868974884895
R400 n_1_6_10 n_2_6_10 239.37490482405386
R401 n_1_6_10 n_1_6_11 0.37786897488489257
R402 n_1_6_11 n_2_6_11 239.3749048240568
R403 n_1_6_11 n_1_6_12 0.37786897488489135
R404 n_1_6_12 n_2_6_12 239.37490482405533
R405 n_1_6_12 n_1_6_13 0.377868974884895
R406 n_1_6_13 n_2_6_13 239.37490482405232
R407 n_1_6_13 n_1_6_14 1.8893448744244798
R408 n_1_6_14 n_2_6_14 26.59721164711703
R409 n_1_6_14 n_1_6_15 58.38075661971696
R410 n_1_6_15 n_2_6_15 8797.027752283871
R411 n_2_0_0 n_3_0_0 125.67181422348102
R412 n_2_0_0 n_2_1_0 43.56171513435994
R413 n_2_0_0 n_2_0_1 1.2370365751767742
R414 n_2_0_1 n_3_0_1 175.9405399128734
R415 n_2_0_1 n_2_1_1 60.986401188103926
R416 n_2_0_1 n_2_0_2 5.435463739413098
R417 n_2_0_2 n_3_0_2 628.359071117405
R418 n_2_0_2 n_2_1_2 217.80857567179973
R419 n_2_0_2 n_2_0_3 5.255531146660113
R420 n_2_0_3 n_3_0_3 4398.51349782183
R421 n_2_0_3 n_2_1_3 1524.6600297025961
R422 n_2_0_3 n_2_0_4 0.04873174387060024
R423 n_2_0_4 n_3_0_4 199.93243171917416
R424 n_2_0_4 n_2_1_4 69.30272862284531
R425 n_2_0_4 n_2_0_5 0.04266258895631303
R426 n_2_0_5 n_3_0_5 837.8120948232058
R427 n_2_0_5 n_2_0_6 0.009996255152943638
R428 n_2_0_6 n_3_0_6 139.635349137201
R429 n_2_0_6 n_2_0_7 0.013566346278994921
R430 n_2_0_7 n_3_0_7 239.37488423520242
R431 n_2_0_7 n_2_0_8 0.009996255152943606
R432 n_2_0_8 n_3_0_8 239.37488423520242
R433 n_2_0_8 n_2_0_9 0.009996255152943606
R434 n_2_0_9 n_3_0_9 239.37488423520242
R435 n_2_0_9 n_2_0_10 0.009996255152943606
R436 n_2_0_10 n_3_0_10 239.37488423520242
R437 n_2_0_10 n_2_0_11 0.009996255152943542
R438 n_2_0_11 n_3_0_11 239.37488423520549
R439 n_2_0_11 n_2_0_12 0.009996255152943511
R440 n_2_0_12 n_3_0_12 239.37488423520404
R441 n_2_0_12 n_2_0_13 0.009996255152943605
R442 n_2_0_13 n_3_0_13 239.37488423520094
R443 n_2_0_13 n_2_0_14 0.049981275764718155
R444 n_2_0_14 n_3_0_14 26.59720935946688
R445 n_2_0_14 n_2_0_15 1.5444214211298053
R446 n_2_0_15 n_3_0_15 8797.026995643584
R447 n_2_0_15 n_2_1_15 3049.3200594051664
R448 n_2_1_0 n_3_1_0 2771.5083278869583
R449 n_2_1_0 n_2_2_0 110.44365037393555
R450 n_2_1_0 n_2_1_1 27.281035060943715
R451 n_2_1_1 n_3_1_1 3880.111659041741
R452 n_2_1_1 n_2_2_1 154.62111052350977
R453 n_2_1_1 n_2_1_2 119.87121466172238
R454 n_2_1_2 n_3_1_2 13857.541639434794
R455 n_2_1_2 n_2_2_2 552.2182518696779
R456 n_2_1_2 n_2_1_3 115.9030641074033
R457 n_2_1_3 n_3_1_3 97002.79147604345
R458 n_2_1_3 n_2_2_3 3865.5277630877404
R459 n_2_1_3 n_2_1_4 1.0747074417947535
R460 n_2_1_4 n_3_1_4 4409.217794365612
R461 n_2_1_4 n_2_2_4 175.70580741307916
R462 n_2_1_15 n_3_1_15 194005.58295208513
R463 n_2_1_15 n_2_2_15 7731.055526175413
R464 n_2_2_0 n_3_2_0 48.243351067603314
R465 n_2_2_0 n_2_3_0 110.44365361735528
R466 n_2_2_0 n_2_2_1 0.47487807945218746
R467 n_2_2_1 n_3_2_1 67.54069149464463
R468 n_2_2_1 n_2_3_1 154.62111506429738
R469 n_2_2_1 n_2_2_2 2.0865855006232477
R470 n_2_2_2 n_3_2_2 241.2167553380165
R471 n_2_2_2 n_2_3_2 552.2182680867766
R472 n_2_2_2 n_2_2_3 2.0175123254302023
R473 n_2_2_3 n_3_2_3 1688.517287366114
R474 n_2_2_3 n_2_3_3 3865.5278766074307
R475 n_2_2_3 n_2_2_4 0.018707318281449826
R476 n_2_2_4 n_3_2_4 76.75078578936882
R477 n_2_2_4 n_2_3_4 175.7058125730651
R478 n_2_2_4 n_2_2_5 0.018707318281449826
R479 n_2_2_5 n_2_2_6 0.03741463656289965
R480 n_2_2_6 n_2_2_7 0.05468293036116097
R481 n_2_2_7 n_2_2_8 0.04029268552927642
R482 n_2_2_8 n_2_2_9 0.04029268552927642
R483 n_2_2_9 n_2_2_10 0.04029268552927642
R484 n_2_2_10 n_2_2_11 0.040292685529276166
R485 n_2_2_11 n_2_2_12 0.040292685529276034
R486 n_2_2_12 n_2_2_13 0.04029268552927642
R487 n_2_2_13 n_2_2_14 0.20146342764638261
R488 n_2_2_14 n_2_2_15 0.7569268781571286
R489 n_2_2_15 n_3_2_15 3377.034574732198
R490 n_2_2_15 n_2_3_15 7731.055753214795
R491 n_2_3_0 n_3_3_0 2771.503570688817
R492 n_2_3_0 n_2_4_0 110.44365361735527
R493 n_2_3_0 n_2_3_1 27.280988233991053
R494 n_2_3_1 n_3_3_1 3880.104998964344
R495 n_2_3_1 n_2_4_1 154.62111506429738
R496 n_2_3_1 n_2_3_2 119.87100890693038
R497 n_2_3_2 n_3_3_2 13857.517853444087
R498 n_2_3_2 n_2_4_2 552.2182680867764
R499 n_2_3_2 n_2_3_3 115.9028651638044
R500 n_2_3_3 n_3_3_3 97002.62497410852
R501 n_2_3_3 n_2_4_3 3865.5278766074302
R502 n_2_3_3 n_2_3_4 1.0747055970966182
R503 n_2_3_4 n_3_3_4 4409.210226095842
R504 n_2_3_4 n_2_4_4 175.70581257306506
R505 n_2_3_15 n_3_3_15 194005.24994821532
R506 n_2_3_15 n_2_4_15 7731.055753214793
R507 n_2_4_0 n_3_4_0 48.24335106760332
R508 n_2_4_0 n_2_5_0 110.44365396273238
R509 n_2_4_0 n_2_4_1 0.4748780794521875
R510 n_2_4_1 n_3_4_1 67.54069149464463
R511 n_2_4_1 n_2_5_1 154.62111554782533
R512 n_2_4_1 n_2_4_2 2.086585500623248
R513 n_2_4_2 n_3_4_2 241.21675533801655
R514 n_2_4_2 n_2_5_2 552.218269813662
R515 n_2_4_2 n_2_4_3 2.0175123254302028
R516 n_2_4_3 n_3_4_3 1688.5172873661143
R517 n_2_4_3 n_2_5_3 3865.5278886956294
R518 n_2_4_3 n_2_4_4 0.018707318281449826
R519 n_2_4_4 n_3_4_4 76.75078578936883
R520 n_2_4_4 n_2_5_4 175.70581312252867
R521 n_2_4_4 n_2_4_5 0.018707318281449826
R522 n_2_4_5 n_2_4_6 0.03741463656289966
R523 n_2_4_6 n_2_4_7 0.054682930361160974
R524 n_2_4_7 n_2_4_8 0.04029268552927642
R525 n_2_4_8 n_2_4_9 0.04029268552927642
R526 n_2_4_9 n_2_4_10 0.04029268552927642
R527 n_2_4_10 n_2_4_11 0.040292685529276166
R528 n_2_4_11 n_2_4_12 0.040292685529276034
R529 n_2_4_12 n_2_4_13 0.04029268552927642
R530 n_2_4_13 n_2_4_14 0.20146342764638264
R531 n_2_4_14 n_2_4_15 0.7569268781571288
R532 n_2_4_15 n_3_4_15 3377.0345747321985
R533 n_2_4_15 n_2_5_15 7731.0557773911905
R534 n_2_5_0 n_3_5_0 2771.503064117241
R535 n_2_5_0 n_2_6_0 43.56171513435996
R536 n_2_5_0 n_2_5_1 27.280983247609882
R537 n_2_5_1 n_3_5_1 3880.104289764137
R538 n_2_5_1 n_2_6_1 60.98640118810394
R539 n_2_5_1 n_2_5_2 119.87098699707371
R540 n_2_5_2 n_3_5_2 13857.515320586204
R541 n_2_5_2 n_2_6_2 217.80857567179982
R542 n_2_5_2 n_2_5_3 115.90284397923955
R543 n_2_5_3 n_3_5_3 97002.60724410333
R544 n_2_5_3 n_2_6_3 1524.6600297025968
R545 n_2_5_3 n_2_5_4 1.0747054006634207
R546 n_2_5_4 n_3_5_4 4409.209420186516
R547 n_2_5_4 n_2_6_4 69.30272862284532
R548 n_2_5_15 n_3_5_15 194005.21448820498
R549 n_2_5_15 n_2_6_15 3049.320059405167
R550 n_2_6_0 n_3_6_0 125.67182504631843
R551 n_2_6_0 n_2_6_1 1.2370366817101748
R552 n_2_6_1 n_3_6_1 175.9405550648458
R553 n_2_6_1 n_2_6_2 5.4354642075144035
R554 n_2_6_2 n_3_6_2 628.3591252315922
R555 n_2_6_2 n_2_6_3 5.255531599265651
R556 n_2_6_3 n_3_6_3 4398.51387662114
R557 n_2_6_3 n_2_6_4 0.04873174806737056
R558 n_2_6_4 n_3_6_4 199.93244893732458
R559 n_2_6_4 n_2_6_5 0.042662592630408655
R560 n_2_6_5 n_3_6_5 837.8121669754555
R561 n_2_6_5 n_2_6_6 0.009996256013819602
R562 n_2_6_6 n_3_6_6 139.63536116257592
R563 n_2_6_6 n_2_6_7 0.013566347447326588
R564 n_2_6_7 n_3_6_7 239.37490485013092
R565 n_2_6_7 n_2_6_8 0.00999625601381957
R566 n_2_6_8 n_3_6_8 239.37490485013092
R567 n_2_6_8 n_2_6_9 0.00999625601381957
R568 n_2_6_9 n_3_6_9 239.37490485013092
R569 n_2_6_9 n_2_6_10 0.00999625601381957
R570 n_2_6_10 n_3_6_10 239.37490485013092
R571 n_2_6_10 n_2_6_11 0.009996256013819507
R572 n_2_6_11 n_3_6_11 239.37490485013387
R573 n_2_6_11 n_2_6_12 0.009996256013819475
R574 n_2_6_12 n_3_6_12 239.37490485013242
R575 n_2_6_12 n_2_6_13 0.00999625601381957
R576 n_2_6_13 n_3_6_13 239.37490485012938
R577 n_2_6_13 n_2_6_14 0.04998128006909798
R578 n_2_6_14 n_3_6_14 26.597211650014483
R579 n_2_6_14 n_2_6_15 1.5444215541351418
R580 n_2_6_15 n_3_6_15 8797.027753242204
R581 n_3_0_0 n_4_0_0 125.67181420979057
R582 n_3_0_0 n_3_1_0 1646.6785714285777
R583 n_3_0_0 n_3_0_1 46.761281417275406
R584 n_3_0_1 n_4_0_1 175.94053989370676
R585 n_3_0_1 n_3_1_1 2305.3500000000085
R586 n_3_0_1 n_3_0_2 205.4662365304525
R587 n_3_0_2 n_4_0_2 628.3590710489527
R588 n_3_0_2 n_3_1_2 8233.392857142888
R589 n_3_0_2 n_3_0_3 198.66459559703063
R590 n_3_0_3 n_4_0_3 4398.513497342665
R591 n_3_0_3 n_3_1_3 57633.750000000146
R592 n_3_0_3 n_3_0_4 1.8421110861350933
R593 n_3_0_4 n_4_0_4 199.9324316973939
R594 n_3_0_4 n_3_1_4 2619.7159090909163
R595 n_3_0_4 n_3_0_5 1.612690657825228
R596 n_3_0_5 n_4_0_5 837.8120947319361
R597 n_3_0_5 n_3_0_6 0.37786894074566013
R598 n_3_0_6 n_4_0_6 139.63534912198938
R599 n_3_0_6 n_3_0_7 0.5128221338691096
R600 n_3_0_7 n_4_0_7 239.37488420912536
R601 n_3_0_7 n_3_0_8 0.37786894074565897
R602 n_3_0_8 n_4_0_8 239.37488420912536
R603 n_3_0_8 n_3_0_9 0.37786894074565897
R604 n_3_0_9 n_4_0_9 239.37488420912536
R605 n_3_0_9 n_3_0_10 0.37786894074565897
R606 n_3_0_10 n_4_0_10 239.37488420912536
R607 n_3_0_10 n_3_0_11 0.3778689407456566
R608 n_3_0_11 n_4_0_11 239.37488420912842
R609 n_3_0_11 n_3_0_12 0.37786894074565536
R610 n_3_0_12 n_4_0_12 239.37488420912698
R611 n_3_0_12 n_3_0_13 0.377868940745659
R612 n_3_0_13 n_4_0_13 239.37488420912388
R613 n_3_0_13 n_3_0_14 1.8893447037282995
R614 n_3_0_14 n_4_0_14 26.59720935656943
R615 n_3_0_14 n_3_0_15 58.380751345205
R616 n_3_0_15 n_4_0_15 8797.026994685253
R617 n_3_0_15 n_3_1_15 115267.49999999929
R618 n_3_1_0 n_4_1_0 2771.508327585035
R619 n_3_1_0 n_3_2_0 4174.885948823918
R620 n_3_1_0 n_3_1_1 1031.2517701079676
R621 n_3_1_1 n_4_1_1 3880.1116586190487
R622 n_3_1_1 n_3_2_1 5844.8403283534835
R623 n_3_1_1 n_3_1_2 4531.25777774713
R624 n_3_1_2 n_4_1_2 13857.541637925178
R625 n_3_1_2 n_3_2_2 20874.42974411958
R626 n_3_1_2 n_3_1_3 4381.25752027688
R627 n_3_1_3 n_4_1_3 97002.79146547616
R628 n_3_1_3 n_3_2_3 146121.00820883692
R629 n_3_1_3 n_3_1_4 40.62506973152603
R630 n_3_1_4 n_4_1_4 4409.217793885279
R631 n_3_1_4 n_3_2_4 6641.8640094925895
R632 n_3_1_15 n_4_1_15 194005.58293095054
R633 n_3_1_15 n_3_2_15 292242.0164176713
R634 n_3_2_0 n_4_2_0 48.24335106234777
R635 n_3_2_0 n_3_3_0 4174.886071428588
R636 n_3_2_0 n_3_2_1 17.950890020358333
R637 n_3_2_1 n_4_2_1 67.54069148728688
R638 n_3_2_1 n_3_3_1 5844.840500000023
R639 n_3_2_1 n_3_2_2 78.875122816726
R640 n_3_2_2 n_4_2_2 241.2167553117388
R641 n_3_2_2 n_3_3_2 20874.430357142937
R642 n_3_2_2 n_3_2_3 76.26408426831026
R643 n_3_2_3 n_4_2_3 1688.51728718217
R644 n_3_2_3 n_3_3_3 146121.0125000004
R645 n_3_2_3 n_3_2_4 0.7071562735292682
R646 n_3_2_4 n_4_2_4 76.75078578100774
R647 n_3_2_4 n_3_3_4 6641.864204545475
R648 n_3_2_15 n_4_2_15 3377.03457436431
R649 n_3_2_15 n_3_3_15 292242.0249999983
R650 n_3_3_0 n_4_3_0 2771.503570386895
R651 n_3_3_0 n_3_4_0 4174.8860714285875
R652 n_3_3_0 n_3_3_1 1031.249999999989
R653 n_3_3_1 n_4_3_1 3880.1049985416525
R654 n_3_3_1 n_3_4_1 5844.840500000022
R655 n_3_3_1 n_3_3_2 4531.249999999952
R656 n_3_3_2 n_4_3_2 13857.517851934475
R657 n_3_3_2 n_3_4_2 20874.430357142934
R658 n_3_3_2 n_3_3_3 4381.249999999954
R659 n_3_3_3 n_4_3_3 97002.62496354122
R660 n_3_3_3 n_3_4_3 146121.0125000004
R661 n_3_3_3 n_3_3_4 40.6249999999996
R662 n_3_3_4 n_4_3_4 4409.21022561551
R663 n_3_3_4 n_3_4_4 6641.864204545474
R664 n_3_3_15 n_4_3_15 194005.24992708073
R665 n_3_3_15 n_3_4_15 292242.0249999982
R666 n_3_4_0 n_4_4_0 48.24335106234778
R667 n_3_4_0 n_3_5_0 4174.886084484206
R668 n_3_4_0 n_3_4_1 17.950890020358337
R669 n_3_4_1 n_4_4_1 67.54069148728688
R670 n_3_4_1 n_3_5_1 5844.840518277887
R671 n_3_4_1 n_3_4_2 78.87512281672602
R672 n_3_4_2 n_4_4_2 241.21675531173886
R673 n_3_4_2 n_3_5_2 20874.43042242102
R674 n_3_4_2 n_3_4_3 76.26408426831027
R675 n_3_4_3 n_4_4_3 1688.5172871821703
R676 n_3_4_3 n_3_5_3 146121.01295694703
R677 n_3_4_3 n_3_4_4 0.7071562735292684
R678 n_3_4_4 n_4_4_4 76.75078578100775
R679 n_3_4_4 n_3_5_4 6641.864225315775
R680 n_3_4_15 n_4_4_15 3377.0345743643106
R681 n_3_4_15 n_3_5_15 292242.02591389144
R682 n_3_5_0 n_4_5_0 2771.503063815319
R683 n_3_5_0 n_3_6_0 1646.6785714285782
R684 n_3_5_0 n_3_5_1 1031.2498115095452
R685 n_3_5_1 n_4_5_1 3880.1042893414456
R686 n_3_5_1 n_3_6_1 2305.350000000009
R687 n_3_5_1 n_3_5_2 4531.249171784365
R688 n_3_5_2 n_4_5_2 13857.515319076592
R689 n_3_5_2 n_3_6_2 8233.39285714289
R690 n_3_5_2 n_3_5_3 4381.249199201158
R691 n_3_5_3 n_4_5_3 97002.60723353605
R692 n_3_5_3 n_3_6_3 57633.75000000017
R693 n_3_5_3 n_3_5_4 40.62499257461849
R694 n_3_5_4 n_4_5_4 4409.209419706184
R695 n_3_5_4 n_3_6_4 2619.7159090909176
R696 n_3_5_15 n_4_5_15 194005.21446707041
R697 n_3_5_15 n_3_6_15 115267.49999999932
R698 n_3_6_0 n_4_6_0 125.67182503262798
R699 n_3_6_0 n_3_6_1 46.761285444349795
R700 n_3_6_1 n_4_6_1 175.94055504567916
R701 n_3_6_1 n_3_6_2 205.4662542251734
R702 n_3_6_2 n_4_6_2 628.3591251631399
R703 n_3_6_2 n_3_6_3 198.66461270599524
R704 n_3_6_3 n_4_6_3 4398.513876141975
R705 n_3_6_3 n_3_6_4 1.842111244777418
R706 n_3_6_4 n_4_6_4 199.9324489155443
R707 n_3_6_4 n_3_6_5 1.612690796709901
R708 n_3_6_5 n_4_6_5 837.8121668841858
R709 n_3_6_5 n_3_6_6 0.37786897328767555
R710 n_3_6_6 n_4_6_6 139.6353611473643
R711 n_3_6_6 n_3_6_7 0.5128221780332733
R712 n_3_6_7 n_4_6_7 239.37490482405386
R713 n_3_6_7 n_3_6_8 0.3778689732876743
R714 n_3_6_8 n_4_6_8 239.37490482405386
R715 n_3_6_8 n_3_6_9 0.3778689732876743
R716 n_3_6_9 n_4_6_9 239.37490482405386
R717 n_3_6_9 n_3_6_10 0.3778689732876743
R718 n_3_6_10 n_4_6_10 239.37490482405386
R719 n_3_6_10 n_3_6_11 0.3778689732876719
R720 n_3_6_11 n_4_6_11 239.3749048240568
R721 n_3_6_11 n_3_6_12 0.3778689732876707
R722 n_3_6_12 n_4_6_12 239.37490482405536
R723 n_3_6_12 n_3_6_13 0.3778689732876743
R724 n_3_6_13 n_4_6_13 239.37490482405232
R725 n_3_6_13 n_3_6_14 1.8893448664383765
R726 n_3_6_14 n_4_6_14 26.59721164711703
R727 n_3_6_14 n_3_6_15 58.38075637294638
R728 n_3_6_15 n_4_6_15 8797.027752283873
R729 n_4_0_0 n_5_0_0 125.67181420979063
R730 n_4_0_0 n_4_1_0 43.56171513923102
R731 n_4_0_0 n_4_0_1 1.2370365753150994
R732 n_4_0_1 n_5_0_1 175.94053989370684
R733 n_4_0_1 n_4_1_1 60.986401194923424
R734 n_4_0_1 n_4_0_2 5.435463740020892
R735 n_4_0_2 n_5_0_2 628.3590710489531
R736 n_4_0_2 n_4_1_2 217.80857569615506
R737 n_4_0_2 n_4_0_3 5.255531147247787
R738 n_4_0_3 n_5_0_3 4398.513497342667
R739 n_4_0_3 n_4_1_3 1524.660029873084
R740 n_4_0_3 n_4_0_4 0.04873174387604942
R741 n_4_0_4 n_5_0_4 199.93243169739398
R742 n_4_0_4 n_4_1_4 69.30272863059473
R743 n_4_0_4 n_4_0_5 0.04266258896108356
R744 n_4_0_5 n_5_0_5 837.8120947319364
R745 n_4_0_5 n_4_0_6 0.009996255154061419
R746 n_4_0_6 n_5_0_6 139.63534912198944
R747 n_4_0_6 n_4_0_7 0.01356634628051191
R748 n_4_0_7 n_5_0_7 239.37488420912547
R749 n_4_0_7 n_4_0_8 0.009996255154061388
R750 n_4_0_8 n_5_0_8 239.37488420912547
R751 n_4_0_8 n_4_0_9 0.009996255154061388
R752 n_4_0_9 n_5_0_9 239.37488420912547
R753 n_4_0_9 n_4_0_10 0.009996255154061388
R754 n_4_0_10 n_5_0_10 239.37488420912547
R755 n_4_0_10 n_4_0_11 0.009996255154061323
R756 n_4_0_11 n_5_0_11 239.37488420912854
R757 n_4_0_11 n_4_0_12 0.00999625515406129
R758 n_4_0_12 n_5_0_12 239.3748842091271
R759 n_4_0_12 n_4_0_13 0.009996255154061388
R760 n_4_0_13 n_5_0_13 239.374884209124
R761 n_4_0_13 n_4_0_14 0.04998127577030706
R762 n_4_0_14 n_5_0_14 26.597209356569444
R763 n_4_0_14 n_4_0_15 1.5444214213025027
R764 n_4_0_15 n_5_0_15 8797.026994685257
R765 n_4_0_15 n_4_1_15 3049.3200597461414
R766 n_4_1_0 n_5_1_0 2771.5083275850366
R767 n_4_1_0 n_4_2_0 110.44365038628538
R768 n_4_1_0 n_4_1_1 27.281035063994285
R769 n_4_1_1 n_5_1_1 3880.1116586190506
R770 n_4_1_1 n_4_2_1 154.6211105407995
R771 n_4_1_1 n_4_1_2 119.8712146751264
R772 n_4_1_2 n_5_1_2 13857.541637925186
R773 n_4_1_2 n_4_2_2 552.2182519314268
R774 n_4_1_2 n_4_1_3 115.9030641203636
R775 n_4_1_3 n_5_1_3 97002.7914654762
R776 n_4_1_3 n_4_2_3 3865.5277635199845
R777 n_4_1_3 n_4_1_4 1.0747074419149274
R778 n_4_1_4 n_5_1_4 4409.217793885281
R779 n_4_1_4 n_4_2_4 175.70580743272657
R780 n_4_1_15 n_5_1_15 194005.58293095062
R781 n_4_1_15 n_4_2_15 7731.055527039901
R782 n_4_2_0 n_5_2_0 48.24335106234779
R783 n_4_2_0 n_4_3_0 110.44365362970511
R784 n_4_2_0 n_4_2_1 0.4748780795052884
R785 n_4_2_1 n_5_2_1 67.5406914872869
R786 n_4_2_1 n_4_3_1 154.6211150815871
R787 n_4_2_1 n_4_2_2 2.08658550085657
R788 n_4_2_2 n_5_2_2 241.2167553117389
R789 n_4_2_2 n_4_3_2 552.2182681485255
R790 n_4_2_2 n_4_2_3 2.0175123256558005
R791 n_4_2_3 n_5_2_3 1688.5172871821708
R792 n_4_2_3 n_4_3_3 3865.527877039675
R793 n_4_2_3 n_4_2_4 0.018707318283541677
R794 n_4_2_4 n_5_2_4 76.75078578100776
R795 n_4_2_4 n_4_3_4 175.70581259271248
R796 n_4_2_4 n_4_2_5 0.018707318283541677
R797 n_4_2_5 n_4_2_6 0.03741463656708336
R798 n_4_2_6 n_4_2_7 0.05468293036727562
R799 n_4_2_7 n_4_2_8 0.04029268553378195
R800 n_4_2_8 n_4_2_9 0.04029268553378195
R801 n_4_2_9 n_4_2_10 0.04029268553378195
R802 n_4_2_10 n_4_2_11 0.040292685533781694
R803 n_4_2_11 n_4_2_12 0.04029268553378157
R804 n_4_2_12 n_4_2_13 0.04029268553378195
R805 n_4_2_13 n_4_2_14 0.2014634276689103
R806 n_4_2_14 n_4_2_15 0.7569268782417682
R807 n_4_2_15 n_5_2_15 3377.0345743643115
R808 n_4_2_15 n_4_3_15 7731.0557540792815
R809 n_4_3_0 n_5_3_0 2771.503570386896
R810 n_4_3_0 n_4_4_0 110.4436536297051
R811 n_4_3_0 n_4_3_1 27.28098823704162
R812 n_4_3_1 n_5_3_1 3880.1049985416544
R813 n_4_3_1 n_4_4_1 154.6211150815871
R814 n_4_3_1 n_4_3_2 119.87100892033438
R815 n_4_3_2 n_5_3_2 13857.51785193448
R816 n_4_3_2 n_4_4_2 552.2182681485253
R817 n_4_3_2 n_4_3_3 115.90286517676468
R818 n_4_3_3 n_5_3_3 97002.62496354127
R819 n_4_3_3 n_4_4_3 3865.527877039674
R820 n_4_3_3 n_4_3_4 1.074705597216792
R821 n_4_3_4 n_5_3_4 4409.210225615513
R822 n_4_3_4 n_4_4_4 175.70581259271245
R823 n_4_3_15 n_5_3_15 194005.24992708082
R824 n_4_3_15 n_4_4_15 7731.055754079281
R825 n_4_4_0 n_5_4_0 48.2433510623478
R826 n_4_4_0 n_4_5_0 110.4436539750822
R827 n_4_4_0 n_4_4_1 0.4748780795052884
R828 n_4_4_1 n_5_4_1 67.5406914872869
R829 n_4_4_1 n_4_5_1 154.62111556511508
R830 n_4_4_1 n_4_4_2 2.0865855008565704
R831 n_4_4_2 n_5_4_2 241.21675531173898
R832 n_4_4_2 n_4_5_2 552.2182698754109
R833 n_4_4_2 n_4_4_3 2.017512325655801
R834 n_4_4_3 n_5_4_3 1688.517287182171
R835 n_4_4_3 n_4_5_3 3865.527889127873
R836 n_4_4_3 n_4_4_4 0.018707318283541684
R837 n_4_4_4 n_5_4_4 76.75078578100778
R838 n_4_4_4 n_4_5_4 175.70581314217605
R839 n_4_4_4 n_4_4_5 0.018707318283541684
R840 n_4_4_5 n_4_4_6 0.03741463656708337
R841 n_4_4_6 n_4_4_7 0.054682930367275624
R842 n_4_4_7 n_4_4_8 0.04029268553378196
R843 n_4_4_8 n_4_4_9 0.04029268553378196
R844 n_4_4_9 n_4_4_10 0.04029268553378196
R845 n_4_4_10 n_4_4_11 0.0402926855337817
R846 n_4_4_11 n_4_4_12 0.04029268553378157
R847 n_4_4_12 n_4_4_13 0.04029268553378196
R848 n_4_4_13 n_4_4_14 0.2014634276689103
R849 n_4_4_14 n_4_4_15 0.7569268782417683
R850 n_4_4_15 n_5_4_15 3377.034574364312
R851 n_4_4_15 n_4_5_15 7731.055778255679
R852 n_4_5_0 n_5_5_0 2771.50306381532
R853 n_4_5_0 n_4_6_0 43.56171513923103
R854 n_4_5_0 n_4_5_1 27.280983250660448
R855 n_4_5_1 n_5_5_1 3880.1042893414474
R856 n_4_5_1 n_4_6_1 60.98640119492344
R857 n_4_5_1 n_4_5_2 119.87098701047772
R858 n_4_5_2 n_5_5_2 13857.5153190766
R859 n_4_5_2 n_4_6_2 217.80857569615515
R860 n_4_5_2 n_4_5_3 115.90284399219983
R861 n_4_5_3 n_5_5_3 97002.6072335361
R862 n_4_5_3 n_4_6_3 1524.6600298730846
R863 n_4_5_3 n_4_5_4 1.0747054007835946
R864 n_4_5_4 n_5_5_4 4409.209419706187
R865 n_4_5_4 n_4_6_4 69.30272863059476
R866 n_4_5_15 n_5_5_15 194005.2144670705
R867 n_4_5_15 n_4_6_15 3049.3200597461423
R868 n_4_6_0 n_5_6_0 125.67182503262805
R869 n_4_6_0 n_4_6_1 1.2370366818485004
R870 n_4_6_1 n_5_6_1 175.94055504567922
R871 n_4_6_1 n_4_6_2 5.435464208122198
R872 n_4_6_2 n_5_6_2 628.3591251631401
R873 n_4_6_2 n_4_6_3 5.255531599853326
R874 n_4_6_3 n_5_6_3 4398.513876141978
R875 n_4_6_3 n_4_6_4 0.048731748072819756
R876 n_4_6_4 n_5_6_4 199.93244891554443
R877 n_4_6_4 n_4_6_5 0.0426625926351792
R878 n_4_6_5 n_5_6_5 837.8121668841861
R879 n_4_6_5 n_4_6_6 0.009996256014937387
R880 n_4_6_6 n_5_6_6 139.63536114736436
R881 n_4_6_6 n_4_6_7 0.01356634744884358
R882 n_4_6_7 n_5_6_7 239.37490482405397
R883 n_4_6_7 n_4_6_8 0.009996256014937354
R884 n_4_6_8 n_5_6_8 239.37490482405397
R885 n_4_6_8 n_4_6_9 0.009996256014937354
R886 n_4_6_9 n_5_6_9 239.37490482405397
R887 n_4_6_9 n_4_6_10 0.009996256014937354
R888 n_4_6_10 n_5_6_10 239.37490482405397
R889 n_4_6_10 n_4_6_11 0.00999625601493729
R890 n_4_6_11 n_5_6_11 239.37490482405693
R891 n_4_6_11 n_4_6_12 0.009996256014937258
R892 n_4_6_12 n_5_6_12 239.37490482405548
R893 n_4_6_12 n_4_6_13 0.009996256014937354
R894 n_4_6_13 n_5_6_13 239.37490482405244
R895 n_4_6_13 n_4_6_14 0.0499812800746869
R896 n_4_6_14 n_5_6_14 26.597211647117046
R897 n_4_6_14 n_4_6_15 1.5444215543078392
R898 n_4_6_15 n_5_6_15 8797.027752283877
R899 n_5_0_0 n_6_0_0 125.67181420979063
R900 n_5_0_0 n_5_1_0 1646.678571428548
R901 n_5_0_0 n_5_0_1 46.761281417274574
R902 n_5_0_1 n_6_0_1 175.94053989370684
R903 n_5_0_1 n_5_1_1 2305.3499999999676
R904 n_5_0_1 n_5_0_2 205.46623653044887
R905 n_5_0_2 n_6_0_2 628.3590710489531
R906 n_5_0_2 n_5_1_2 8233.39285714274
R907 n_5_0_2 n_5_0_3 198.6645955970271
R908 n_5_0_3 n_6_0_3 4398.513497342667
R909 n_5_0_3 n_5_1_3 57633.74999999913
R910 n_5_0_3 n_5_0_4 1.8421110861350607
R911 n_5_0_4 n_6_0_4 199.93243169739398
R912 n_5_0_4 n_5_1_4 2619.71590909087
R913 n_5_0_4 n_5_0_5 1.6126906578251996
R914 n_5_0_5 n_6_0_5 837.8120947319364
R915 n_5_0_5 n_5_0_6 0.3778689407456534
R916 n_5_0_6 n_6_0_6 139.63534912198944
R917 n_5_0_6 n_5_0_7 0.5128221338691005
R918 n_5_0_7 n_6_0_7 239.37488420912547
R919 n_5_0_7 n_5_0_8 0.37786894074565225
R920 n_5_0_8 n_6_0_8 239.37488420912547
R921 n_5_0_8 n_5_0_9 0.37786894074565225
R922 n_5_0_9 n_6_0_9 239.37488420912547
R923 n_5_0_9 n_5_0_10 0.37786894074565225
R924 n_5_0_10 n_6_0_10 239.37488420912547
R925 n_5_0_10 n_5_0_11 0.3778689407456498
R926 n_5_0_11 n_6_0_11 239.37488420912854
R927 n_5_0_11 n_5_0_12 0.3778689407456486
R928 n_5_0_12 n_6_0_12 239.3748842091271
R929 n_5_0_12 n_5_0_13 0.37786894074565225
R930 n_5_0_13 n_6_0_13 239.374884209124
R931 n_5_0_13 n_5_0_14 1.8893447037282658
R932 n_5_0_14 n_6_0_14 26.597209356569444
R933 n_5_0_14 n_5_0_15 58.38075134520396
R934 n_5_0_15 n_6_0_15 8797.026994685257
R935 n_5_0_15 n_5_1_15 115267.49999999725
R936 n_5_1_0 n_6_1_0 2771.5083275850366
R937 n_5_1_0 n_5_2_0 4174.885948823842
R938 n_5_1_0 n_5_1_1 1031.2517701079491
R939 n_5_1_1 n_6_1_1 3880.1116586190506
R940 n_5_1_1 n_5_2_1 5844.840328353379
R941 n_5_1_1 n_5_1_2 4531.25777774705
R942 n_5_1_2 n_6_1_2 13857.541637925186
R943 n_5_1_2 n_5_2_2 20874.429744119214
R944 n_5_1_2 n_5_1_3 4381.257520276802
R945 n_5_1_3 n_6_1_3 97002.7914654762
R946 n_5_1_3 n_5_2_3 146121.00820883433
R947 n_5_1_3 n_5_1_4 40.62506973152531
R948 n_5_1_4 n_6_1_4 4409.217793885281
R949 n_5_1_4 n_5_2_4 6641.86400949247
R950 n_5_1_15 n_6_1_15 194005.58293095062
R951 n_5_1_15 n_5_2_15 292242.0164176661
R952 n_5_2_0 n_6_2_0 48.24335106234779
R953 n_5_2_0 n_5_3_0 4174.886071428514
R954 n_5_2_0 n_5_2_1 17.950890020358017
R955 n_5_2_1 n_6_2_1 67.5406914872869
R956 n_5_2_1 n_5_3_1 5844.840499999918
R957 n_5_2_1 n_5_2_2 78.87512281672461
R958 n_5_2_2 n_6_2_2 241.2167553117389
R959 n_5_2_2 n_5_3_2 20874.43035714257
R960 n_5_2_2 n_5_2_3 76.2640842683089
R961 n_5_2_3 n_6_2_3 1688.5172871821708
R962 n_5_2_3 n_5_3_3 146121.01249999783
R963 n_5_2_3 n_5_2_4 0.7071562735292558
R964 n_5_2_4 n_6_2_4 76.75078578100776
R965 n_5_2_4 n_5_3_4 6641.864204545357
R966 n_5_2_15 n_6_2_15 3377.0345743643115
R967 n_5_2_15 n_5_3_15 292242.0249999931
R968 n_5_3_0 n_6_3_0 2771.503570386896
R969 n_5_3_0 n_5_4_0 4174.886071428513
R970 n_5_3_0 n_5_3_1 1031.2499999999707
R971 n_5_3_1 n_6_3_1 3880.1049985416544
R972 n_5_3_1 n_5_4_1 5844.8404999999175
R973 n_5_3_1 n_5_3_2 4531.249999999871
R974 n_5_3_2 n_6_3_2 13857.51785193448
R975 n_5_3_2 n_5_4_2 20874.430357142566
R976 n_5_3_2 n_5_3_3 4381.249999999875
R977 n_5_3_3 n_6_3_3 97002.62496354127
R978 n_5_3_3 n_5_4_3 146121.0124999978
R979 n_5_3_3 n_5_3_4 40.624999999998884
R980 n_5_3_4 n_6_3_4 4409.210225615513
R981 n_5_3_4 n_5_4_4 6641.864204545356
R982 n_5_3_15 n_6_3_15 194005.24992708082
R983 n_5_3_15 n_5_4_15 292242.02499999304
R984 n_5_4_0 n_6_4_0 48.2433510623478
R985 n_5_4_0 n_5_5_0 4174.88608448413
R986 n_5_4_0 n_5_4_1 17.950890020358017
R987 n_5_4_1 n_6_4_1 67.5406914872869
R988 n_5_4_1 n_5_5_1 5844.840518277782
R989 n_5_4_1 n_5_4_2 78.87512281672463
R990 n_5_4_2 n_6_4_2 241.21675531173898
R991 n_5_4_2 n_5_5_2 20874.430422420653
R992 n_5_4_2 n_5_4_3 76.26408426830892
R993 n_5_4_3 n_6_4_3 1688.517287182171
R994 n_5_4_3 n_5_5_3 146121.0129569444
R995 n_5_4_3 n_5_4_4 0.7071562735292559
R996 n_5_4_4 n_6_4_4 76.75078578100778
R997 n_5_4_4 n_5_5_4 6641.864225315657
R998 n_5_4_15 n_6_4_15 3377.034574364312
R999 n_5_4_15 n_5_5_15 292242.02591388626
R1000 n_5_5_0 n_6_5_0 2771.50306381532
R1001 n_5_5_0 n_5_6_0 1646.6785714285486
R1002 n_5_5_0 n_5_5_1 1031.249811509527
R1003 n_5_5_1 n_6_5_1 3880.1042893414474
R1004 n_5_5_1 n_5_6_1 2305.349999999968
R1005 n_5_5_1 n_5_5_2 4531.249171784285
R1006 n_5_5_2 n_6_5_2 13857.5153190766
R1007 n_5_5_2 n_5_6_2 8233.392857142744
R1008 n_5_5_2 n_5_5_3 4381.249199201081
R1009 n_5_5_3 n_6_5_3 97002.6072335361
R1010 n_5_5_3 n_5_6_3 57633.74999999915
R1011 n_5_5_3 n_5_5_4 40.624992574617764
R1012 n_5_5_4 n_6_5_4 4409.209419706187
R1013 n_5_5_4 n_5_6_4 2619.7159090908704
R1014 n_5_5_15 n_6_5_15 194005.2144670705
R1015 n_5_5_15 n_5_6_15 115267.49999999728
R1016 n_5_6_0 n_6_6_0 125.67182503262805
R1017 n_5_6_0 n_5_6_1 46.76128544434897
R1018 n_5_6_1 n_6_6_1 175.94055504567922
R1019 n_5_6_1 n_5_6_2 205.46625422516973
R1020 n_5_6_2 n_6_6_2 628.3591251631401
R1021 n_5_6_2 n_5_6_3 198.66461270599171
R1022 n_5_6_3 n_6_6_3 4398.513876141978
R1023 n_5_6_3 n_5_6_4 1.8421112447773855
R1024 n_5_6_4 n_6_6_4 199.93244891554443
R1025 n_5_6_4 n_5_6_5 1.6126907967098723
R1026 n_5_6_5 n_6_6_5 837.8121668841861
R1027 n_5_6_5 n_5_6_6 0.37786897328766883
R1028 n_5_6_6 n_6_6_6 139.63536114736436
R1029 n_5_6_6 n_5_6_7 0.5128221780332642
R1030 n_5_6_7 n_6_6_7 239.37490482405397
R1031 n_5_6_7 n_5_6_8 0.3778689732876676
R1032 n_5_6_8 n_6_6_8 239.37490482405397
R1033 n_5_6_8 n_5_6_9 0.3778689732876676
R1034 n_5_6_9 n_6_6_9 239.37490482405397
R1035 n_5_6_9 n_5_6_10 0.3778689732876676
R1036 n_5_6_10 n_6_6_10 239.37490482405397
R1037 n_5_6_10 n_5_6_11 0.3778689732876652
R1038 n_5_6_11 n_6_6_11 239.37490482405693
R1039 n_5_6_11 n_5_6_12 0.377868973287664
R1040 n_5_6_12 n_6_6_12 239.37490482405548
R1041 n_5_6_12 n_5_6_13 0.37786897328766755
R1042 n_5_6_13 n_6_6_13 239.37490482405244
R1043 n_5_6_13 n_5_6_14 1.8893448664383428
R1044 n_5_6_14 n_6_6_14 26.597211647117046
R1045 n_5_6_14 n_5_6_15 58.380756372945335
R1046 n_5_6_15 n_6_6_15 8797.027752283877
R1047 n_6_0_0 n_7_0_0 125.67181420979057
R1048 n_6_0_0 n_6_1_0 43.56171513923102
R1049 n_6_0_0 n_6_0_1 1.2370365753150994
R1050 n_6_0_1 n_7_0_1 175.94053989370676
R1051 n_6_0_1 n_6_1_1 60.986401194923424
R1052 n_6_0_1 n_6_0_2 5.435463740020892
R1053 n_6_0_2 n_7_0_2 628.3590710489527
R1054 n_6_0_2 n_6_1_2 217.80857569615506
R1055 n_6_0_2 n_6_0_3 5.255531147247787
R1056 n_6_0_3 n_7_0_3 4398.513497342665
R1057 n_6_0_3 n_6_1_3 1524.660029873084
R1058 n_6_0_3 n_6_0_4 0.04873174387604942
R1059 n_6_0_4 n_7_0_4 199.9324316973939
R1060 n_6_0_4 n_6_1_4 69.30272863059473
R1061 n_6_0_4 n_6_0_5 0.04266258896108356
R1062 n_6_0_5 n_7_0_5 837.8120947319361
R1063 n_6_0_5 n_6_0_6 0.009996255154061419
R1064 n_6_0_6 n_7_0_6 139.63534912198938
R1065 n_6_0_6 n_6_0_7 0.01356634628051191
R1066 n_6_0_7 n_7_0_7 239.37488420912536
R1067 n_6_0_7 n_6_0_8 0.009996255154061388
R1068 n_6_0_8 n_7_0_8 239.37488420912536
R1069 n_6_0_8 n_6_0_9 0.009996255154061388
R1070 n_6_0_9 n_7_0_9 239.37488420912536
R1071 n_6_0_9 n_6_0_10 0.009996255154061388
R1072 n_6_0_10 n_7_0_10 239.37488420912536
R1073 n_6_0_10 n_6_0_11 0.009996255154061323
R1074 n_6_0_11 n_7_0_11 239.37488420912842
R1075 n_6_0_11 n_6_0_12 0.00999625515406129
R1076 n_6_0_12 n_7_0_12 239.37488420912698
R1077 n_6_0_12 n_6_0_13 0.009996255154061388
R1078 n_6_0_13 n_7_0_13 239.37488420912388
R1079 n_6_0_13 n_6_0_14 0.04998127577030706
R1080 n_6_0_14 n_7_0_14 26.59720935656943
R1081 n_6_0_14 n_6_0_15 1.5444214213025027
R1082 n_6_0_15 n_7_0_15 8797.026994685253
R1083 n_6_0_15 n_6_1_15 3049.3200597461414
R1084 n_6_1_0 n_7_1_0 2771.508327585035
R1085 n_6_1_0 n_6_2_0 110.44365038628538
R1086 n_6_1_0 n_6_1_1 27.281035063994285
R1087 n_6_1_1 n_7_1_1 3880.1116586190487
R1088 n_6_1_1 n_6_2_1 154.6211105407995
R1089 n_6_1_1 n_6_1_2 119.8712146751264
R1090 n_6_1_2 n_7_1_2 13857.541637925178
R1091 n_6_1_2 n_6_2_2 552.2182519314268
R1092 n_6_1_2 n_6_1_3 115.9030641203636
R1093 n_6_1_3 n_7_1_3 97002.79146547616
R1094 n_6_1_3 n_6_2_3 3865.5277635199845
R1095 n_6_1_3 n_6_1_4 1.0747074419149274
R1096 n_6_1_4 n_7_1_4 4409.217793885279
R1097 n_6_1_4 n_6_2_4 175.70580743272657
R1098 n_6_1_15 n_7_1_15 194005.58293095054
R1099 n_6_1_15 n_6_2_15 7731.055527039901
R1100 n_6_2_0 n_7_2_0 48.24335106234777
R1101 n_6_2_0 n_6_3_0 110.44365362970511
R1102 n_6_2_0 n_6_2_1 0.4748780795052884
R1103 n_6_2_1 n_7_2_1 67.54069148728688
R1104 n_6_2_1 n_6_3_1 154.6211150815871
R1105 n_6_2_1 n_6_2_2 2.08658550085657
R1106 n_6_2_2 n_7_2_2 241.2167553117388
R1107 n_6_2_2 n_6_3_2 552.2182681485255
R1108 n_6_2_2 n_6_2_3 2.0175123256558005
R1109 n_6_2_3 n_7_2_3 1688.51728718217
R1110 n_6_2_3 n_6_3_3 3865.527877039675
R1111 n_6_2_3 n_6_2_4 0.018707318283541677
R1112 n_6_2_4 n_7_2_4 76.75078578100774
R1113 n_6_2_4 n_6_3_4 175.70581259271248
R1114 n_6_2_4 n_6_2_5 0.018707318283541677
R1115 n_6_2_5 n_6_2_6 0.03741463656708336
R1116 n_6_2_6 n_6_2_7 0.05468293036727562
R1117 n_6_2_7 n_6_2_8 0.04029268553378195
R1118 n_6_2_8 n_6_2_9 0.04029268553378195
R1119 n_6_2_9 n_6_2_10 0.04029268553378195
R1120 n_6_2_10 n_6_2_11 0.040292685533781694
R1121 n_6_2_11 n_6_2_12 0.04029268553378157
R1122 n_6_2_12 n_6_2_13 0.04029268553378195
R1123 n_6_2_13 n_6_2_14 0.2014634276689103
R1124 n_6_2_14 n_6_2_15 0.7569268782417682
R1125 n_6_2_15 n_7_2_15 3377.03457436431
R1126 n_6_2_15 n_6_3_15 7731.0557540792815
R1127 n_6_3_0 n_7_3_0 2771.503570386895
R1128 n_6_3_0 n_6_4_0 110.4436536297051
R1129 n_6_3_0 n_6_3_1 27.28098823704162
R1130 n_6_3_1 n_7_3_1 3880.1049985416525
R1131 n_6_3_1 n_6_4_1 154.6211150815871
R1132 n_6_3_1 n_6_3_2 119.87100892033438
R1133 n_6_3_2 n_7_3_2 13857.517851934475
R1134 n_6_3_2 n_6_4_2 552.2182681485253
R1135 n_6_3_2 n_6_3_3 115.90286517676468
R1136 n_6_3_3 n_7_3_3 97002.62496354122
R1137 n_6_3_3 n_6_4_3 3865.527877039674
R1138 n_6_3_3 n_6_3_4 1.074705597216792
R1139 n_6_3_4 n_7_3_4 4409.21022561551
R1140 n_6_3_4 n_6_4_4 175.70581259271245
R1141 n_6_3_15 n_7_3_15 194005.24992708073
R1142 n_6_3_15 n_6_4_15 7731.055754079281
R1143 n_6_4_0 n_7_4_0 48.24335106234778
R1144 n_6_4_0 n_6_5_0 110.4436539750822
R1145 n_6_4_0 n_6_4_1 0.4748780795052884
R1146 n_6_4_1 n_7_4_1 67.54069148728688
R1147 n_6_4_1 n_6_5_1 154.62111556511508
R1148 n_6_4_1 n_6_4_2 2.0865855008565704
R1149 n_6_4_2 n_7_4_2 241.21675531173886
R1150 n_6_4_2 n_6_5_2 552.2182698754109
R1151 n_6_4_2 n_6_4_3 2.017512325655801
R1152 n_6_4_3 n_7_4_3 1688.5172871821703
R1153 n_6_4_3 n_6_5_3 3865.527889127873
R1154 n_6_4_3 n_6_4_4 0.018707318283541684
R1155 n_6_4_4 n_7_4_4 76.75078578100775
R1156 n_6_4_4 n_6_5_4 175.70581314217605
R1157 n_6_4_4 n_6_4_5 0.018707318283541684
R1158 n_6_4_5 n_6_4_6 0.03741463656708337
R1159 n_6_4_6 n_6_4_7 0.054682930367275624
R1160 n_6_4_7 n_6_4_8 0.04029268553378196
R1161 n_6_4_8 n_6_4_9 0.04029268553378196
R1162 n_6_4_9 n_6_4_10 0.04029268553378196
R1163 n_6_4_10 n_6_4_11 0.0402926855337817
R1164 n_6_4_11 n_6_4_12 0.04029268553378157
R1165 n_6_4_12 n_6_4_13 0.04029268553378196
R1166 n_6_4_13 n_6_4_14 0.2014634276689103
R1167 n_6_4_14 n_6_4_15 0.7569268782417683
R1168 n_6_4_15 n_7_4_15 3377.0345743643106
R1169 n_6_4_15 n_6_5_15 7731.055778255679
R1170 n_6_5_0 n_7_5_0 2771.503063815319
R1171 n_6_5_0 n_6_6_0 43.56171513923103
R1172 n_6_5_0 n_6_5_1 27.280983250660448
R1173 n_6_5_1 n_7_5_1 3880.1042893414456
R1174 n_6_5_1 n_6_6_1 60.98640119492344
R1175 n_6_5_1 n_6_5_2 119.87098701047772
R1176 n_6_5_2 n_7_5_2 13857.515319076592
R1177 n_6_5_2 n_6_6_2 217.80857569615515
R1178 n_6_5_2 n_6_5_3 115.90284399219983
R1179 n_6_5_3 n_7_5_3 97002.60723353605
R1180 n_6_5_3 n_6_6_3 1524.6600298730846
R1181 n_6_5_3 n_6_5_4 1.0747054007835946
R1182 n_6_5_4 n_7_5_4 4409.209419706184
R1183 n_6_5_4 n_6_6_4 69.30272863059476
R1184 n_6_5_15 n_7_5_15 194005.21446707041
R1185 n_6_5_15 n_6_6_15 3049.3200597461423
R1186 n_6_6_0 n_7_6_0 125.67182503262798
R1187 n_6_6_0 n_6_6_1 1.2370366818485004
R1188 n_6_6_1 n_7_6_1 175.94055504567916
R1189 n_6_6_1 n_6_6_2 5.435464208122198
R1190 n_6_6_2 n_7_6_2 628.3591251631399
R1191 n_6_6_2 n_6_6_3 5.255531599853326
R1192 n_6_6_3 n_7_6_3 4398.513876141975
R1193 n_6_6_3 n_6_6_4 0.048731748072819756
R1194 n_6_6_4 n_7_6_4 199.9324489155443
R1195 n_6_6_4 n_6_6_5 0.0426625926351792
R1196 n_6_6_5 n_7_6_5 837.8121668841858
R1197 n_6_6_5 n_6_6_6 0.009996256014937387
R1198 n_6_6_6 n_7_6_6 139.6353611473643
R1199 n_6_6_6 n_6_6_7 0.01356634744884358
R1200 n_6_6_7 n_7_6_7 239.37490482405386
R1201 n_6_6_7 n_6_6_8 0.009996256014937354
R1202 n_6_6_8 n_7_6_8 239.37490482405386
R1203 n_6_6_8 n_6_6_9 0.009996256014937354
R1204 n_6_6_9 n_7_6_9 239.37490482405386
R1205 n_6_6_9 n_6_6_10 0.009996256014937354
R1206 n_6_6_10 n_7_6_10 239.37490482405386
R1207 n_6_6_10 n_6_6_11 0.00999625601493729
R1208 n_6_6_11 n_7_6_11 239.3749048240568
R1209 n_6_6_11 n_6_6_12 0.009996256014937258
R1210 n_6_6_12 n_7_6_12 239.37490482405536
R1211 n_6_6_12 n_6_6_13 0.009996256014937354
R1212 n_6_6_13 n_7_6_13 239.37490482405232
R1213 n_6_6_13 n_6_6_14 0.0499812800746869
R1214 n_6_6_14 n_7_6_14 26.59721164711703
R1215 n_6_6_14 n_6_6_15 1.5444215543078392
R1216 n_6_6_15 n_7_6_15 8797.027752283873
R1217 n_7_0_0 n_8_0_0 19.58524410956276
R1218 n_7_0_0 n_7_1_0 1646.6785714285777
R1219 n_7_0_0 n_7_0_1 46.761281417275406
R1220 n_7_0_1 n_8_0_1 27.419341753387855
R1221 n_7_0_1 n_7_1_1 2305.3500000000085
R1222 n_7_0_1 n_7_0_2 205.4662365304525
R1223 n_7_0_2 n_8_0_2 97.92622054781378
R1224 n_7_0_2 n_7_1_2 8233.392857142888
R1225 n_7_0_2 n_7_0_3 198.66459559703063
R1226 n_7_0_3 n_8_0_3 685.4835438346958
R1227 n_7_0_3 n_7_1_3 57633.750000000146
R1228 n_7_0_3 n_7_0_4 1.8421110861350933
R1229 n_7_0_4 n_8_0_4 31.158342901577086
R1230 n_7_0_4 n_7_1_4 2619.7159090909163
R1231 n_7_0_4 n_7_0_5 1.612690657825228
R1232 n_7_0_5 n_8_0_5 130.56829406375158
R1233 n_7_0_5 n_7_0_6 0.37786894074566013
R1234 n_7_0_6 n_8_0_6 21.761382343958598
R1235 n_7_0_6 n_7_0_7 0.5128221338691096
R1236 n_7_0_7 n_8_0_7 37.30522687535771
R1237 n_7_0_7 n_7_0_8 0.37786894074565897
R1238 n_7_0_8 n_8_0_8 37.30522687535771
R1239 n_7_0_8 n_7_0_9 0.37786894074565897
R1240 n_7_0_9 n_8_0_9 37.30522687535771
R1241 n_7_0_9 n_7_0_10 0.37786894074565897
R1242 n_7_0_10 n_8_0_10 37.30522687535771
R1243 n_7_0_10 n_7_0_11 0.3778689407456566
R1244 n_7_0_11 n_8_0_11 37.30522687535819
R1245 n_7_0_11 n_7_0_12 0.37786894074565536
R1246 n_7_0_12 n_8_0_12 37.30522687535796
R1247 n_7_0_12 n_7_0_13 0.377868940745659
R1248 n_7_0_13 n_8_0_13 37.30522687535748
R1249 n_7_0_13 n_7_0_14 1.8893447037282995
R1250 n_7_0_14 n_8_0_14 4.14502520837307
R1251 n_7_0_14 n_7_0_15 58.380751345205
R1252 n_7_0_15 n_8_0_15 1370.9670876693795
R1253 n_7_0_15 n_7_1_15 115267.49999999929
R1254 n_7_1_0 n_8_1_0 431.92395597015394
R1255 n_7_1_0 n_7_2_0 4174.885948823918
R1256 n_7_1_0 n_7_1_1 1031.2517701079676
R1257 n_7_1_1 n_8_1_1 604.6935383582155
R1258 n_7_1_1 n_7_2_1 5844.8403283534835
R1259 n_7_1_1 n_7_1_2 4531.25777774713
R1260 n_7_1_2 n_8_1_2 2159.61977985077
R1261 n_7_1_2 n_7_2_2 20874.42974411958
R1262 n_7_1_2 n_7_1_3 4381.25752027688
R1263 n_7_1_3 n_8_1_3 15117.338458955375
R1264 n_7_1_3 n_7_2_3 146121.00820883692
R1265 n_7_1_3 n_7_1_4 40.62506973152603
R1266 n_7_1_4 n_8_1_4 687.1517481343352
R1267 n_7_1_4 n_7_2_4 6641.8640094925895
R1268 n_7_1_15 n_8_1_15 30234.676917910474
R1269 n_7_1_15 n_7_2_15 292242.0164176713
R1270 n_7_2_0 n_8_2_0 7.518454421626428
R1271 n_7_2_0 n_7_3_0 4174.886071428588
R1272 n_7_2_0 n_7_2_1 17.950890020358333
R1273 n_7_2_1 n_8_2_1 10.525836190276998
R1274 n_7_2_1 n_7_3_1 5844.840500000023
R1275 n_7_2_1 n_7_2_2 78.875122816726
R1276 n_7_2_2 n_8_2_2 37.592272108132136
R1277 n_7_2_2 n_7_3_2 20874.430357142937
R1278 n_7_2_2 n_7_2_3 76.26408426831026
R1279 n_7_2_3 n_8_2_3 263.1459047569247
R1280 n_7_2_3 n_7_3_3 146121.0125000004
R1281 n_7_2_3 n_7_2_4 0.7071562735292682
R1282 n_7_2_4 n_8_2_4 11.961177488951124
R1283 n_7_2_4 n_7_3_4 6641.864204545475
R1284 n_7_2_15 n_8_2_15 526.2918095138448
R1285 n_7_2_15 n_7_3_15 292242.0249999983
R1286 n_7_3_0 n_8_3_0 431.92321458762956
R1287 n_7_3_0 n_7_4_0 4174.8860714285875
R1288 n_7_3_0 n_7_3_1 1031.249999999989
R1289 n_7_3_1 n_8_3_1 604.6925004226814
R1290 n_7_3_1 n_7_4_1 5844.840500000022
R1291 n_7_3_1 n_7_3_2 4531.249999999952
R1292 n_7_3_2 n_8_3_2 2159.616072938148
R1293 n_7_3_2 n_7_4_2 20874.430357142934
R1294 n_7_3_2 n_7_3_3 4381.249999999954
R1295 n_7_3_3 n_8_3_3 15117.312510567022
R1296 n_7_3_3 n_7_4_3 146121.0125000004
R1297 n_7_3_3 n_7_3_4 40.6249999999996
R1298 n_7_3_4 n_8_3_4 687.1505686621374
R1299 n_7_3_4 n_7_4_4 6641.864204545474
R1300 n_7_3_15 n_8_3_15 30234.625021133776
R1301 n_7_3_15 n_7_4_15 292242.0249999982
R1302 n_7_4_0 n_8_4_0 7.518454421626429
R1303 n_7_4_0 n_7_5_0 4174.886084484206
R1304 n_7_4_0 n_7_4_1 17.950890020358337
R1305 n_7_4_1 n_8_4_1 10.525836190277001
R1306 n_7_4_1 n_7_5_1 5844.840518277887
R1307 n_7_4_1 n_7_4_2 78.87512281672602
R1308 n_7_4_2 n_8_4_2 37.59227210813214
R1309 n_7_4_2 n_7_5_2 20874.43042242102
R1310 n_7_4_2 n_7_4_3 76.26408426831027
R1311 n_7_4_3 n_8_4_3 263.1459047569248
R1312 n_7_4_3 n_7_5_3 146121.01295694703
R1313 n_7_4_3 n_7_4_4 0.7071562735292684
R1314 n_7_4_4 n_8_4_4 11.961177488951126
R1315 n_7_4_4 n_7_5_4 6641.864225315775
R1316 n_7_4_15 n_8_4_15 526.2918095138449
R1317 n_7_4_15 n_7_5_15 292242.02591389144
R1318 n_7_5_0 n_8_5_0 431.9231356413039
R1319 n_7_5_0 n_7_6_0 1646.6785714285782
R1320 n_7_5_0 n_7_5_1 1031.2498115095452
R1321 n_7_5_1 n_8_5_1 604.6923898978254
R1322 n_7_5_1 n_7_6_1 2305.350000000009
R1323 n_7_5_1 n_7_5_2 4531.249171784365
R1324 n_7_5_2 n_8_5_2 2159.615678206519
R1325 n_7_5_2 n_7_6_2 8233.39285714289
R1326 n_7_5_2 n_7_5_3 4381.249199201158
R1327 n_7_5_3 n_8_5_3 15117.30974744562
R1328 n_7_5_3 n_7_6_3 57633.75000000017
R1329 n_7_5_3 n_7_5_4 40.62499257461849
R1330 n_7_5_4 n_8_5_4 687.1504430657101
R1331 n_7_5_4 n_7_6_4 2619.7159090909176
R1332 n_7_5_15 n_8_5_15 30234.619494890976
R1333 n_7_5_15 n_7_6_15 115267.49999999932
R1334 n_7_6_0 n_8_6_0 19.585245796240986
R1335 n_7_6_0 n_7_6_1 46.761285444349795
R1336 n_7_6_1 n_8_6_1 27.419344114737378
R1337 n_7_6_1 n_7_6_2 205.4662542251734
R1338 n_7_6_2 n_8_6_2 97.92622898120493
R1339 n_7_6_2 n_7_6_3 198.66461270599524
R1340 n_7_6_3 n_8_6_3 685.4836028684338
R1341 n_7_6_3 n_7_6_4 1.842111244777418
R1342 n_7_6_4 n_8_6_4 31.15834558492881
R1343 n_7_6_4 n_7_6_5 1.612690796709901
R1344 n_7_6_5 n_8_6_5 130.56830530827312
R1345 n_7_6_5 n_7_6_6 0.37786897328767555
R1346 n_7_6_6 n_8_6_6 21.761384218045517
R1347 n_7_6_6 n_7_6_7 0.5128221780332733
R1348 n_7_6_7 n_8_6_7 37.30523008807816
R1349 n_7_6_7 n_7_6_8 0.3778689732876743
R1350 n_7_6_8 n_8_6_8 37.30523008807816
R1351 n_7_6_8 n_7_6_9 0.3778689732876743
R1352 n_7_6_9 n_8_6_9 37.30523008807816
R1353 n_7_6_9 n_7_6_10 0.3778689732876743
R1354 n_7_6_10 n_8_6_10 37.30523008807816
R1355 n_7_6_10 n_7_6_11 0.3778689732876719
R1356 n_7_6_11 n_8_6_11 37.305230088078616
R1357 n_7_6_11 n_7_6_12 0.3778689732876707
R1358 n_7_6_12 n_8_6_12 37.30523008807839
R1359 n_7_6_12 n_7_6_13 0.3778689732876743
R1360 n_7_6_13 n_8_6_13 37.30523008807792
R1361 n_7_6_13 n_7_6_14 1.8893448664383765
R1362 n_7_6_14 n_8_6_14 4.145025565342007
R1363 n_7_6_14 n_7_6_15 58.38075637294638
R1364 n_7_6_15 n_8_6_15 1370.9672057368557
R1365 n_8_0_0 n_8_1_0 326.2736359366237
R1366 n_8_0_0 n_8_0_1 9.265301421778945
R1367 n_8_0_1 n_8_1_1 456.78309031127316
R1368 n_8_0_1 n_8_0_2 40.711172913877185
R1369 n_8_0_2 n_8_1_2 1631.3681796831186
R1370 n_8_0_2 n_8_0_3 39.36349270707298
R1371 n_8_0_3 n_8_1_3 11419.577257781819
R1372 n_8_0_3 n_8_0_4 0.3649967226761406
R1373 n_8_0_4 n_8_1_4 519.0716935355372
R1374 n_8_0_4 n_8_0_5 0.31953925538314143
R1375 n_8_0_5 n_8_1_5 2175.157572910822
R1376 n_8_0_5 n_8_0_6 0.07487112260023397
R1377 n_8_0_6 n_8_1_6 362.5262621518038
R1378 n_8_0_6 n_8_0_7 0.10161080924317456
R1379 n_8_0_7 n_8_1_7 621.4735922602371
R1380 n_8_0_7 n_8_0_8 0.07487112260023374
R1381 n_8_0_8 n_8_1_8 621.4735922602371
R1382 n_8_0_8 n_8_0_9 0.07487112260023374
R1383 n_8_0_9 n_8_1_9 621.4735922602371
R1384 n_8_0_9 n_8_0_10 0.07487112260023374
R1385 n_8_0_10 n_8_1_10 621.4735922602371
R1386 n_8_0_10 n_8_0_11 0.07487112260023326
R1387 n_8_0_11 n_8_1_11 621.4735922602448
R1388 n_8_0_11 n_8_0_12 0.07487112260023301
R1389 n_8_0_12 n_8_1_12 621.4735922602408
R1390 n_8_0_12 n_8_0_13 0.07487112260023374
R1391 n_8_0_13 n_8_1_13 621.473592260233
R1392 n_8_0_13 n_8_0_14 0.3743556130011696
R1393 n_8_0_14 n_8_1_14 69.05262136224843
R1394 n_8_0_14 n_8_0_15 11.567588441736248
R1395 n_8_0_15 n_8_1_15 22839.154515563438
R1396 n_8_1_0 n_8_2_0 827.2137876682037
R1397 n_8_1_0 n_8_1_1 204.33269153876256
R1398 n_8_1_1 n_8_2_1 1158.099302735485
R1399 n_8_1_1 n_8_1_2 897.8254628218356
R1400 n_8_1_2 n_8_2_2 4136.068938341018
R1401 n_8_1_2 n_8_1_3 868.104344052561
R1402 n_8_1_3 n_8_2_3 28952.482568387102
R1403 n_8_1_3 n_8_1_4 8.049469666678533
R1404 n_8_1_4 n_8_2_4 1316.0219349266863
R1405 n_8_1_4 n_8_1_5 7.046971612953001
R1406 n_8_1_5 n_8_2_5 5514.758584454686
R1407 n_8_1_5 n_8_1_6 1.651173264959699
R1408 n_8_1_6 n_8_2_6 919.1264307424478
R1409 n_8_1_6 n_8_1_7 2.2408780024453034
R1410 n_8_1_7 n_8_2_7 1575.6453098442012
R1411 n_8_1_7 n_8_1_8 1.651173264959694
R1412 n_8_1_8 n_8_2_8 1575.6453098442012
R1413 n_8_1_8 n_8_1_9 1.651173264959694
R1414 n_8_1_9 n_8_2_9 1575.6453098442012
R1415 n_8_1_9 n_8_1_10 1.651173264959694
R1416 n_8_1_10 n_8_2_10 1575.6453098442012
R1417 n_8_1_10 n_8_1_11 1.6511732649596835
R1418 n_8_1_11 n_8_2_11 1575.645309844221
R1419 n_8_1_11 n_8_1_12 1.6511732649596782
R1420 n_8_1_12 n_8_2_12 1575.645309844211
R1421 n_8_1_12 n_8_1_13 1.6511732649596942
R1422 n_8_1_13 n_8_2_13 1575.645309844191
R1423 n_8_1_13 n_8_1_14 8.255866324798491
R1424 n_8_1_14 n_8_2_14 175.0717010937998
R1425 n_8_1_14 n_8_1_15 255.1062694362757
R1426 n_8_1_15 n_8_2_15 57904.965136773695
R1427 n_8_2_0 n_8_3_0 827.2138119611487
R1428 n_8_2_0 n_8_2_1 3.5567974569315037
R1429 n_8_2_1 n_8_3_1 1158.099336745608
R1430 n_8_2_1 n_8_2_2 15.628352462274789
R1431 n_8_2_2 n_8_3_2 4136.069059805744
R1432 n_8_2_2 n_8_2_3 15.111000104902933
R1433 n_8_2_3 n_8_3_3 28952.483418640175
R1434 n_8_2_3 n_8_2_4 0.14011626345487754
R1435 n_8_2_4 n_8_3_4 1316.0219735745534
R1436 n_8_2_4 n_8_2_5 0.12266588632130306
R1437 n_8_2_5 n_8_3_5 5514.758746407652
R1438 n_8_2_5 n_8_2_6 0.028741797631769754
R1439 n_8_2_6 n_8_3_6 919.1264577346088
R1440 n_8_2_6 n_8_2_7 0.03900672535740177
R1441 n_8_2_7 n_8_3_7 1575.6453561164772
R1442 n_8_2_7 n_8_2_8 0.028741797631769664
R1443 n_8_2_8 n_8_3_8 1575.6453561164772
R1444 n_8_2_8 n_8_2_9 0.028741797631769664
R1445 n_8_2_9 n_8_3_9 1575.6453561164772
R1446 n_8_2_9 n_8_2_10 0.028741797631769664
R1447 n_8_2_10 n_8_3_10 1575.6453561164772
R1448 n_8_2_10 n_8_2_11 0.02874179763176948
R1449 n_8_2_11 n_8_3_11 1575.6453561164972
R1450 n_8_2_11 n_8_2_12 0.028741797631769386
R1451 n_8_2_12 n_8_3_12 1575.645356116487
R1452 n_8_2_12 n_8_2_13 0.028741797631769664
R1453 n_8_2_13 n_8_3_13 1575.645356116467
R1454 n_8_2_13 n_8_2_14 0.1437089881588487
R1455 n_8_2_14 n_8_3_14 175.07170623516382
R1456 n_8_2_14 n_8_2_15 4.4406077341084655
R1457 n_8_2_15 n_8_3_15 57904.96683727984
R1458 n_8_3_0 n_8_4_0 827.2138119611486
R1459 n_8_3_0 n_8_3_1 204.33234080876815
R1460 n_8_3_1 n_8_4_1 1158.099336745608
R1461 n_8_3_1 n_8_3_2 897.8239217354965
R1462 n_8_3_2 n_8_4_2 4136.069059805743
R1463 n_8_3_2 n_8_3_3 868.1028539814938
R1464 n_8_3_3 n_8_4_3 28952.483418640168
R1465 n_8_3_3 n_8_3_4 8.049455850042389
R1466 n_8_3_4 n_8_4_4 1316.0219735745534
R1467 n_8_3_4 n_8_3_5 7.046959517070077
R1468 n_8_3_5 n_8_4_5 5514.758746407652
R1469 n_8_3_5 n_8_3_6 1.6511704307779262
R1470 n_8_3_6 n_8_4_6 919.1264577346087
R1471 n_8_3_6 n_8_3_7 2.2408741560557544
R1472 n_8_3_7 n_8_4_7 1575.645356116477
R1473 n_8_3_7 n_8_3_8 1.651170430777921
R1474 n_8_3_8 n_8_4_8 1575.645356116477
R1475 n_8_3_8 n_8_3_9 1.651170430777921
R1476 n_8_3_9 n_8_4_9 1575.645356116477
R1477 n_8_3_9 n_8_3_10 1.651170430777921
R1478 n_8_3_10 n_8_4_10 1575.645356116477
R1479 n_8_3_10 n_8_3_11 1.6511704307779103
R1480 n_8_3_11 n_8_4_11 1575.645356116497
R1481 n_8_3_11 n_8_3_12 1.6511704307779052
R1482 n_8_3_12 n_8_4_12 1575.6453561164867
R1483 n_8_3_12 n_8_3_13 1.651170430777921
R1484 n_8_3_13 n_8_4_13 1575.6453561164667
R1485 n_8_3_13 n_8_3_14 8.255852153889625
R1486 n_8_3_14 n_8_4_14 175.0717062351638
R1487 n_8_3_14 n_8_3_15 255.1058315551918
R1488 n_8_3_15 n_8_4_15 57904.96683727983
R1489 n_8_4_0 n_8_5_0 827.2138145479945
R1490 n_8_4_0 n_8_4_1 3.556797456931504
R1491 n_8_4_1 n_8_5_1 1158.0993403671923
R1492 n_8_4_1 n_8_4_2 15.628352462274794
R1493 n_8_4_2 n_8_5_2 4136.069072739972
R1494 n_8_4_2 n_8_4_3 15.111000104902939
R1495 n_8_4_3 n_8_5_3 28952.483509179776
R1496 n_8_4_3 n_8_4_4 0.14011626345487757
R1497 n_8_4_4 n_8_5_4 1316.02197768999
R1498 n_8_4_4 n_8_4_5 0.12266588632130307
R1499 n_8_4_5 n_8_5_5 5514.758763653292
R1500 n_8_4_5 n_8_4_6 0.028741797631769758
R1501 n_8_4_6 n_8_5_6 919.126460608882
R1502 n_8_4_6 n_8_4_7 0.03900672535740177
R1503 n_8_4_7 n_8_5_7 1575.6453610438025
R1504 n_8_4_7 n_8_4_8 0.028741797631769667
R1505 n_8_4_8 n_8_5_8 1575.6453610438025
R1506 n_8_4_8 n_8_4_9 0.028741797631769667
R1507 n_8_4_9 n_8_5_9 1575.6453610438025
R1508 n_8_4_9 n_8_4_10 0.028741797631769667
R1509 n_8_4_10 n_8_5_10 1575.6453610438025
R1510 n_8_4_10 n_8_4_11 0.028741797631769483
R1511 n_8_4_11 n_8_5_11 1575.6453610438225
R1512 n_8_4_11 n_8_4_12 0.028741797631769393
R1513 n_8_4_12 n_8_5_12 1575.6453610438123
R1514 n_8_4_12 n_8_4_13 0.028741797631769667
R1515 n_8_4_13 n_8_5_13 1575.6453610437925
R1516 n_8_4_13 n_8_4_14 0.14370898815884872
R1517 n_8_4_14 n_8_5_14 175.0717067826444
R1518 n_8_4_14 n_8_4_15 4.440607734108466
R1519 n_8_4_15 n_8_5_15 57904.96701835905
R1520 n_8_5_0 n_8_6_0 326.2736359366238
R1521 n_8_5_0 n_8_5_1 204.33230346118654
R1522 n_8_5_1 n_8_6_1 456.7830903112733
R1523 n_8_5_1 n_8_5_2 897.8237576324863
R1524 n_8_5_2 n_8_6_2 1631.3681796831188
R1525 n_8_5_2 n_8_5_3 868.1026953108592
R1526 n_8_5_3 n_8_6_3 11419.577257781822
R1527 n_8_5_3 n_8_5_4 8.049454378774023
R1528 n_8_5_4 n_8_6_4 519.0716935355374
R1529 n_8_5_4 n_8_5_5 7.046958229036599
R1530 n_8_5_5 n_8_6_5 2175.157572910823
R1531 n_8_5_5 n_8_5_6 1.6511701289792864
R1532 n_8_5_6 n_8_6_6 362.5262621518039
R1533 n_8_5_6 n_8_5_7 2.240873746471886
R1534 n_8_5_7 n_8_6_7 621.4735922602372
R1535 n_8_5_7 n_8_5_8 1.6511701289792813
R1536 n_8_5_8 n_8_6_8 621.4735922602372
R1537 n_8_5_8 n_8_5_9 1.6511701289792813
R1538 n_8_5_9 n_8_6_9 621.4735922602372
R1539 n_8_5_9 n_8_5_10 1.6511701289792813
R1540 n_8_5_10 n_8_6_10 621.4735922602372
R1541 n_8_5_10 n_8_5_11 1.6511701289792708
R1542 n_8_5_11 n_8_6_11 621.473592260245
R1543 n_8_5_11 n_8_5_12 1.6511701289792655
R1544 n_8_5_12 n_8_6_12 621.473592260241
R1545 n_8_5_12 n_8_5_13 1.6511701289792813
R1546 n_8_5_13 n_8_6_13 621.4735922602331
R1547 n_8_5_13 n_8_5_14 8.255850644896428
R1548 n_8_5_14 n_8_6_14 69.05262136224844
R1549 n_8_5_14 n_8_5_15 255.10578492730195
R1550 n_8_5_15 n_8_6_15 22839.154515563445
R1551 n_8_6_0 n_8_6_1 9.265302219705285
R1552 n_8_6_1 n_8_6_2 40.711176419917166
R1553 n_8_6_2 n_8_6_3 39.36349609705094
R1554 n_8_6_3 n_8_6_4 0.3649967541096025
R1555 n_8_6_4 n_8_6_5 0.31953928290181316
R1556 n_8_6_5 n_8_6_6 0.0748711290481236
R1557 n_8_6_6 n_8_6_7 0.10161081799388191
R1558 n_8_6_7 n_8_6_8 0.07487112904812336
R1559 n_8_6_8 n_8_6_9 0.07487112904812336
R1560 n_8_6_9 n_8_6_10 0.07487112904812336
R1561 n_8_6_10 n_8_6_11 0.07487112904812288
R1562 n_8_6_11 n_8_6_12 0.07487112904812265
R1563 n_8_6_12 n_8_6_13 0.07487112904812337
R1564 n_8_6_13 n_8_6_14 0.37435564524061776
R1565 n_8_6_14 n_8_6_15 11.567589437935196
R1566 n_0_0_15 amb 32.08762397152871
R1567 n_0_1_15 amb 707.6456849827252
R1568 n_0_2_15 amb 12.317913270758416
R1569 n_0_3_15 amb 707.6444703333939
R1570 n_0_4_15 amb 12.31791327075842
R1571 n_0_5_15 amb 707.6443409911197
R1572 n_0_6_15 amb 32.08762673490998
R1573 n_1_0_15 amb 161.943832432663
R1574 n_1_1_4 amb 3571.434716768772
R1575 n_1_1_15 amb 3571.434716768772
R1576 n_1_2_4 amb 62.16758474886666
R1577 n_1_2_15 amb 62.16758474886666
R1578 n_1_3_4 amb 3571.428586524664
R1579 n_1_3_15 amb 3571.428586524664
R1580 n_1_4_4 amb 62.16758474886667
R1581 n_1_4_15 amb 62.16758474886667
R1582 n_1_5_4 amb 3571.427933743904
R1583 n_1_5_15 amb 3571.427933743904
R1584 n_1_6_15 amb 161.9438463792411
R1585 n_2_0_15 amb 4.284109351261555
R1586 n_2_1_4 amb 94.47977510283536
R1587 n_2_1_15 amb 94.47977510283536
R1588 n_2_2_15 amb 1.6445994093582248
R1589 n_2_3_4 amb 94.47961293157074
R1590 n_2_3_15 amb 94.47961293157074
R1591 n_2_4_15 amb 1.644599409358225
R1592 n_2_5_4 amb 94.4795956627182
R1593 n_2_5_15 amb 94.4795956627182
R1594 n_2_6_15 amb 4.284109720208397
R1595 n_3_0_15 amb 161.9438317481399
R1596 n_3_1_4 amb 3571.4347016726147
R1597 n_3_1_15 amb 3571.4347016726147
R1598 n_3_2_4 amb 62.16758448608946
R1599 n_3_2_15 amb 62.16758448608946
R1600 n_3_3_4 amb 3571.428571428534
R1601 n_3_3_15 amb 3571.428571428534
R1602 n_3_4_4 amb 62.167584486089474
R1603 n_3_4_15 amb 62.167584486089474
R1604 n_3_5_4 amb 3571.427918647775
R1605 n_3_5_15 amb 3571.427918647775
R1606 n_3_6_15 amb 161.94384569471796
R1607 n_4_0_15 amb 4.284109351740605
R1608 n_4_1_4 amb 94.47977511340011
R1609 n_4_1_15 amb 94.47977511340011
R1610 n_4_2_15 amb 1.644599409542124
R1611 n_4_3_4 amb 94.47961294213546
R1612 n_4_3_15 amb 94.47961294213546
R1613 n_4_4_15 amb 1.6445994095421244
R1614 n_4_5_4 amb 94.47959567328293
R1615 n_4_5_15 amb 94.47959567328293
R1616 n_4_6_15 amb 4.2841097206874466
R1617 n_5_0_15 amb 161.94383174813706
R1618 n_5_1_4 amb 3571.434701672551
R1619 n_5_1_15 amb 3571.434701672551
R1620 n_5_2_4 amb 62.167584486088366
R1621 n_5_2_15 amb 62.167584486088366
R1622 n_5_3_4 amb 3571.4285714284692
R1623 n_5_3_15 amb 3571.4285714284692
R1624 n_5_4_4 amb 62.16758448608838
R1625 n_5_4_15 amb 62.16758448608838
R1626 n_5_5_4 amb 3571.4279186477124
R1627 n_5_5_15 amb 3571.4279186477124
R1628 n_5_6_15 amb 161.94384569471507
R1629 n_6_0_15 amb 4.284109351740605
R1630 n_6_1_4 amb 94.47977511340011
R1631 n_6_1_15 amb 94.47977511340011
R1632 n_6_2_15 amb 1.644599409542124
R1633 n_6_3_4 amb 94.47961294213546
R1634 n_6_3_15 amb 94.47961294213546
R1635 n_6_4_15 amb 1.6445994095421244
R1636 n_6_5_4 amb 94.47959567328293
R1637 n_6_5_15 amb 94.47959567328293
R1638 n_6_6_15 amb 4.2841097206874466
R1639 n_7_0_15 amb 161.9438317481399
R1640 n_7_1_4 amb 3571.4347016726147
R1641 n_7_1_15 amb 3571.4347016726147
R1642 n_7_2_4 amb 62.16758448608946
R1643 n_7_2_15 amb 62.16758448608946
R1644 n_7_3_4 amb 3571.428571428534
R1645 n_7_3_15 amb 3571.428571428534
R1646 n_7_4_4 amb 62.167584486089474
R1647 n_7_4_15 amb 62.167584486089474
R1648 n_7_5_4 amb 3571.427918647775
R1649 n_7_5_15 amb 3571.427918647775
R1650 n_7_6_15 amb 161.94384569471796
R1651 n_8_0_15 amb 32.087623971528814
R1652 n_8_1_15 amb 707.6456849827276
R1653 n_8_2_15 amb 12.317913270758455
R1654 n_8_3_15 amb 707.6444703333963
R1655 n_8_4_15 amb 12.317913270758456
R1656 n_8_5_15 amb 707.6443409911222
R1657 n_8_6_15 amb 32.08762673491008
I0 0 n_0_0_4 1.4549329483456017
I1 0 n_0_1_4 0.06597276340551829
I2 0 n_0_2_4 3.790036536555906
I3 0 n_0_3_4 0.06597287664567816
I4 0 n_0_4_4 3.7900365365559057
I5 0 n_0_5_4 0.0659728887041112
I6 0 n_0_6_4 1.454932823047009
I7 0 n_1_0_4 0.2882810703501984
I8 0 n_1_1_4 0.013071873085374346
I9 0 n_1_2_4 0.7509595481132529
I10 0 n_1_3_4 0.013071895522830678
I11 0 n_1_4_4 0.7509595481132528
I12 0 n_1_5_4 0.013071897912094038
I13 0 n_1_6_4 0.28828104552347883
I14 0 n_2_0_4 10.897327197438058
I15 0 n_2_1_4 0.49413053004716784
I16 0 n_2_2_4 28.38705953841937
I17 0 n_2_2_6 1.0
I18 0 n_2_2_7 0.5
I19 0 n_2_2_8 0.5
I20 0 n_2_2_9 0.5
I21 0 n_2_2_10 0.5
I22 0 n_2_2_11 0.5
I23 0 n_2_2_12 0.5
I24 0 n_2_2_13 0.5
I25 0 n_2_2_14 0.5
I26 0 n_2_3_4 0.4941313782065799
I27 0 n_2_4_4 28.387059538419365
I28 0 n_2_4_6 1.0
I29 0 n_2_4_7 0.5
I30 0 n_2_4_8 0.5
I31 0 n_2_4_9 0.5
I32 0 n_2_4_10 0.5
I33 0 n_2_4_11 0.5
I34 0 n_2_4_12 0.5
I35 0 n_2_4_13 0.5
I36 0 n_2_4_14 0.5
I37 0 n_2_5_4 0.49413146852324397
I38 0 n_2_6_4 10.89732625896199
I39 0 n_3_0_4 0.28828107156873845
I40 0 n_3_1_4 0.013071873140628064
I41 0 n_3_2_4 0.7509595512874964
I42 0 n_3_3_4 0.013071895578084492
I43 0 n_3_4_4 0.750959551287496
I44 0 n_3_5_4 0.01307189796734786
I45 0 n_3_6_4 0.2882810467420188
I46 0 n_4_0_4 10.897327196219518
I47 0 n_4_1_4 0.49413052999191415
I48 0 n_4_2_4 28.387059535245125
I49 0 n_4_2_6 1.0
I50 0 n_4_2_7 0.5
I51 0 n_4_2_8 0.5
I52 0 n_4_2_9 0.5
I53 0 n_4_2_10 0.5
I54 0 n_4_2_11 0.5
I55 0 n_4_2_12 0.5
I56 0 n_4_2_13 0.5
I57 0 n_4_2_14 0.5
I58 0 n_4_3_4 0.494131378151326
I59 0 n_4_4_4 28.387059535245122
I60 0 n_4_4_6 1.0
I61 0 n_4_4_7 0.5
I62 0 n_4_4_8 0.5
I63 0 n_4_4_9 0.5
I64 0 n_4_4_10 0.5
I65 0 n_4_4_11 0.5
I66 0 n_4_4_12 0.5
I67 0 n_4_4_13 0.5
I68 0 n_4_4_14 0.5
I69 0 n_4_5_4 0.4941314684679901
I70 0 n_4_6_4 10.897326257743446
I71 0 n_5_0_4 0.28828107156874355
I72 0 n_5_1_4 0.013071873140628295
I73 0 n_5_2_4 0.7509595512875097
I74 0 n_5_3_4 0.013071895578084726
I75 0 n_5_4_4 0.7509595512875095
I76 0 n_5_5_4 0.013071897967348093
I77 0 n_5_6_4 0.28828104674202387
I78 0 n_6_0_4 10.897327196219518
I79 0 n_6_1_4 0.49413052999191415
I80 0 n_6_2_4 28.387059535245125
I81 0 n_6_2_6 1.0
I82 0 n_6_2_7 0.5
I83 0 n_6_2_8 0.5
I84 0 n_6_2_9 0.5
I85 0 n_6_2_10 0.5
I86 0 n_6_2_11 0.5
I87 0 n_6_2_12 0.5
I88 0 n_6_2_13 0.5
I89 0 n_6_2_14 0.5
I90 0 n_6_3_4 0.494131378151326
I91 0 n_6_4_4 28.387059535245122
I92 0 n_6_4_6 1.0
I93 0 n_6_4_7 0.5
I94 0 n_6_4_8 0.5
I95 0 n_6_4_9 0.5
I96 0 n_6_4_10 0.5
I97 0 n_6_4_11 0.5
I98 0 n_6_4_12 0.5
I99 0 n_6_4_13 0.5
I100 0 n_6_4_14 0.5
I101 0 n_6_5_4 0.4941314684679901
I102 0 n_6_6_4 10.897326257743446
I103 0 n_7_0_4 0.28828107156873845
I104 0 n_7_1_4 0.013071873140628064
I105 0 n_7_2_4 0.7509595512874964
I106 0 n_7_3_4 0.013071895578084492
I107 0 n_7_4_4 0.750959551287496
I108 0 n_7_5_4 0.01307189796734786
I109 0 n_7_6_4 0.2882810467420188
I110 0 n_8_0_4 1.4549329483455966
I111 0 n_8_1_4 0.06597276340551808
I112 0 n_8_2_4 3.790036536555894
I113 0 n_8_3_4 0.06597287664567794
I114 0 n_8_4_4 3.7900365365558937
I115 0 n_8_5_4 0.06597288870411099
I116 0 n_8_6_4 1.4549328230470042
.control
set filetype=ascii
op
write thermal_op.raw all
quit
.endc
.end
