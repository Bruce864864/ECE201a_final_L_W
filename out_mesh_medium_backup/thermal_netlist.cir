* thermal network
.option numdgt=6
Vamb amb 0 45.0
R0 n_0_0_0 n_1_0_0 32.69273494920007
R1 n_0_0_0 n_0_1_0 624.2415416457985
R2 n_0_0_0 n_0_0_1 37.06120568711566
R3 n_0_0_1 n_1_0_1 45.76982892888009
R4 n_0_0_1 n_0_1_1 873.9381583041178
R5 n_0_0_1 n_0_0_2 162.84469165550817
R6 n_0_0_2 n_1_0_2 163.46367474600035
R7 n_0_0_2 n_0_1_2 3121.2077082289925
R8 n_0_0_2 n_0_0_3 157.45397082829138
R9 n_0_0_3 n_1_0_3 1144.2457232220013
R10 n_0_0_3 n_0_1_3 21848.453957602927
R11 n_0_0_3 n_0_0_4 1.4599868907045577
R12 n_0_0_4 n_1_0_4 52.011169237363696
R13 n_0_0_4 n_0_1_4 993.1115435274056
R14 n_0_0_4 n_0_0_5 1.2781570215325615
R15 n_0_0_5 n_1_0_5 217.9515663280002
R16 n_0_0_5 n_0_1_5 4161.610277638653
R17 n_0_0_5 n_0_0_6 0.29948449040093483
R18 n_0_0_6 n_1_0_6 36.32526105466671
R19 n_0_0_6 n_0_1_6 693.6017129397754
R20 n_0_0_6 n_0_0_7 0.40644323697269685
R21 n_0_0_7 n_1_0_7 62.27187609371455
R22 n_0_0_7 n_0_1_7 1189.0315078967617
R23 n_0_0_7 n_0_0_8 0.29948449040093394
R24 n_0_0_8 n_1_0_8 62.27187609371455
R25 n_0_0_8 n_0_1_8 1189.0315078967617
R26 n_0_0_8 n_0_0_9 0.29948449040093394
R27 n_0_0_9 n_1_0_9 62.27187609371455
R28 n_0_0_9 n_0_1_9 1189.0315078967617
R29 n_0_0_9 n_0_0_10 0.29948449040093394
R30 n_0_0_10 n_1_0_10 62.27187609371455
R31 n_0_0_10 n_0_1_10 1189.0315078967617
R32 n_0_0_10 n_0_0_11 0.29948449040093206
R33 n_0_0_11 n_1_0_11 62.27187609371534
R34 n_0_0_11 n_0_1_11 1189.031507896777
R35 n_0_0_11 n_0_0_12 0.29948449040093106
R36 n_0_0_12 n_1_0_12 62.271876093714965
R37 n_0_0_12 n_0_1_12 1189.0315078967692
R38 n_0_0_12 n_0_0_13 0.29948449040093394
R39 n_0_0_13 n_1_0_13 62.27187609371416
R40 n_0_0_13 n_0_1_13 1189.0315078967542
R41 n_0_0_13 n_0_0_14 1.4974224520046735
R42 n_0_0_14 n_1_0_14 6.919097343746047
R43 n_0_0_14 n_0_1_14 132.11461198852882
R44 n_0_0_14 n_0_0_15 46.27035376694484
R45 n_0_0_15 n_1_0_15 2288.491446443982
R46 n_0_0_15 n_0_1_15 43696.90791520547
R47 n_0_1_0 n_1_1_0 32.69273494920007
R48 n_0_1_0 n_0_2_0 326.2736359366226
R49 n_0_1_0 n_0_1_1 37.06120568711566
R50 n_0_1_1 n_1_1_1 45.76982892888009
R51 n_0_1_1 n_0_2_1 456.7830903112716
R52 n_0_1_1 n_0_1_2 162.84469165550817
R53 n_0_1_2 n_1_1_2 163.46367474600035
R54 n_0_1_2 n_0_2_2 1631.368179683113
R55 n_0_1_2 n_0_1_3 157.45397082829138
R56 n_0_1_3 n_1_1_3 1144.2457232220013
R57 n_0_1_3 n_0_2_3 11419.57725778178
R58 n_0_1_3 n_0_1_4 1.4599868907045577
R59 n_0_1_4 n_1_1_4 52.011169237363696
R60 n_0_1_4 n_0_2_4 519.0716935355354
R61 n_0_1_4 n_0_1_5 1.2781570215325615
R62 n_0_1_5 n_1_1_5 217.9515663280002
R63 n_0_1_5 n_0_2_5 2175.157572910816
R64 n_0_1_5 n_0_1_6 0.29948449040093483
R65 n_0_1_6 n_1_1_6 36.32526105466671
R66 n_0_1_6 n_0_2_6 362.52626215180254
R67 n_0_1_6 n_0_1_7 0.40644323697269685
R68 n_0_1_7 n_1_1_7 62.27187609371455
R69 n_0_1_7 n_0_2_7 621.4735922602349
R70 n_0_1_7 n_0_1_8 0.29948449040093394
R71 n_0_1_8 n_1_1_8 62.27187609371455
R72 n_0_1_8 n_0_2_8 621.4735922602349
R73 n_0_1_8 n_0_1_9 0.29948449040093394
R74 n_0_1_9 n_1_1_9 62.27187609371455
R75 n_0_1_9 n_0_2_9 621.4735922602349
R76 n_0_1_9 n_0_1_10 0.29948449040093394
R77 n_0_1_10 n_1_1_10 62.27187609371455
R78 n_0_1_10 n_0_2_10 621.4735922602349
R79 n_0_1_10 n_0_1_11 0.29948449040093206
R80 n_0_1_11 n_1_1_11 62.27187609371534
R81 n_0_1_11 n_0_2_11 621.4735922602429
R82 n_0_1_11 n_0_1_12 0.29948449040093106
R83 n_0_1_12 n_1_1_12 62.271876093714965
R84 n_0_1_12 n_0_2_12 621.4735922602389
R85 n_0_1_12 n_0_1_13 0.29948449040093394
R86 n_0_1_13 n_1_1_13 62.27187609371416
R87 n_0_1_13 n_0_2_13 621.473592260231
R88 n_0_1_13 n_0_1_14 1.4974224520046735
R89 n_0_1_14 n_1_1_14 6.919097343746047
R90 n_0_1_14 n_0_2_14 69.05262136224819
R91 n_0_1_14 n_0_1_15 46.27035376694484
R92 n_0_1_15 n_1_1_15 2288.491446443982
R93 n_0_1_15 n_0_2_15 22839.15451556336
R94 n_0_2_0 n_1_2_0 720.9905238734066
R95 n_0_2_0 n_0_3_0 28.305730227446716
R96 n_0_2_0 n_0_2_1 817.3307661550475
R97 n_0_2_1 n_1_2_1 1009.3867334227691
R98 n_0_2_1 n_0_3_1 39.628022318425394
R99 n_0_2_1 n_0_2_2 3591.301851287331
R100 n_0_2_2 n_1_2_2 3604.9526193670335
R101 n_0_2_2 n_0_3_2 141.52865113723357
R102 n_0_2_2 n_0_2_3 3472.4173762102328
R103 n_0_2_3 n_1_2_3 25234.668335569208
R104 n_0_2_3 n_0_3_3 990.700557960634
R105 n_0_2_3 n_0_2_4 32.19787866671402
R106 n_0_2_4 n_1_2_4 1147.0303788895094
R107 n_0_2_4 n_0_3_4 45.031843543665175
R108 n_0_2_4 n_0_2_5 28.18788645181191
R109 n_0_2_5 n_1_2_5 4806.603492489374
R110 n_0_2_5 n_0_3_5 188.70486818297792
R111 n_0_2_5 n_0_2_6 6.604693059838775
R112 n_0_2_6 n_1_2_6 801.1005820815622
R113 n_0_2_6 n_0_3_6 31.450811363829654
R114 n_0_2_6 n_0_2_7 8.963512009781184
R115 n_0_2_7 n_1_2_7 1373.3152835683968
R116 n_0_2_7 n_0_3_7 53.915676623708144
R117 n_0_2_7 n_0_2_8 6.604693059838754
R118 n_0_2_8 n_1_2_8 1373.3152835683968
R119 n_0_2_8 n_0_3_8 53.915676623708144
R120 n_0_2_8 n_0_2_9 6.604693059838754
R121 n_0_2_9 n_1_2_9 1373.3152835683968
R122 n_0_2_9 n_0_3_9 53.915676623708144
R123 n_0_2_9 n_0_2_10 6.604693059838754
R124 n_0_2_10 n_1_2_10 1373.3152835683968
R125 n_0_2_10 n_0_3_10 53.915676623708144
R126 n_0_2_10 n_0_2_11 6.604693059838711
R127 n_0_2_11 n_1_2_11 1373.3152835684139
R128 n_0_2_11 n_0_3_11 53.91567662370884
R129 n_0_2_11 n_0_2_12 6.604693059838691
R130 n_0_2_12 n_1_2_12 1373.3152835684054
R131 n_0_2_12 n_0_3_12 53.91567662370849
R132 n_0_2_12 n_0_2_13 6.604693059838754
R133 n_0_2_13 n_1_2_13 1373.3152835683877
R134 n_0_2_13 n_0_3_13 53.9156766237078
R135 n_0_2_13 n_0_2_14 33.02346529919385
R136 n_0_2_14 n_1_2_14 152.59058706315486
R137 n_0_2_14 n_0_3_14 5.990630735967559
R138 n_0_2_14 n_0_2_15 1020.4250777450995
R139 n_0_2_15 n_1_2_15 50469.33667113796
R140 n_0_2_15 n_0_3_15 1981.4011159212507
R141 n_0_3_0 n_1_3_0 720.9905238734066
R142 n_0_3_0 n_0_4_0 827.2137876682011
R143 n_0_3_0 n_0_3_1 817.3307661550475
R144 n_0_3_1 n_1_3_1 1009.3867334227691
R145 n_0_3_1 n_0_4_1 1158.0993027354814
R146 n_0_3_1 n_0_3_2 3591.301851287331
R147 n_0_3_2 n_1_3_2 3604.9526193670335
R148 n_0_3_2 n_0_4_2 4136.068938341005
R149 n_0_3_2 n_0_3_3 3472.4173762102328
R150 n_0_3_3 n_1_3_3 25234.668335569208
R151 n_0_3_3 n_0_4_3 28952.48256838701
R152 n_0_3_3 n_0_3_4 32.19787866671402
R153 n_0_3_4 n_1_3_4 1147.0303788895094
R154 n_0_3_4 n_0_4_4 1316.0219349266822
R155 n_0_3_4 n_0_3_5 28.18788645181191
R156 n_0_3_5 n_1_3_5 4806.603492489374
R157 n_0_3_5 n_0_4_5 5514.758584454669
R158 n_0_3_5 n_0_3_6 6.604693059838775
R159 n_0_3_6 n_1_3_6 801.1005820815622
R160 n_0_3_6 n_0_4_6 919.1264307424449
R161 n_0_3_6 n_0_3_7 8.963512009781184
R162 n_0_3_7 n_1_3_7 1373.3152835683968
R163 n_0_3_7 n_0_4_7 1575.6453098441962
R164 n_0_3_7 n_0_3_8 6.604693059838754
R165 n_0_3_8 n_1_3_8 1373.3152835683968
R166 n_0_3_8 n_0_4_8 1575.6453098441962
R167 n_0_3_8 n_0_3_9 6.604693059838754
R168 n_0_3_9 n_1_3_9 1373.3152835683968
R169 n_0_3_9 n_0_4_9 1575.6453098441962
R170 n_0_3_9 n_0_3_10 6.604693059838754
R171 n_0_3_10 n_1_3_10 1373.3152835683968
R172 n_0_3_10 n_0_4_10 1575.6453098441962
R173 n_0_3_10 n_0_3_11 6.604693059838711
R174 n_0_3_11 n_1_3_11 1373.3152835684139
R175 n_0_3_11 n_0_4_11 1575.6453098442164
R176 n_0_3_11 n_0_3_12 6.604693059838691
R177 n_0_3_12 n_1_3_12 1373.3152835684054
R178 n_0_3_12 n_0_4_12 1575.6453098442062
R179 n_0_3_12 n_0_3_13 6.604693059838754
R180 n_0_3_13 n_1_3_13 1373.3152835683877
R181 n_0_3_13 n_0_4_13 1575.6453098441862
R182 n_0_3_13 n_0_3_14 33.02346529919385
R183 n_0_3_14 n_1_3_14 152.59058706315486
R184 n_0_3_14 n_0_4_14 175.07170109379922
R185 n_0_3_14 n_0_3_15 1020.4250777450995
R186 n_0_3_15 n_1_3_15 50469.33667113796
R187 n_0_3_15 n_0_4_15 57904.96513677351
R188 n_0_4_0 n_1_4_0 12.550205463809329
R189 n_0_4_0 n_0_5_0 1626.1218451089553
R190 n_0_4_0 n_0_4_1 14.227189827725967
R191 n_0_4_1 n_1_4_1 17.570287649333064
R192 n_0_4_1 n_0_5_1 2276.5705831525374
R193 n_0_4_1 n_0_4_2 62.51340984909895
R194 n_0_4_2 n_1_4_2 62.751027319046656
R195 n_0_4_2 n_0_5_2 8130.609225544777
R196 n_0_4_2 n_0_4_3 60.444000419611534
R197 n_0_4_3 n_1_4_3 439.2571912333262
R198 n_0_4_3 n_0_5_3 56914.26457881338
R199 n_0_4_3 n_0_4_4 0.5604650538195083
R200 n_0_4_4 n_1_4_4 19.966235965151192
R201 n_0_4_4 n_0_5_4 2587.0120263096987
R202 n_0_4_4 n_0_4_5 0.49066354528521056
R203 n_0_4_5 n_1_4_5 83.66803642539546
R204 n_0_4_5 n_0_5_5 10840.812300726358
R205 n_0_4_5 n_0_4_6 0.11496719052707863
R206 n_0_4_6 n_1_4_6 13.944672737565913
R207 n_0_4_6 n_0_5_6 1806.80205012106
R208 n_0_4_6 n_0_4_7 0.1560269014296065
R209 n_0_4_7 n_1_4_7 23.90515326439878
R210 n_0_4_7 n_0_5_7 3097.3749430646835
R211 n_0_4_7 n_0_4_8 0.11496719052707827
R212 n_0_4_8 n_1_4_8 23.90515326439878
R213 n_0_4_8 n_0_5_8 3097.3749430646835
R214 n_0_4_8 n_0_4_9 0.11496719052707827
R215 n_0_4_9 n_1_4_9 23.90515326439878
R216 n_0_4_9 n_0_5_9 3097.3749430646835
R217 n_0_4_9 n_0_4_10 0.11496719052707827
R218 n_0_4_10 n_1_4_10 23.90515326439878
R219 n_0_4_10 n_0_5_10 3097.3749430646835
R220 n_0_4_10 n_0_4_11 0.11496719052707753
R221 n_0_4_11 n_1_4_11 23.905153264399086
R222 n_0_4_11 n_0_5_11 3097.3749430647235
R223 n_0_4_11 n_0_4_12 0.11496719052707716
R224 n_0_4_12 n_1_4_12 23.90515326439893
R225 n_0_4_12 n_0_5_12 3097.374943064703
R226 n_0_4_12 n_0_4_13 0.11496719052707827
R227 n_0_4_13 n_1_4_13 23.90515326439863
R228 n_0_4_13 n_0_5_13 3097.374943064664
R229 n_0_4_13 n_0_4_14 0.5748359526353928
R230 n_0_4_14 n_1_4_14 2.656128140488748
R231 n_0_4_14 n_0_5_14 344.1527714516308
R232 n_0_4_14 n_0_4_15 17.762430936433798
R233 n_0_4_15 n_1_4_15 878.5143824666446
R234 n_0_4_15 n_0_5_15 113828.52915762576
R235 n_0_5_0 n_1_5_0 12.550205463809338
R236 n_0_5_0 n_0_6_0 827.2138119611458
R237 n_0_5_0 n_0_5_1 14.227189827725972
R238 n_0_5_1 n_1_5_1 17.57028764933307
R239 n_0_5_1 n_0_6_1 1158.099336745604
R240 n_0_5_1 n_0_5_2 62.51340984909897
R241 n_0_5_2 n_1_5_2 62.75102731904668
R242 n_0_5_2 n_0_6_2 4136.069059805729
R243 n_0_5_2 n_0_5_3 60.444000419611555
R244 n_0_5_3 n_1_5_3 439.25719123332635
R245 n_0_5_3 n_0_6_3 28952.483418640077
R246 n_0_5_3 n_0_5_4 0.5604650538195085
R247 n_0_5_4 n_1_5_4 19.9662359651512
R248 n_0_5_4 n_0_6_4 1316.0219735745486
R249 n_0_5_4 n_0_5_5 0.4906635452852107
R250 n_0_5_5 n_1_5_5 83.66803642539551
R251 n_0_5_5 n_0_6_5 5514.758746407633
R252 n_0_5_5 n_0_5_6 0.11496719052707867
R253 n_0_5_6 n_1_5_6 13.944672737565918
R254 n_0_5_6 n_0_6_6 919.1264577346055
R255 n_0_5_6 n_0_5_7 0.1560269014296066
R256 n_0_5_7 n_1_5_7 23.90515326439879
R257 n_0_5_7 n_0_6_7 1575.6453561164717
R258 n_0_5_7 n_0_5_8 0.11496719052707831
R259 n_0_5_8 n_1_5_8 23.90515326439879
R260 n_0_5_8 n_0_6_8 1575.6453561164717
R261 n_0_5_8 n_0_5_9 0.11496719052707831
R262 n_0_5_9 n_1_5_9 23.90515326439879
R263 n_0_5_9 n_0_6_9 1575.6453561164717
R264 n_0_5_9 n_0_5_10 0.11496719052707831
R265 n_0_5_10 n_1_5_10 23.90515326439879
R266 n_0_5_10 n_0_6_10 1575.6453561164717
R267 n_0_5_10 n_0_5_11 0.11496719052707757
R268 n_0_5_11 n_1_5_11 23.905153264399097
R269 n_0_5_11 n_0_6_11 1575.645356116492
R270 n_0_5_11 n_0_5_12 0.11496719052707721
R271 n_0_5_12 n_1_5_12 23.905153264398944
R272 n_0_5_12 n_0_6_12 1575.6453561164817
R273 n_0_5_12 n_0_5_13 0.11496719052707831
R274 n_0_5_13 n_1_5_13 23.905153264398635
R275 n_0_5_13 n_0_6_13 1575.6453561164617
R276 n_0_5_13 n_0_5_14 0.574835952635393
R277 n_0_5_14 n_1_5_14 2.6561281404887485
R278 n_0_5_14 n_0_6_14 175.07170623516316
R279 n_0_5_14 n_0_5_15 17.762430936433805
R280 n_0_5_15 n_1_5_15 878.514382466645
R281 n_0_5_15 n_0_6_15 57904.966837279644
R282 n_0_6_0 n_1_6_0 720.9892863181211
R283 n_0_6_0 n_0_7_0 28.305778813336566
R284 n_0_6_0 n_0_6_1 817.3293632350699
R285 n_0_6_1 n_1_6_1 1009.3850008453696
R286 n_0_6_1 n_0_7_1 39.62809033867119
R287 n_0_6_1 n_0_6_2 3591.295686941974
R288 n_0_6_2 n_1_6_2 3604.946431590606
R289 n_0_6_2 n_0_7_2 141.52889406668282
R290 n_0_6_2 n_0_6_3 3472.411415925964
R291 n_0_6_3 n_1_6_3 25234.625021134216
R292 n_0_6_3 n_0_7_3 990.7022584667789
R293 n_0_6_3 n_0_6_4 32.197823400169455
R294 n_0_6_4 n_1_6_4 1147.0284100515555
R295 n_0_6_4 n_0_7_4 45.031920839399035
R296 n_0_6_4 n_0_6_5 28.187838068280215
R297 n_0_6_5 n_1_6_5 4806.595242120803
R298 n_0_6_5 n_0_7_5 188.70519208891028
R299 n_0_6_5 n_0_6_6 6.604681723111682
R300 n_0_6_6 n_1_6_6 801.0992070201339
R301 n_0_6_6 n_0_7_6 31.450865348151712
R302 n_0_6_6 n_0_6_7 8.963496624222987
R303 n_0_6_7 n_1_6_7 1373.3129263202338
R304 n_0_6_7 n_0_7_7 53.91576916826025
R305 n_0_6_7 n_0_6_8 6.6046817231116615
R306 n_0_6_8 n_1_6_8 1373.3129263202338
R307 n_0_6_8 n_0_7_8 53.91576916826025
R308 n_0_6_8 n_0_6_9 6.6046817231116615
R309 n_0_6_9 n_1_6_9 1373.3129263202338
R310 n_0_6_9 n_0_7_9 53.91576916826025
R311 n_0_6_9 n_0_6_10 6.6046817231116615
R312 n_0_6_10 n_1_6_10 1373.3129263202338
R313 n_0_6_10 n_0_7_10 53.91576916826025
R314 n_0_6_10 n_0_6_11 6.60468172311162
R315 n_0_6_11 n_1_6_11 1373.3129263202513
R316 n_0_6_11 n_0_7_11 53.915769168260944
R317 n_0_6_11 n_0_6_12 6.604681723111598
R318 n_0_6_12 n_1_6_12 1373.3129263202425
R319 n_0_6_12 n_0_7_12 53.91576916826059
R320 n_0_6_12 n_0_6_13 6.604681723111662
R321 n_0_6_13 n_1_6_13 1373.3129263202252
R322 n_0_6_13 n_0_7_13 53.91576916825991
R323 n_0_6_13 n_0_6_14 33.023408615558395
R324 n_0_6_14 n_1_6_14 152.59032514669232
R325 n_0_6_14 n_0_7_14 5.9906410186955705
R326 n_0_6_14 n_0_6_15 1020.4233262207638
R327 n_0_6_15 n_1_6_15 50469.25004226799
R328 n_0_6_15 n_0_7_15 1981.4045169335404
R329 n_0_7_0 n_1_7_0 720.9892863181211
R330 n_0_7_0 n_0_8_0 827.2138119611458
R331 n_0_7_0 n_0_7_1 817.3293632350699
R332 n_0_7_1 n_1_7_1 1009.3850008453696
R333 n_0_7_1 n_0_8_1 1158.099336745604
R334 n_0_7_1 n_0_7_2 3591.295686941974
R335 n_0_7_2 n_1_7_2 3604.946431590606
R336 n_0_7_2 n_0_8_2 4136.069059805729
R337 n_0_7_2 n_0_7_3 3472.411415925964
R338 n_0_7_3 n_1_7_3 25234.625021134216
R339 n_0_7_3 n_0_8_3 28952.483418640077
R340 n_0_7_3 n_0_7_4 32.197823400169455
R341 n_0_7_4 n_1_7_4 1147.0284100515555
R342 n_0_7_4 n_0_8_4 1316.0219735745486
R343 n_0_7_4 n_0_7_5 28.187838068280215
R344 n_0_7_5 n_1_7_5 4806.595242120803
R345 n_0_7_5 n_0_8_5 5514.758746407633
R346 n_0_7_5 n_0_7_6 6.604681723111682
R347 n_0_7_6 n_1_7_6 801.0992070201339
R348 n_0_7_6 n_0_8_6 919.1264577346055
R349 n_0_7_6 n_0_7_7 8.963496624222987
R350 n_0_7_7 n_1_7_7 1373.3129263202338
R351 n_0_7_7 n_0_8_7 1575.6453561164717
R352 n_0_7_7 n_0_7_8 6.6046817231116615
R353 n_0_7_8 n_1_7_8 1373.3129263202338
R354 n_0_7_8 n_0_8_8 1575.6453561164717
R355 n_0_7_8 n_0_7_9 6.6046817231116615
R356 n_0_7_9 n_1_7_9 1373.3129263202338
R357 n_0_7_9 n_0_8_9 1575.6453561164717
R358 n_0_7_9 n_0_7_10 6.6046817231116615
R359 n_0_7_10 n_1_7_10 1373.3129263202338
R360 n_0_7_10 n_0_8_10 1575.6453561164717
R361 n_0_7_10 n_0_7_11 6.60468172311162
R362 n_0_7_11 n_1_7_11 1373.3129263202513
R363 n_0_7_11 n_0_8_11 1575.645356116492
R364 n_0_7_11 n_0_7_12 6.604681723111598
R365 n_0_7_12 n_1_7_12 1373.3129263202425
R366 n_0_7_12 n_0_8_12 1575.6453561164817
R367 n_0_7_12 n_0_7_13 6.604681723111662
R368 n_0_7_13 n_1_7_13 1373.3129263202252
R369 n_0_7_13 n_0_8_13 1575.6453561164617
R370 n_0_7_13 n_0_7_14 33.023408615558395
R371 n_0_7_14 n_1_7_14 152.59032514669232
R372 n_0_7_14 n_0_8_14 175.07170623516316
R373 n_0_7_14 n_0_7_15 1020.4233262207638
R374 n_0_7_15 n_1_7_15 50469.25004226799
R375 n_0_7_15 n_0_8_15 57904.966837279644
R376 n_0_8_0 n_1_8_0 12.550205463809338
R377 n_0_8_0 n_0_9_0 1626.121845108955
R378 n_0_8_0 n_0_8_1 14.227189827725972
R379 n_0_8_1 n_1_8_1 17.57028764933307
R380 n_0_8_1 n_0_9_1 2276.570583152537
R381 n_0_8_1 n_0_8_2 62.51340984909897
R382 n_0_8_2 n_1_8_2 62.75102731904668
R383 n_0_8_2 n_0_9_2 8130.609225544775
R384 n_0_8_2 n_0_8_3 60.444000419611555
R385 n_0_8_3 n_1_8_3 439.25719123332635
R386 n_0_8_3 n_0_9_3 56914.264578813374
R387 n_0_8_3 n_0_8_4 0.5604650538195085
R388 n_0_8_4 n_1_8_4 19.9662359651512
R389 n_0_8_4 n_0_9_4 2587.0120263096983
R390 n_0_8_4 n_0_8_5 0.4906635452852107
R391 n_0_8_5 n_1_8_5 83.66803642539551
R392 n_0_8_5 n_0_9_5 10840.812300726357
R393 n_0_8_5 n_0_8_6 0.11496719052707867
R394 n_0_8_6 n_1_8_6 13.944672737565918
R395 n_0_8_6 n_0_9_6 1806.8020501210594
R396 n_0_8_6 n_0_8_7 0.1560269014296066
R397 n_0_8_7 n_1_8_7 23.90515326439879
R398 n_0_8_7 n_0_9_7 3097.374943064683
R399 n_0_8_7 n_0_8_8 0.11496719052707831
R400 n_0_8_8 n_1_8_8 23.90515326439879
R401 n_0_8_8 n_0_9_8 3097.374943064683
R402 n_0_8_8 n_0_8_9 0.11496719052707831
R403 n_0_8_9 n_1_8_9 23.90515326439879
R404 n_0_8_9 n_0_9_9 3097.374943064683
R405 n_0_8_9 n_0_8_10 0.11496719052707831
R406 n_0_8_10 n_1_8_10 23.90515326439879
R407 n_0_8_10 n_0_9_10 3097.374943064683
R408 n_0_8_10 n_0_8_11 0.11496719052707757
R409 n_0_8_11 n_1_8_11 23.905153264399097
R410 n_0_8_11 n_0_9_11 3097.374943064723
R411 n_0_8_11 n_0_8_12 0.11496719052707721
R412 n_0_8_12 n_1_8_12 23.905153264398944
R413 n_0_8_12 n_0_9_12 3097.3749430647026
R414 n_0_8_12 n_0_8_13 0.11496719052707831
R415 n_0_8_13 n_1_8_13 23.905153264398635
R416 n_0_8_13 n_0_9_13 3097.3749430646635
R417 n_0_8_13 n_0_8_14 0.574835952635393
R418 n_0_8_14 n_1_8_14 2.6561281404887485
R419 n_0_8_14 n_0_9_14 344.15277145163077
R420 n_0_8_14 n_0_8_15 17.762430936433805
R421 n_0_8_15 n_1_8_15 878.514382466645
R422 n_0_8_15 n_0_9_15 113828.52915762574
R423 n_0_9_0 n_1_9_0 12.550205463809338
R424 n_0_9_0 n_0_10_0 827.213814547992
R425 n_0_9_0 n_0_9_1 14.227189827725972
R426 n_0_9_1 n_1_9_1 17.57028764933307
R427 n_0_9_1 n_0_10_1 1158.0993403671887
R428 n_0_9_1 n_0_9_2 62.51340984909897
R429 n_0_9_2 n_1_9_2 62.75102731904668
R430 n_0_9_2 n_0_10_2 4136.06907273996
R431 n_0_9_2 n_0_9_3 60.444000419611555
R432 n_0_9_3 n_1_9_3 439.25719123332635
R433 n_0_9_3 n_0_10_3 28952.483509179692
R434 n_0_9_3 n_0_9_4 0.5604650538195085
R435 n_0_9_4 n_1_9_4 19.9662359651512
R436 n_0_9_4 n_0_10_4 1316.0219776899858
R437 n_0_9_4 n_0_9_5 0.4906635452852107
R438 n_0_9_5 n_1_9_5 83.66803642539551
R439 n_0_9_5 n_0_10_5 5514.758763653274
R440 n_0_9_5 n_0_9_6 0.11496719052707867
R441 n_0_9_6 n_1_9_6 13.944672737565918
R442 n_0_9_6 n_0_10_6 919.1264606088791
R443 n_0_9_6 n_0_9_7 0.1560269014296066
R444 n_0_9_7 n_1_9_7 23.90515326439879
R445 n_0_9_7 n_0_10_7 1575.6453610437977
R446 n_0_9_7 n_0_9_8 0.11496719052707831
R447 n_0_9_8 n_1_9_8 23.90515326439879
R448 n_0_9_8 n_0_10_8 1575.6453610437977
R449 n_0_9_8 n_0_9_9 0.11496719052707831
R450 n_0_9_9 n_1_9_9 23.90515326439879
R451 n_0_9_9 n_0_10_9 1575.6453610437977
R452 n_0_9_9 n_0_9_10 0.11496719052707831
R453 n_0_9_10 n_1_9_10 23.90515326439879
R454 n_0_9_10 n_0_10_10 1575.6453610437977
R455 n_0_9_10 n_0_9_11 0.11496719052707757
R456 n_0_9_11 n_1_9_11 23.905153264399097
R457 n_0_9_11 n_0_10_11 1575.6453610438182
R458 n_0_9_11 n_0_9_12 0.11496719052707721
R459 n_0_9_12 n_1_9_12 23.905153264398944
R460 n_0_9_12 n_0_10_12 1575.6453610438077
R461 n_0_9_12 n_0_9_13 0.11496719052707831
R462 n_0_9_13 n_1_9_13 23.905153264398635
R463 n_0_9_13 n_0_10_13 1575.6453610437877
R464 n_0_9_13 n_0_9_14 0.574835952635393
R465 n_0_9_14 n_1_9_14 2.6561281404887485
R466 n_0_9_14 n_0_10_14 175.07170678264384
R467 n_0_9_14 n_0_9_15 17.762430936433805
R468 n_0_9_15 n_1_9_15 878.514382466645
R469 n_0_9_15 n_0_10_15 57904.967018358875
R470 n_0_10_0 n_1_10_0 720.9891545366872
R471 n_0_10_0 n_0_11_0 28.305783987028477
R472 n_0_10_0 n_0_10_1 817.3292138447288
R473 n_0_10_1 n_1_10_1 1009.384816351362
R474 n_0_10_1 n_0_11_1 39.62809758183987
R475 n_0_10_1 n_0_10_2 3591.295030529869
R476 n_0_10_2 n_1_10_2 3604.9457726834366
R477 n_0_10_2 n_0_11_2 141.52891993514237
R478 n_0_10_2 n_0_10_3 3472.4107812433635
R479 n_0_10_3 n_1_10_3 25234.620408784027
R480 n_0_10_3 n_0_11_3 990.7024395459957
R481 n_0_10_3 n_0_10_4 32.19781751509541
R482 n_0_10_4 n_1_10_4 1147.028200399274
R483 n_0_10_4 n_0_11_4 45.031929070272525
R484 n_0_10_4 n_0_10_5 28.187832916145794
R485 n_0_10_5 n_1_10_5 4806.59436357791
R486 n_0_10_5 n_0_11_5 188.70522658018967
R487 n_0_10_5 n_0_10_6 6.604680515917008
R488 n_0_10_6 n_1_10_6 801.0990605963185
R489 n_0_10_6 n_0_11_6 31.45087109669828
R490 n_0_10_6 n_0_10_7 8.963494985887356
R491 n_0_10_7 n_1_10_7 1373.3126753079787
R492 n_0_10_7 n_0_11_7 53.91577902291151
R493 n_0_10_7 n_0_10_8 6.604680515916987
R494 n_0_10_8 n_1_10_8 1373.3126753079787
R495 n_0_10_8 n_0_11_8 53.91577902291151
R496 n_0_10_8 n_0_10_9 6.604680515916987
R497 n_0_10_9 n_1_10_9 1373.3126753079787
R498 n_0_10_9 n_0_11_9 53.91577902291151
R499 n_0_10_9 n_0_10_10 6.604680515916987
R500 n_0_10_10 n_1_10_10 1373.3126753079787
R501 n_0_10_10 n_0_11_10 53.91577902291151
R502 n_0_10_10 n_0_10_11 6.604680515916945
R503 n_0_10_11 n_1_10_11 1373.3126753079964
R504 n_0_10_11 n_0_11_11 53.915779022912204
R505 n_0_10_11 n_0_10_12 6.6046805159169235
R506 n_0_10_12 n_1_10_12 1373.3126753079873
R507 n_0_10_12 n_0_11_12 53.91577902291185
R508 n_0_10_12 n_0_10_13 6.6046805159169875
R509 n_0_10_13 n_1_10_13 1373.3126753079698
R510 n_0_10_13 n_0_11_13 53.91577902291117
R511 n_0_10_13 n_0_10_14 33.02340257958502
R512 n_0_10_14 n_1_10_14 152.59029725644177
R513 n_0_10_14 n_0_11_14 5.990642113656822
R514 n_0_10_14 n_0_10_15 1020.4231397091863
R515 n_0_10_15 n_1_10_15 50469.2408175676
R516 n_0_10_15 n_0_11_15 1981.4048790919742
R517 n_0_11_0 n_1_11_0 720.9891545367128
R518 n_0_11_0 n_0_12_0 326.2736359366222
R519 n_0_11_0 n_0_11_1 817.3292138447578
R520 n_0_11_1 n_1_11_1 1009.384816351398
R521 n_0_11_1 n_0_12_1 456.78309031127105
R522 n_0_11_1 n_0_11_2 3591.295030529997
R523 n_0_11_2 n_1_11_2 3604.945772683564
R524 n_0_11_2 n_0_12_2 1631.368179683111
R525 n_0_11_2 n_0_11_3 3472.410781243487
R526 n_0_11_3 n_1_11_3 25234.620408784926
R527 n_0_11_3 n_0_12_3 11419.577257781766
R528 n_0_11_3 n_0_11_4 32.197817515096546
R529 n_0_11_4 n_1_11_4 1147.0282003993148
R530 n_0_11_4 n_0_12_4 519.0716935355348
R531 n_0_11_4 n_0_11_5 28.187832916146796
R532 n_0_11_5 n_1_11_5 4806.594363578081
R533 n_0_11_5 n_0_12_5 2175.157572910813
R534 n_0_11_5 n_0_11_6 6.604680515917241
R535 n_0_11_6 n_1_11_6 801.0990605963468
R536 n_0_11_6 n_0_12_6 362.52626215180214
R537 n_0_11_6 n_0_11_7 8.963494985887674
R538 n_0_11_7 n_1_11_7 1373.3126753080276
R539 n_0_11_7 n_0_12_7 621.4735922602341
R540 n_0_11_7 n_0_11_8 6.60468051591722
R541 n_0_11_8 n_1_11_8 1373.3126753080276
R542 n_0_11_8 n_0_12_8 621.4735922602341
R543 n_0_11_8 n_0_11_9 6.60468051591722
R544 n_0_11_9 n_1_11_9 1373.3126753080276
R545 n_0_11_9 n_0_12_9 621.4735922602341
R546 n_0_11_9 n_0_11_10 6.60468051591722
R547 n_0_11_10 n_1_11_10 1373.3126753080276
R548 n_0_11_10 n_0_12_10 621.4735922602341
R549 n_0_11_10 n_0_11_11 6.6046805159171775
R550 n_0_11_11 n_1_11_11 1373.3126753080448
R551 n_0_11_11 n_0_12_11 621.4735922602422
R552 n_0_11_11 n_0_11_12 6.604680515917156
R553 n_0_11_12 n_1_11_12 1373.3126753080364
R554 n_0_11_12 n_0_12_12 621.4735922602381
R555 n_0_11_12 n_0_11_13 6.60468051591722
R556 n_0_11_13 n_1_11_13 1373.312675308019
R557 n_0_11_13 n_0_12_13 621.4735922602302
R558 n_0_11_13 n_0_11_14 33.02340257958618
R559 n_0_11_14 n_1_11_14 152.59029725644717
R560 n_0_11_14 n_0_12_14 69.0526213622481
R561 n_0_11_14 n_0_11_15 1020.4231397092226
R562 n_0_11_15 n_1_11_15 50469.2408175694
R563 n_0_11_15 n_0_12_15 22839.154515563332
R564 n_0_12_0 n_1_12_0 32.69273776469343
R565 n_0_12_0 n_0_13_0 624.2414878862169
R566 n_0_12_0 n_0_12_1 37.06120887882106
R567 n_0_12_1 n_1_12_1 45.7698328705708
R568 n_0_12_1 n_0_13_1 873.9380830407036
R569 n_0_12_1 n_0_12_2 162.8447056796683
R570 n_0_12_2 n_1_12_2 163.46368882346715
R571 n_0_12_2 n_0_13_2 3121.207439431085
R572 n_0_12_2 n_0_12_3 157.4539843882034
R573 n_0_12_3 n_1_12_3 1144.2458217642688
R574 n_0_12_3 n_0_13_3 21848.452076017573
R575 n_0_12_3 n_0_12_4 1.4599870164384068
R576 n_0_12_4 n_1_12_4 52.011173716557686
R577 n_0_12_4 n_0_13_4 993.1114580007986
R578 n_0_12_4 n_0_12_5 1.27815713160725
R579 n_0_12_5 n_1_12_5 217.95158509795598
R580 n_0_12_5 n_0_13_5 4161.609919241442
R581 n_0_12_5 n_0_12_6 0.29948451619249367
R582 n_0_12_6 n_1_12_6 36.32526418299267
R583 n_0_12_6 n_0_13_6 693.601653206907
R584 n_0_12_6 n_0_12_7 0.40644327197552665
R585 n_0_12_7 n_1_12_7 62.27188145655905
R586 n_0_12_7 n_0_13_7 1189.0314054975588
R587 n_0_12_7 n_0_12_8 0.2994845161924927
R588 n_0_12_8 n_1_12_8 62.27188145655905
R589 n_0_12_8 n_0_13_8 1189.0314054975588
R590 n_0_12_8 n_0_12_9 0.2994845161924927
R591 n_0_12_9 n_1_12_9 62.27188145655905
R592 n_0_12_9 n_0_13_9 1189.0314054975588
R593 n_0_12_9 n_0_12_10 0.2994845161924927
R594 n_0_12_10 n_1_12_10 62.27188145655905
R595 n_0_12_10 n_0_13_10 1189.0314054975588
R596 n_0_12_10 n_0_12_11 0.29948451619249083
R597 n_0_12_11 n_1_12_11 62.27188145655986
R598 n_0_12_11 n_0_13_11 1189.031405497574
R599 n_0_12_11 n_0_12_12 0.29948451619248984
R600 n_0_12_12 n_1_12_12 62.27188145655944
R601 n_0_12_12 n_0_13_12 1189.0314054975663
R602 n_0_12_12 n_0_12_13 0.2994845161924927
R603 n_0_12_13 n_1_12_13 62.27188145655866
R604 n_0_12_13 n_0_13_13 1189.0314054975513
R605 n_0_12_13 n_0_12_14 1.4974225809624675
R606 n_0_12_14 n_1_12_14 6.919097939617658
R607 n_0_12_14 n_0_13_14 132.1146006108396
R608 n_0_12_14 n_0_12_15 46.27035775174067
R609 n_0_12_15 n_1_12_15 2288.4916435285177
R610 n_0_12_15 n_0_13_15 43696.90415203476
R611 n_0_13_0 n_1_13_0 32.692737764693376
R612 n_0_13_0 n_0_13_1 37.061208878821
R613 n_0_13_1 n_1_13_1 45.769832870570724
R614 n_0_13_1 n_0_13_2 162.844705679668
R615 n_0_13_2 n_1_13_2 163.4636888234669
R616 n_0_13_2 n_0_13_3 157.45398438820314
R617 n_0_13_3 n_1_13_3 1144.2458217642672
R618 n_0_13_3 n_0_13_4 1.4599870164384041
R619 n_0_13_4 n_1_13_4 52.0111737165576
R620 n_0_13_4 n_0_13_5 1.2781571316072475
R621 n_0_13_5 n_1_13_5 217.95158509795567
R622 n_0_13_5 n_0_13_6 0.29948451619249317
R623 n_0_13_6 n_1_13_6 36.325264182992605
R624 n_0_13_6 n_0_13_7 0.406443271975526
R625 n_0_13_7 n_1_13_7 62.27188145655895
R626 n_0_13_7 n_0_13_8 0.2994845161924922
R627 n_0_13_8 n_1_13_8 62.27188145655895
R628 n_0_13_8 n_0_13_9 0.2994845161924922
R629 n_0_13_9 n_1_13_9 62.27188145655895
R630 n_0_13_9 n_0_13_10 0.2994845161924922
R631 n_0_13_10 n_1_13_10 62.27188145655895
R632 n_0_13_10 n_0_13_11 0.2994845161924903
R633 n_0_13_11 n_1_13_11 62.27188145655975
R634 n_0_13_11 n_0_13_12 0.2994845161924894
R635 n_0_13_12 n_1_13_12 62.271881456559356
R636 n_0_13_12 n_0_13_13 0.2994845161924923
R637 n_0_13_13 n_1_13_13 62.27188145655856
R638 n_0_13_13 n_0_13_14 1.497422580962465
R639 n_0_13_14 n_1_13_14 6.919097939617647
R640 n_0_13_14 n_0_13_15 46.2703577517406
R641 n_0_13_15 n_1_13_15 2288.491643528514
R642 n_1_0_0 n_2_0_0 19.58524409587235
R643 n_1_0_0 n_1_1_0 624.2415416457985
R644 n_1_0_0 n_1_0_1 37.06120568711566
R645 n_1_0_1 n_2_0_1 27.419341734221284
R646 n_1_0_1 n_1_1_1 873.9381583041178
R647 n_1_0_1 n_1_0_2 162.84469165550817
R648 n_1_0_2 n_2_0_2 97.92622047936175
R649 n_1_0_2 n_1_1_2 3121.2077082289925
R650 n_1_0_2 n_1_0_3 157.45397082829138
R651 n_1_0_3 n_2_0_3 685.4835433555315
R652 n_1_0_3 n_1_1_3 21848.453957602927
R653 n_1_0_3 n_1_0_4 1.4599868907045577
R654 n_1_0_4 n_2_0_4 31.158342879796887
R655 n_1_0_4 n_1_1_4 993.1115435274056
R656 n_1_0_4 n_1_0_5 1.2781570215325615
R657 n_1_0_5 n_2_0_5 130.56829397248217
R658 n_1_0_5 n_1_1_5 4161.610277638653
R659 n_1_0_5 n_1_0_6 0.29948449040093483
R660 n_1_0_6 n_2_0_6 21.761382328747036
R661 n_1_0_6 n_1_1_6 693.6017129397754
R662 n_1_0_6 n_1_0_7 0.40644323697269685
R663 n_1_0_7 n_2_0_7 37.30522684928074
R664 n_1_0_7 n_1_1_7 1189.0315078967617
R665 n_1_0_7 n_1_0_8 0.29948449040093394
R666 n_1_0_8 n_2_0_8 37.30522684928074
R667 n_1_0_8 n_1_1_8 1189.0315078967617
R668 n_1_0_8 n_1_0_9 0.29948449040093394
R669 n_1_0_9 n_2_0_9 37.30522684928074
R670 n_1_0_9 n_1_1_9 1189.0315078967617
R671 n_1_0_9 n_1_0_10 0.29948449040093394
R672 n_1_0_10 n_2_0_10 37.30522684928074
R673 n_1_0_10 n_1_1_10 1189.0315078967617
R674 n_1_0_10 n_1_0_11 0.29948449040093206
R675 n_1_0_11 n_2_0_11 37.30522684928122
R676 n_1_0_11 n_1_1_11 1189.031507896777
R677 n_1_0_11 n_1_0_12 0.29948449040093106
R678 n_1_0_12 n_2_0_12 37.30522684928099
R679 n_1_0_12 n_1_1_12 1189.0315078967692
R680 n_1_0_12 n_1_0_13 0.29948449040093394
R681 n_1_0_13 n_2_0_13 37.30522684928051
R682 n_1_0_13 n_1_1_13 1189.0315078967542
R683 n_1_0_13 n_1_0_14 1.4974224520046735
R684 n_1_0_14 n_2_0_14 4.14502520547563
R685 n_1_0_14 n_1_1_14 132.11461198852882
R686 n_1_0_14 n_1_0_15 46.27035376694484
R687 n_1_0_15 n_2_0_15 1370.9670867110508
R688 n_1_0_15 n_1_1_15 43696.90791520547
R689 n_1_1_0 n_2_1_0 19.58524409587235
R690 n_1_1_0 n_1_2_0 326.2736359366226
R691 n_1_1_0 n_1_1_1 37.06120568711566
R692 n_1_1_1 n_2_1_1 27.419341734221284
R693 n_1_1_1 n_1_2_1 456.7830903112716
R694 n_1_1_1 n_1_1_2 162.84469165550817
R695 n_1_1_2 n_2_1_2 97.92622047936175
R696 n_1_1_2 n_1_2_2 1631.368179683113
R697 n_1_1_2 n_1_1_3 157.45397082829138
R698 n_1_1_3 n_2_1_3 685.4835433555315
R699 n_1_1_3 n_1_2_3 11419.57725778178
R700 n_1_1_3 n_1_1_4 1.4599868907045577
R701 n_1_1_4 n_2_1_4 31.158342879796887
R702 n_1_1_4 n_1_2_4 519.0716935355354
R703 n_1_1_4 n_1_1_5 1.2781570215325615
R704 n_1_1_5 n_2_1_5 130.56829397248217
R705 n_1_1_5 n_1_2_5 2175.157572910816
R706 n_1_1_5 n_1_1_6 0.29948449040093483
R707 n_1_1_6 n_2_1_6 21.761382328747036
R708 n_1_1_6 n_1_2_6 362.52626215180254
R709 n_1_1_6 n_1_1_7 0.40644323697269685
R710 n_1_1_7 n_2_1_7 37.30522684928074
R711 n_1_1_7 n_1_2_7 621.4735922602349
R712 n_1_1_7 n_1_1_8 0.29948449040093394
R713 n_1_1_8 n_2_1_8 37.30522684928074
R714 n_1_1_8 n_1_2_8 621.4735922602349
R715 n_1_1_8 n_1_1_9 0.29948449040093394
R716 n_1_1_9 n_2_1_9 37.30522684928074
R717 n_1_1_9 n_1_2_9 621.4735922602349
R718 n_1_1_9 n_1_1_10 0.29948449040093394
R719 n_1_1_10 n_2_1_10 37.30522684928074
R720 n_1_1_10 n_1_2_10 621.4735922602349
R721 n_1_1_10 n_1_1_11 0.29948449040093206
R722 n_1_1_11 n_2_1_11 37.30522684928122
R723 n_1_1_11 n_1_2_11 621.4735922602429
R724 n_1_1_11 n_1_1_12 0.29948449040093106
R725 n_1_1_12 n_2_1_12 37.30522684928099
R726 n_1_1_12 n_1_2_12 621.4735922602389
R727 n_1_1_12 n_1_1_13 0.29948449040093394
R728 n_1_1_13 n_2_1_13 37.30522684928051
R729 n_1_1_13 n_1_2_13 621.473592260231
R730 n_1_1_13 n_1_1_14 1.4974224520046735
R731 n_1_1_14 n_2_1_14 4.14502520547563
R732 n_1_1_14 n_1_2_14 69.05262136224819
R733 n_1_1_14 n_1_1_15 46.27035376694484
R734 n_1_1_15 n_2_1_15 1370.9670867110508
R735 n_1_1_15 n_1_2_15 22839.15451556336
R736 n_1_2_0 n_2_2_0 431.92395566823194
R737 n_1_2_0 n_1_3_0 28.305730227446716
R738 n_1_2_0 n_1_2_1 817.3307661550475
R739 n_1_2_1 n_2_2_1 604.6935379355247
R740 n_1_2_1 n_1_3_1 39.628022318425394
R741 n_1_2_1 n_1_2_2 3591.301851287331
R742 n_1_2_2 n_2_2_2 2159.6197783411603
R743 n_1_2_2 n_1_3_2 141.52865113723357
R744 n_1_2_2 n_1_2_3 3472.4173762102328
R745 n_1_2_3 n_2_2_3 15117.338448388105
R746 n_1_2_3 n_1_3_3 990.700557960634
R747 n_1_2_3 n_1_2_4 32.19787866671402
R748 n_1_2_4 n_2_2_4 687.1517476540047
R749 n_1_2_4 n_1_3_4 45.031843543665175
R750 n_1_2_4 n_1_2_5 28.18788645181191
R751 n_1_2_5 n_1_3_5 188.70486818297792
R752 n_1_2_5 n_1_2_6 6.604693059838775
R753 n_1_2_6 n_1_3_6 31.450811363829654
R754 n_1_2_6 n_1_2_7 8.963512009781184
R755 n_1_2_7 n_1_3_7 53.915676623708144
R756 n_1_2_7 n_1_2_8 6.604693059838754
R757 n_1_2_8 n_1_3_8 53.915676623708144
R758 n_1_2_8 n_1_2_9 6.604693059838754
R759 n_1_2_9 n_1_3_9 53.915676623708144
R760 n_1_2_9 n_1_2_10 6.604693059838754
R761 n_1_2_10 n_1_3_10 53.915676623708144
R762 n_1_2_10 n_1_2_11 6.604693059838711
R763 n_1_2_11 n_1_3_11 53.91567662370884
R764 n_1_2_11 n_1_2_12 6.604693059838691
R765 n_1_2_12 n_1_3_12 53.91567662370849
R766 n_1_2_12 n_1_2_13 6.604693059838754
R767 n_1_2_13 n_1_3_13 53.9156766237078
R768 n_1_2_13 n_1_2_14 33.02346529919385
R769 n_1_2_14 n_1_3_14 5.990630735967559
R770 n_1_2_14 n_1_2_15 1020.4250777450995
R771 n_1_2_15 n_2_2_15 30234.676896775934
R772 n_1_2_15 n_1_3_15 1981.4011159212507
R773 n_1_3_0 n_2_3_0 431.92395566823194
R774 n_1_3_0 n_1_4_0 827.2137876682011
R775 n_1_3_0 n_1_3_1 817.3307661550475
R776 n_1_3_1 n_2_3_1 604.6935379355247
R777 n_1_3_1 n_1_4_1 1158.0993027354814
R778 n_1_3_1 n_1_3_2 3591.301851287331
R779 n_1_3_2 n_2_3_2 2159.6197783411603
R780 n_1_3_2 n_1_4_2 4136.068938341005
R781 n_1_3_2 n_1_3_3 3472.4173762102328
R782 n_1_3_3 n_2_3_3 15117.338448388105
R783 n_1_3_3 n_1_4_3 28952.48256838701
R784 n_1_3_3 n_1_3_4 32.19787866671402
R785 n_1_3_4 n_2_3_4 687.1517476540047
R786 n_1_3_4 n_1_4_4 1316.0219349266822
R787 n_1_3_4 n_1_3_5 28.18788645181191
R788 n_1_3_5 n_1_4_5 5514.758584454669
R789 n_1_3_5 n_1_3_6 6.604693059838775
R790 n_1_3_6 n_1_4_6 919.1264307424449
R791 n_1_3_6 n_1_3_7 8.963512009781184
R792 n_1_3_7 n_1_4_7 1575.6453098441962
R793 n_1_3_7 n_1_3_8 6.604693059838754
R794 n_1_3_8 n_1_4_8 1575.6453098441962
R795 n_1_3_8 n_1_3_9 6.604693059838754
R796 n_1_3_9 n_1_4_9 1575.6453098441962
R797 n_1_3_9 n_1_3_10 6.604693059838754
R798 n_1_3_10 n_1_4_10 1575.6453098441962
R799 n_1_3_10 n_1_3_11 6.604693059838711
R800 n_1_3_11 n_1_4_11 1575.6453098442164
R801 n_1_3_11 n_1_3_12 6.604693059838691
R802 n_1_3_12 n_1_4_12 1575.6453098442062
R803 n_1_3_12 n_1_3_13 6.604693059838754
R804 n_1_3_13 n_1_4_13 1575.6453098441862
R805 n_1_3_13 n_1_3_14 33.02346529919385
R806 n_1_3_14 n_1_4_14 175.07170109379922
R807 n_1_3_14 n_1_3_15 1020.4250777450995
R808 n_1_3_15 n_2_3_15 30234.676896775934
R809 n_1_3_15 n_1_4_15 57904.96513677351
R810 n_1_4_0 n_2_4_0 7.518454416370901
R811 n_1_4_0 n_1_5_0 1626.1218451089553
R812 n_1_4_0 n_1_4_1 14.227189827725967
R813 n_1_4_1 n_2_4_1 10.525836182919264
R814 n_1_4_1 n_1_5_1 2276.5705831525374
R815 n_1_4_1 n_1_4_2 62.51340984909895
R816 n_1_4_2 n_2_4_2 37.59227208185451
R817 n_1_4_2 n_1_5_2 8130.609225544777
R818 n_1_4_2 n_1_4_3 60.444000419611534
R819 n_1_4_3 n_2_4_3 263.1459045729813
R820 n_1_4_3 n_1_5_3 56914.26457881338
R821 n_1_4_3 n_1_4_4 0.5604650538195083
R822 n_1_4_4 n_2_4_4 11.961177480590061
R823 n_1_4_4 n_1_5_4 2587.0120263096987
R824 n_1_4_4 n_1_4_5 0.49066354528521056
R825 n_1_4_5 n_1_5_5 10840.812300726358
R826 n_1_4_5 n_1_4_6 0.11496719052707863
R827 n_1_4_6 n_1_5_6 1806.80205012106
R828 n_1_4_6 n_1_4_7 0.1560269014296065
R829 n_1_4_7 n_1_5_7 3097.3749430646835
R830 n_1_4_7 n_1_4_8 0.11496719052707827
R831 n_1_4_8 n_1_5_8 3097.3749430646835
R832 n_1_4_8 n_1_4_9 0.11496719052707827
R833 n_1_4_9 n_1_5_9 3097.3749430646835
R834 n_1_4_9 n_1_4_10 0.11496719052707827
R835 n_1_4_10 n_1_5_10 3097.3749430646835
R836 n_1_4_10 n_1_4_11 0.11496719052707753
R837 n_1_4_11 n_1_5_11 3097.3749430647235
R838 n_1_4_11 n_1_4_12 0.11496719052707716
R839 n_1_4_12 n_1_5_12 3097.374943064703
R840 n_1_4_12 n_1_4_13 0.11496719052707827
R841 n_1_4_13 n_1_5_13 3097.374943064664
R842 n_1_4_13 n_1_4_14 0.5748359526353928
R843 n_1_4_14 n_1_5_14 344.1527714516308
R844 n_1_4_14 n_1_4_15 17.762430936433798
R845 n_1_4_15 n_2_4_15 526.291809145958
R846 n_1_4_15 n_1_5_15 113828.52915762576
R847 n_1_5_0 n_2_5_0 7.518454416370906
R848 n_1_5_0 n_1_6_0 827.2138119611458
R849 n_1_5_0 n_1_5_1 14.227189827725972
R850 n_1_5_1 n_2_5_1 10.525836182919267
R851 n_1_5_1 n_1_6_1 1158.099336745604
R852 n_1_5_1 n_1_5_2 62.51340984909897
R853 n_1_5_2 n_2_5_2 37.592272081854524
R854 n_1_5_2 n_1_6_2 4136.069059805729
R855 n_1_5_2 n_1_5_3 60.444000419611555
R856 n_1_5_3 n_2_5_3 263.1459045729814
R857 n_1_5_3 n_1_6_3 28952.483418640077
R858 n_1_5_3 n_1_5_4 0.5604650538195085
R859 n_1_5_4 n_2_5_4 11.961177480590065
R860 n_1_5_4 n_1_6_4 1316.0219735745486
R861 n_1_5_4 n_1_5_5 0.4906635452852107
R862 n_1_5_5 n_1_6_5 5514.758746407633
R863 n_1_5_5 n_1_5_6 0.11496719052707867
R864 n_1_5_6 n_1_6_6 919.1264577346055
R865 n_1_5_6 n_1_5_7 0.1560269014296066
R866 n_1_5_7 n_1_6_7 1575.6453561164717
R867 n_1_5_7 n_1_5_8 0.11496719052707831
R868 n_1_5_8 n_1_6_8 1575.6453561164717
R869 n_1_5_8 n_1_5_9 0.11496719052707831
R870 n_1_5_9 n_1_6_9 1575.6453561164717
R871 n_1_5_9 n_1_5_10 0.11496719052707831
R872 n_1_5_10 n_1_6_10 1575.6453561164717
R873 n_1_5_10 n_1_5_11 0.11496719052707757
R874 n_1_5_11 n_1_6_11 1575.645356116492
R875 n_1_5_11 n_1_5_12 0.11496719052707721
R876 n_1_5_12 n_1_6_12 1575.6453561164817
R877 n_1_5_12 n_1_5_13 0.11496719052707831
R878 n_1_5_13 n_1_6_13 1575.6453561164617
R879 n_1_5_13 n_1_5_14 0.574835952635393
R880 n_1_5_14 n_1_6_14 175.07170623516316
R881 n_1_5_14 n_1_5_15 17.762430936433805
R882 n_1_5_15 n_2_5_15 526.2918091459583
R883 n_1_5_15 n_1_6_15 57904.966837279644
R884 n_1_6_0 n_2_6_0 431.9232142857081
R885 n_1_6_0 n_1_7_0 28.305778813336566
R886 n_1_6_0 n_1_6_1 817.3293632350699
R887 n_1_6_1 n_2_6_1 604.6924999999914
R888 n_1_6_1 n_1_7_1 39.62809033867119
R889 n_1_6_1 n_1_6_2 3591.295686941974
R890 n_1_6_2 n_2_6_2 2159.6160714285406
R891 n_1_6_2 n_1_7_2 141.52889406668282
R892 n_1_6_2 n_1_6_3 3472.411415925964
R893 n_1_6_3 n_2_6_3 15117.31249999977
R894 n_1_6_3 n_1_7_3 990.7022584667789
R895 n_1_6_3 n_1_6_4 32.197823400169455
R896 n_1_6_4 n_2_6_4 687.1505681818079
R897 n_1_6_4 n_1_7_4 45.031920839399035
R898 n_1_6_4 n_1_6_5 28.187838068280215
R899 n_1_6_5 n_1_7_5 188.70519208891028
R900 n_1_6_5 n_1_6_6 6.604681723111682
R901 n_1_6_6 n_1_7_6 31.450865348151712
R902 n_1_6_6 n_1_6_7 8.963496624222987
R903 n_1_6_7 n_1_7_7 53.91576916826025
R904 n_1_6_7 n_1_6_8 6.6046817231116615
R905 n_1_6_8 n_1_7_8 53.91576916826025
R906 n_1_6_8 n_1_6_9 6.6046817231116615
R907 n_1_6_9 n_1_7_9 53.91576916826025
R908 n_1_6_9 n_1_6_10 6.6046817231116615
R909 n_1_6_10 n_1_7_10 53.91576916826025
R910 n_1_6_10 n_1_6_11 6.60468172311162
R911 n_1_6_11 n_1_7_11 53.915769168260944
R912 n_1_6_11 n_1_6_12 6.604681723111598
R913 n_1_6_12 n_1_7_12 53.91576916826059
R914 n_1_6_12 n_1_6_13 6.604681723111662
R915 n_1_6_13 n_1_7_13 53.91576916825991
R916 n_1_6_13 n_1_6_14 33.023408615558395
R917 n_1_6_14 n_1_7_14 5.9906410186955705
R918 n_1_6_14 n_1_6_15 1020.4233262207638
R919 n_1_6_15 n_2_6_15 30234.624999999272
R920 n_1_6_15 n_1_7_15 1981.4045169335404
R921 n_1_7_0 n_2_7_0 431.9232142857081
R922 n_1_7_0 n_1_8_0 827.2138119611458
R923 n_1_7_0 n_1_7_1 817.3293632350699
R924 n_1_7_1 n_2_7_1 604.6924999999914
R925 n_1_7_1 n_1_8_1 1158.099336745604
R926 n_1_7_1 n_1_7_2 3591.295686941974
R927 n_1_7_2 n_2_7_2 2159.6160714285406
R928 n_1_7_2 n_1_8_2 4136.069059805729
R929 n_1_7_2 n_1_7_3 3472.411415925964
R930 n_1_7_3 n_2_7_3 15117.31249999977
R931 n_1_7_3 n_1_8_3 28952.483418640077
R932 n_1_7_3 n_1_7_4 32.197823400169455
R933 n_1_7_4 n_2_7_4 687.1505681818079
R934 n_1_7_4 n_1_8_4 1316.0219735745486
R935 n_1_7_4 n_1_7_5 28.187838068280215
R936 n_1_7_5 n_1_8_5 5514.758746407633
R937 n_1_7_5 n_1_7_6 6.604681723111682
R938 n_1_7_6 n_1_8_6 919.1264577346055
R939 n_1_7_6 n_1_7_7 8.963496624222987
R940 n_1_7_7 n_1_8_7 1575.6453561164717
R941 n_1_7_7 n_1_7_8 6.6046817231116615
R942 n_1_7_8 n_1_8_8 1575.6453561164717
R943 n_1_7_8 n_1_7_9 6.6046817231116615
R944 n_1_7_9 n_1_8_9 1575.6453561164717
R945 n_1_7_9 n_1_7_10 6.6046817231116615
R946 n_1_7_10 n_1_8_10 1575.6453561164717
R947 n_1_7_10 n_1_7_11 6.60468172311162
R948 n_1_7_11 n_1_8_11 1575.645356116492
R949 n_1_7_11 n_1_7_12 6.604681723111598
R950 n_1_7_12 n_1_8_12 1575.6453561164817
R951 n_1_7_12 n_1_7_13 6.604681723111662
R952 n_1_7_13 n_1_8_13 1575.6453561164617
R953 n_1_7_13 n_1_7_14 33.023408615558395
R954 n_1_7_14 n_1_8_14 175.07170623516316
R955 n_1_7_14 n_1_7_15 1020.4233262207638
R956 n_1_7_15 n_2_7_15 30234.624999999272
R957 n_1_7_15 n_1_8_15 57904.966837279644
R958 n_1_8_0 n_2_8_0 7.518454416370906
R959 n_1_8_0 n_1_9_0 1626.121845108955
R960 n_1_8_0 n_1_8_1 14.227189827725972
R961 n_1_8_1 n_2_8_1 10.525836182919267
R962 n_1_8_1 n_1_9_1 2276.570583152537
R963 n_1_8_1 n_1_8_2 62.51340984909897
R964 n_1_8_2 n_2_8_2 37.592272081854524
R965 n_1_8_2 n_1_9_2 8130.609225544775
R966 n_1_8_2 n_1_8_3 60.444000419611555
R967 n_1_8_3 n_2_8_3 263.1459045729814
R968 n_1_8_3 n_1_9_3 56914.264578813374
R969 n_1_8_3 n_1_8_4 0.5604650538195085
R970 n_1_8_4 n_2_8_4 11.961177480590065
R971 n_1_8_4 n_1_9_4 2587.0120263096983
R972 n_1_8_4 n_1_8_5 0.4906635452852107
R973 n_1_8_5 n_1_9_5 10840.812300726357
R974 n_1_8_5 n_1_8_6 0.11496719052707867
R975 n_1_8_6 n_1_9_6 1806.8020501210594
R976 n_1_8_6 n_1_8_7 0.1560269014296066
R977 n_1_8_7 n_1_9_7 3097.374943064683
R978 n_1_8_7 n_1_8_8 0.11496719052707831
R979 n_1_8_8 n_1_9_8 3097.374943064683
R980 n_1_8_8 n_1_8_9 0.11496719052707831
R981 n_1_8_9 n_1_9_9 3097.374943064683
R982 n_1_8_9 n_1_8_10 0.11496719052707831
R983 n_1_8_10 n_1_9_10 3097.374943064683
R984 n_1_8_10 n_1_8_11 0.11496719052707757
R985 n_1_8_11 n_1_9_11 3097.374943064723
R986 n_1_8_11 n_1_8_12 0.11496719052707721
R987 n_1_8_12 n_1_9_12 3097.3749430647026
R988 n_1_8_12 n_1_8_13 0.11496719052707831
R989 n_1_8_13 n_1_9_13 3097.3749430646635
R990 n_1_8_13 n_1_8_14 0.574835952635393
R991 n_1_8_14 n_1_9_14 344.15277145163077
R992 n_1_8_14 n_1_8_15 17.762430936433805
R993 n_1_8_15 n_2_8_15 526.2918091459583
R994 n_1_8_15 n_1_9_15 113828.52915762574
R995 n_1_9_0 n_2_9_0 7.518454416370906
R996 n_1_9_0 n_1_10_0 827.213814547992
R997 n_1_9_0 n_1_9_1 14.227189827725972
R998 n_1_9_1 n_2_9_1 10.525836182919267
R999 n_1_9_1 n_1_10_1 1158.0993403671887
R1000 n_1_9_1 n_1_9_2 62.51340984909897
R1001 n_1_9_2 n_2_9_2 37.592272081854524
R1002 n_1_9_2 n_1_10_2 4136.06907273996
R1003 n_1_9_2 n_1_9_3 60.444000419611555
R1004 n_1_9_3 n_2_9_3 263.1459045729814
R1005 n_1_9_3 n_1_10_3 28952.483509179692
R1006 n_1_9_3 n_1_9_4 0.5604650538195085
R1007 n_1_9_4 n_2_9_4 11.961177480590065
R1008 n_1_9_4 n_1_10_4 1316.0219776899858
R1009 n_1_9_4 n_1_9_5 0.4906635452852107
R1010 n_1_9_5 n_1_10_5 5514.758763653274
R1011 n_1_9_5 n_1_9_6 0.11496719052707867
R1012 n_1_9_6 n_1_10_6 919.1264606088791
R1013 n_1_9_6 n_1_9_7 0.1560269014296066
R1014 n_1_9_7 n_1_10_7 1575.6453610437977
R1015 n_1_9_7 n_1_9_8 0.11496719052707831
R1016 n_1_9_8 n_1_10_8 1575.6453610437977
R1017 n_1_9_8 n_1_9_9 0.11496719052707831
R1018 n_1_9_9 n_1_10_9 1575.6453610437977
R1019 n_1_9_9 n_1_9_10 0.11496719052707831
R1020 n_1_9_10 n_1_10_10 1575.6453610437977
R1021 n_1_9_10 n_1_9_11 0.11496719052707757
R1022 n_1_9_11 n_1_10_11 1575.6453610438182
R1023 n_1_9_11 n_1_9_12 0.11496719052707721
R1024 n_1_9_12 n_1_10_12 1575.6453610438077
R1025 n_1_9_12 n_1_9_13 0.11496719052707831
R1026 n_1_9_13 n_1_10_13 1575.6453610437877
R1027 n_1_9_13 n_1_9_14 0.574835952635393
R1028 n_1_9_14 n_1_10_14 175.07170678264384
R1029 n_1_9_14 n_1_9_15 17.762430936433805
R1030 n_1_9_15 n_2_9_15 526.2918091459583
R1031 n_1_9_15 n_1_10_15 57904.967018358875
R1032 n_1_10_0 n_2_10_0 431.9231353393748
R1033 n_1_10_0 n_1_11_0 28.305783987028477
R1034 n_1_10_0 n_1_10_1 817.3292138447288
R1035 n_1_10_1 n_2_10_1 604.6923894751246
R1036 n_1_10_1 n_1_11_1 39.62809758183987
R1037 n_1_10_1 n_1_10_2 3591.295030529869
R1038 n_1_10_2 n_2_10_2 2159.6156766968743
R1039 n_1_10_2 n_1_11_2 141.52891993514237
R1040 n_1_10_2 n_1_10_3 3472.4107812433635
R1041 n_1_10_3 n_2_10_3 15117.309736878102
R1042 n_1_10_3 n_1_11_3 990.7024395459957
R1043 n_1_10_3 n_1_10_4 32.19781751509541
R1044 n_1_10_4 n_2_10_4 687.1504425853684
R1045 n_1_10_4 n_1_11_4 45.031929070272525
R1046 n_1_10_4 n_1_10_5 28.187832916145794
R1047 n_1_10_5 n_1_11_5 188.70522658018967
R1048 n_1_10_5 n_1_10_6 6.604680515917008
R1049 n_1_10_6 n_1_11_6 31.45087109669828
R1050 n_1_10_6 n_1_10_7 8.963494985887356
R1051 n_1_10_7 n_1_11_7 53.91577902291151
R1052 n_1_10_7 n_1_10_8 6.604680515916987
R1053 n_1_10_8 n_1_11_8 53.91577902291151
R1054 n_1_10_8 n_1_10_9 6.604680515916987
R1055 n_1_10_9 n_1_11_9 53.91577902291151
R1056 n_1_10_9 n_1_10_10 6.604680515916987
R1057 n_1_10_10 n_1_11_10 53.91577902291151
R1058 n_1_10_10 n_1_10_11 6.604680515916945
R1059 n_1_10_11 n_1_11_11 53.915779022912204
R1060 n_1_10_11 n_1_10_12 6.6046805159169235
R1061 n_1_10_12 n_1_11_12 53.91577902291185
R1062 n_1_10_12 n_1_10_13 6.6046805159169875
R1063 n_1_10_13 n_1_11_13 53.91577902291117
R1064 n_1_10_13 n_1_10_14 33.02340257958502
R1065 n_1_10_14 n_1_11_14 5.990642113656822
R1066 n_1_10_14 n_1_10_15 1020.4231397091863
R1067 n_1_10_15 n_2_10_15 30234.619473755934
R1068 n_1_10_15 n_1_11_15 1981.4048790919742
R1069 n_1_11_0 n_2_11_0 431.9231353393901
R1070 n_1_11_0 n_1_12_0 326.2736359366222
R1071 n_1_11_0 n_1_11_1 817.3292138447578
R1072 n_1_11_1 n_2_11_1 604.6923894751462
R1073 n_1_11_1 n_1_12_1 456.78309031127105
R1074 n_1_11_1 n_1_11_2 3591.295030529997
R1075 n_1_11_2 n_2_11_2 2159.6156766969507
R1076 n_1_11_2 n_1_12_2 1631.368179683111
R1077 n_1_11_2 n_1_11_3 3472.410781243487
R1078 n_1_11_3 n_2_11_3 15117.30973687864
R1079 n_1_11_3 n_1_12_3 11419.577257781766
R1080 n_1_11_3 n_1_11_4 32.197817515096546
R1081 n_1_11_4 n_2_11_4 687.1504425853927
R1082 n_1_11_4 n_1_12_4 519.0716935355348
R1083 n_1_11_4 n_1_11_5 28.187832916146796
R1084 n_1_11_5 n_1_12_5 2175.157572910813
R1085 n_1_11_5 n_1_11_6 6.604680515917241
R1086 n_1_11_6 n_1_12_6 362.52626215180214
R1087 n_1_11_6 n_1_11_7 8.963494985887674
R1088 n_1_11_7 n_1_12_7 621.4735922602341
R1089 n_1_11_7 n_1_11_8 6.60468051591722
R1090 n_1_11_8 n_1_12_8 621.4735922602341
R1091 n_1_11_8 n_1_11_9 6.60468051591722
R1092 n_1_11_9 n_1_12_9 621.4735922602341
R1093 n_1_11_9 n_1_11_10 6.60468051591722
R1094 n_1_11_10 n_1_12_10 621.4735922602341
R1095 n_1_11_10 n_1_11_11 6.6046805159171775
R1096 n_1_11_11 n_1_12_11 621.4735922602422
R1097 n_1_11_11 n_1_11_12 6.604680515917156
R1098 n_1_11_12 n_1_12_12 621.4735922602381
R1099 n_1_11_12 n_1_11_13 6.60468051591722
R1100 n_1_11_13 n_1_12_13 621.4735922602302
R1101 n_1_11_13 n_1_11_14 33.02340257958618
R1102 n_1_11_14 n_1_12_14 69.0526213622481
R1103 n_1_11_14 n_1_11_15 1020.4231397092226
R1104 n_1_11_15 n_2_11_15 30234.61947375701
R1105 n_1_11_15 n_1_12_15 22839.154515563332
R1106 n_1_12_0 n_2_12_0 19.585245782550594
R1107 n_1_12_0 n_1_13_0 624.2414878862169
R1108 n_1_12_0 n_1_12_1 37.06120887882106
R1109 n_1_12_1 n_2_12_1 27.41934409557083
R1110 n_1_12_1 n_1_13_1 873.9380830407036
R1111 n_1_12_1 n_1_12_2 162.8447056796683
R1112 n_1_12_2 n_2_12_2 97.92622891275296
R1113 n_1_12_2 n_1_13_2 3121.207439431085
R1114 n_1_12_2 n_1_12_3 157.4539843882034
R1115 n_1_12_3 n_2_12_3 685.48360238927
R1116 n_1_12_3 n_1_13_3 21848.452076017573
R1117 n_1_12_3 n_1_12_4 1.4599870164384068
R1118 n_1_12_4 n_2_12_4 31.158345563148643
R1119 n_1_12_4 n_1_13_4 993.1114580007986
R1120 n_1_12_4 n_1_12_5 1.27815713160725
R1121 n_1_12_5 n_2_12_5 130.5683052170038
R1122 n_1_12_5 n_1_13_5 4161.609919241442
R1123 n_1_12_5 n_1_12_6 0.29948451619249367
R1124 n_1_12_6 n_2_12_6 21.76138420283397
R1125 n_1_12_6 n_1_13_6 693.601653206907
R1126 n_1_12_6 n_1_12_7 0.40644327197552665
R1127 n_1_12_7 n_2_12_7 37.30523006200121
R1128 n_1_12_7 n_1_13_7 1189.0314054975588
R1129 n_1_12_7 n_1_12_8 0.2994845161924927
R1130 n_1_12_8 n_2_12_8 37.30523006200121
R1131 n_1_12_8 n_1_13_8 1189.0314054975588
R1132 n_1_12_8 n_1_12_9 0.2994845161924927
R1133 n_1_12_9 n_2_12_9 37.30523006200121
R1134 n_1_12_9 n_1_13_9 1189.0314054975588
R1135 n_1_12_9 n_1_12_10 0.2994845161924927
R1136 n_1_12_10 n_2_12_10 37.30523006200121
R1137 n_1_12_10 n_1_13_10 1189.0314054975588
R1138 n_1_12_10 n_1_12_11 0.29948451619249083
R1139 n_1_12_11 n_2_12_11 37.30523006200169
R1140 n_1_12_11 n_1_13_11 1189.031405497574
R1141 n_1_12_11 n_1_12_12 0.29948451619248984
R1142 n_1_12_12 n_2_12_12 37.30523006200144
R1143 n_1_12_12 n_1_13_12 1189.0314054975663
R1144 n_1_12_12 n_1_12_13 0.2994845161924927
R1145 n_1_12_13 n_2_12_13 37.30523006200097
R1146 n_1_12_13 n_1_13_13 1189.0314054975513
R1147 n_1_12_13 n_1_12_14 1.4974225809624675
R1148 n_1_12_14 n_2_12_14 4.14502556244457
R1149 n_1_12_14 n_1_13_14 132.1146006108396
R1150 n_1_12_14 n_1_12_15 46.27035775174067
R1151 n_1_12_15 n_2_12_15 1370.967204778528
R1152 n_1_12_15 n_1_13_15 43696.90415203476
R1153 n_1_13_0 n_2_13_0 19.585245782550558
R1154 n_1_13_0 n_1_13_1 37.061208878821
R1155 n_1_13_1 n_2_13_1 27.419344095570782
R1156 n_1_13_1 n_1_13_2 162.844705679668
R1157 n_1_13_2 n_2_13_2 97.9262289127528
R1158 n_1_13_2 n_1_13_3 157.45398438820314
R1159 n_1_13_3 n_2_13_3 685.483602389269
R1160 n_1_13_3 n_1_13_4 1.4599870164384041
R1161 n_1_13_4 n_2_13_4 31.15834556314859
R1162 n_1_13_4 n_1_13_5 1.2781571316072475
R1163 n_1_13_5 n_2_13_5 130.56830521700363
R1164 n_1_13_5 n_1_13_6 0.29948451619249317
R1165 n_1_13_6 n_2_13_6 21.761384202833934
R1166 n_1_13_6 n_1_13_7 0.406443271975526
R1167 n_1_13_7 n_2_13_7 37.30523006200115
R1168 n_1_13_7 n_1_13_8 0.2994845161924922
R1169 n_1_13_8 n_2_13_8 37.30523006200115
R1170 n_1_13_8 n_1_13_9 0.2994845161924922
R1171 n_1_13_9 n_2_13_9 37.30523006200115
R1172 n_1_13_9 n_1_13_10 0.2994845161924922
R1173 n_1_13_10 n_2_13_10 37.30523006200115
R1174 n_1_13_10 n_1_13_11 0.2994845161924903
R1175 n_1_13_11 n_2_13_11 37.30523006200163
R1176 n_1_13_11 n_1_13_12 0.2994845161924894
R1177 n_1_13_12 n_2_13_12 37.30523006200139
R1178 n_1_13_12 n_1_13_13 0.2994845161924923
R1179 n_1_13_13 n_2_13_13 37.305230062000916
R1180 n_1_13_13 n_1_13_14 1.497422580962465
R1181 n_1_13_14 n_2_13_14 4.145025562444563
R1182 n_1_13_14 n_1_13_15 46.2703577517406
R1183 n_1_13_15 n_2_13_15 1370.9672047785257
R1184 n_2_0_0 n_3_0_0 6.477753242544629
R1185 n_2_0_0 n_2_1_0 3150.5002585262537
R1186 n_2_0_0 n_2_0_1 187.04512645972574
R1187 n_2_0_1 n_3_0_1 9.068854539562478
R1188 n_2_0_1 n_2_1_1 4410.700361936755
R1189 n_2_0_1 n_2_0_2 821.8649495957645
R1190 n_2_0_2 n_3_0_2 32.38876621272314
R1191 n_2_0_2 n_2_1_2 15752.501292631268
R1192 n_2_0_2 n_2_0_3 794.6583857470772
R1193 n_2_0_3 n_3_0_3 226.72136348906173
R1194 n_2_0_3 n_2_1_3 110267.50904841878
R1195 n_2_0_3 n_2_0_4 7.368444375686172
R1196 n_2_0_4 n_3_0_4 10.30551652223008
R1197 n_2_0_4 n_2_1_4 5012.159502200853
R1198 n_2_0_4 n_2_0_5 6.450762658567747
R1199 n_2_0_5 n_3_0_5 43.18502161696414
R1200 n_2_0_5 n_2_1_5 21003.33505684167
R1201 n_2_0_5 n_2_0_6 1.5114757693715226
R1202 n_2_0_6 n_3_0_6 7.197503602827358
R1203 n_2_0_6 n_2_1_6 3500.5558428069457
R1204 n_2_0_6 n_2_0_7 2.051288544147064
R1205 n_2_0_7 n_3_0_7 12.338577604846938
R1206 n_2_0_7 n_2_1_7 6000.952873383354
R1207 n_2_0_7 n_2_0_8 1.511475769371518
R1208 n_2_0_8 n_3_0_8 12.338577604846938
R1209 n_2_0_8 n_2_1_8 6000.952873383354
R1210 n_2_0_8 n_2_0_9 1.511475769371518
R1211 n_2_0_9 n_3_0_9 12.338577604846938
R1212 n_2_0_9 n_2_1_9 6000.952873383354
R1213 n_2_0_9 n_2_0_10 1.511475769371518
R1214 n_2_0_10 n_3_0_10 12.338577604846938
R1215 n_2_0_10 n_2_1_10 6000.952873383354
R1216 n_2_0_10 n_2_0_11 1.5114757693715082
R1217 n_2_0_11 n_3_0_11 12.338577604847094
R1218 n_2_0_11 n_2_1_11 6000.9528733834295
R1219 n_2_0_11 n_2_0_12 1.5114757693715033
R1220 n_2_0_12 n_3_0_12 12.33857760484702
R1221 n_2_0_12 n_2_1_12 6000.952873383392
R1222 n_2_0_12 n_2_0_13 1.511475769371518
R1223 n_2_0_13 n_3_0_13 12.33857760484686
R1224 n_2_0_13 n_2_1_13 6000.952873383315
R1225 n_2_0_13 n_2_0_14 7.557378846857608
R1226 n_2_0_14 n_3_0_14 1.3709530672052124
R1227 n_2_0_14 n_2_1_14 666.772541487038
R1228 n_2_0_14 n_2_0_15 233.5230063679022
R1229 n_2_0_15 n_3_0_15 453.44272697811954
R1230 n_2_0_15 n_2_1_15 220535.01809683556
R1231 n_2_1_0 n_3_1_0 6.477753242544629
R1232 n_2_1_0 n_2_2_0 1646.6785783889504
R1233 n_2_1_0 n_2_1_1 187.04512645972574
R1234 n_2_1_1 n_3_1_1 9.068854539562478
R1235 n_2_1_1 n_2_2_1 2305.350009744531
R1236 n_2_1_1 n_2_1_2 821.8649495957645
R1237 n_2_1_2 n_3_1_2 32.38876621272314
R1238 n_2_1_2 n_2_2_2 8233.392891944752
R1239 n_2_1_2 n_2_1_3 794.6583857470772
R1240 n_2_1_3 n_3_1_3 226.72136348906173
R1241 n_2_1_3 n_2_2_3 57633.75024361321
R1242 n_2_1_3 n_2_1_4 7.368444375686172
R1243 n_2_1_4 n_3_1_4 10.30551652223008
R1244 n_2_1_4 n_2_2_4 2619.7159201642366
R1245 n_2_1_4 n_2_1_5 6.450762658567747
R1246 n_2_1_5 n_3_1_5 43.18502161696414
R1247 n_2_1_5 n_2_1_6 1.5114757693715226
R1248 n_2_1_6 n_3_1_6 7.197503602827358
R1249 n_2_1_6 n_2_1_7 2.051288544147064
R1250 n_2_1_7 n_3_1_7 12.338577604846938
R1251 n_2_1_7 n_2_1_8 1.511475769371518
R1252 n_2_1_8 n_3_1_8 12.338577604846938
R1253 n_2_1_8 n_2_1_9 1.511475769371518
R1254 n_2_1_9 n_3_1_9 12.338577604846938
R1255 n_2_1_9 n_2_1_10 1.511475769371518
R1256 n_2_1_10 n_3_1_10 12.338577604846938
R1257 n_2_1_10 n_2_1_11 1.5114757693715082
R1258 n_2_1_11 n_3_1_11 12.338577604847094
R1259 n_2_1_11 n_2_1_12 1.5114757693715033
R1260 n_2_1_12 n_3_1_12 12.33857760484702
R1261 n_2_1_12 n_2_1_13 1.511475769371518
R1262 n_2_1_13 n_3_1_13 12.33857760484686
R1263 n_2_1_13 n_2_1_14 7.557378846857608
R1264 n_2_1_14 n_3_1_14 1.3709530672052124
R1265 n_2_1_14 n_2_1_15 233.5230063679022
R1266 n_2_1_15 n_3_1_15 453.44272697811954
R1267 n_2_1_15 n_2_2_15 115267.50048722538
R1268 n_2_2_0 n_3_2_0 142.85738746305734
R1269 n_2_2_0 n_2_3_0 142.85689825164727
R1270 n_2_2_0 n_2_2_1 4125.007097867931
R1271 n_2_2_1 n_3_2_1 200.00034244828024
R1272 n_2_2_1 n_2_3_1 199.99965755230616
R1273 n_2_2_1 n_2_2_2 18125.031187601515
R1274 n_2_2_2 n_3_2_2 714.2869373152868
R1275 n_2_2_2 n_2_3_2 714.2844912582364
R1276 n_2_2_2 n_2_2_3 17525.030155184362
R1277 n_2_2_3 n_3_2_3 5000.008561207002
R1278 n_2_2_3 n_2_3_3 4999.9914388076495
R1279 n_2_2_3 n_2_2_4 162.50027961297926
R1280 n_2_2_4 n_3_2_4 227.27311641850005
R1281 n_2_2_4 n_2_3_4 227.2723381276204
R1282 n_2_2_15 n_3_2_15 10000.017122413912
R1283 n_2_2_15 n_2_3_15 9999.982877615208
R1284 n_2_3_0 n_3_3_0 142.85738746305734
R1285 n_2_3_0 n_2_4_0 4174.8859664708125
R1286 n_2_3_0 n_2_3_1 4125.007097867931
R1287 n_2_3_1 n_3_3_1 200.00034244828024
R1288 n_2_3_1 n_2_4_1 5844.840353059136
R1289 n_2_3_1 n_2_3_2 18125.031187601515
R1290 n_2_3_2 n_3_3_2 714.2869373152868
R1291 n_2_3_2 n_2_4_2 20874.42983235406
R1292 n_2_3_2 n_2_3_3 17525.030155184362
R1293 n_2_3_3 n_3_3_3 5000.008561207002
R1294 n_2_3_3 n_2_4_3 146121.00882647827
R1295 n_2_3_3 n_2_3_4 162.50027961297926
R1296 n_2_3_4 n_3_3_4 227.27311641850005
R1297 n_2_3_4 n_2_4_4 6641.864037567194
R1298 n_2_3_15 n_3_3_15 10000.017122413912
R1299 n_2_3_15 n_2_4_15 292242.0176529539
R1300 n_2_4_0 n_3_4_0 2.4867033689324725
R1301 n_2_4_0 n_2_5_0 8206.915034689977
R1302 n_2_4_0 n_2_4_1 71.803560384941
R1303 n_2_4_1 n_3_4_1 3.481384716505462
R1304 n_2_4_1 n_2_5_1 11489.681048565964
R1305 n_2_4_1 n_2_4_2 315.5004926004983
R1306 n_2_4_2 n_3_4_2 12.433516844662364
R1307 n_2_4_2 n_2_5_2 41034.57517344988
R1308 n_2_4_2 n_2_4_3 305.0563383626887
R1309 n_2_4_3 n_3_4_3 87.03461791263646
R1310 n_2_4_3 n_2_5_3 287242.02621414885
R1311 n_2_4_3 n_2_4_4 2.828625106073435
R1312 n_2_4_4 n_3_4_4 3.9561189960289305
R1313 n_2_4_4 n_2_5_4 13056.455737006765
R1314 n_2_4_15 n_3_4_15 174.0692358252714
R1315 n_2_4_15 n_2_5_15 574484.0524282926
R1316 n_2_5_0 n_3_5_0 2.486703368932474
R1317 n_2_5_0 n_2_6_0 4174.886089075483
R1318 n_2_5_0 n_2_5_1 71.803560384941
R1319 n_2_5_1 n_3_5_1 3.481384716505463
R1320 n_2_5_1 n_2_6_1 5844.840524705674
R1321 n_2_5_1 n_2_5_2 315.5004926004984
R1322 n_2_5_2 n_3_5_2 12.433516844662368
R1323 n_2_5_2 n_2_6_2 20874.430445377413
R1324 n_2_5_2 n_2_5_3 305.05633836268873
R1325 n_2_5_3 n_3_5_3 87.0346179126365
R1326 n_2_5_3 n_2_6_3 146121.01311764176
R1327 n_2_5_3 n_2_5_4 2.828625106073436
R1328 n_2_5_4 n_3_5_4 3.956118996028932
R1329 n_2_5_4 n_2_6_4 6641.864232620079
R1330 n_2_5_15 n_3_5_15 174.06923582527145
R1331 n_2_5_15 n_2_6_15 292242.02623528085
R1332 n_2_6_0 n_3_6_0 142.8571422532951
R1333 n_2_6_0 n_2_7_0 142.85714346099064
R1334 n_2_6_0 n_2_6_1 4125.0000174359875
R1335 n_2_6_1 n_3_6_1 199.99999915461314
R1336 n_2_6_1 n_2_7_1 200.0000008453869
R1337 n_2_6_1 n_2_6_2 18125.000076612672
R1338 n_2_6_2 n_3_6_2 714.2857112664756
R1339 n_2_6_2 n_2_7_2 714.2857173049533
R1340 n_2_6_2 n_2_6_3 17525.000074076528
R1341 n_2_6_3 n_3_6_3 4999.999978865324
R1342 n_2_6_3 n_2_7_3 5000.000021134669
R1343 n_2_6_3 n_2_6_4 162.5000006868724
R1344 n_2_6_4 n_3_6_4 227.2727263120602
R1345 n_2_6_4 n_2_7_4 227.272728233394
R1346 n_2_6_15 n_3_6_15 9999.99995773056
R1347 n_2_6_15 n_2_7_15 10000.000042269246
R1348 n_2_7_0 n_3_7_0 142.8571422532951
R1349 n_2_7_0 n_2_8_0 4174.886089075483
R1350 n_2_7_0 n_2_7_1 4125.0000174359875
R1351 n_2_7_1 n_3_7_1 199.99999915461314
R1352 n_2_7_1 n_2_8_1 5844.840524705674
R1353 n_2_7_1 n_2_7_2 18125.000076612672
R1354 n_2_7_2 n_3_7_2 714.2857112664756
R1355 n_2_7_2 n_2_8_2 20874.430445377413
R1356 n_2_7_2 n_2_7_3 17525.000074076528
R1357 n_2_7_3 n_3_7_3 4999.999978865324
R1358 n_2_7_3 n_2_8_3 146121.01311764176
R1359 n_2_7_3 n_2_7_4 162.5000006868724
R1360 n_2_7_4 n_3_7_4 227.2727263120602
R1361 n_2_7_4 n_2_8_4 6641.864232620079
R1362 n_2_7_15 n_3_7_15 9999.99995773056
R1363 n_2_7_15 n_2_8_15 292242.02623528085
R1364 n_2_8_0 n_3_8_0 2.486703368932474
R1365 n_2_8_0 n_2_9_0 8206.915034689975
R1366 n_2_8_0 n_2_8_1 71.803560384941
R1367 n_2_8_1 n_3_8_1 3.481384716505463
R1368 n_2_8_1 n_2_9_1 11489.681048565963
R1369 n_2_8_1 n_2_8_2 315.5004926004984
R1370 n_2_8_2 n_3_8_2 12.433516844662368
R1371 n_2_8_2 n_2_9_2 41034.57517344987
R1372 n_2_8_2 n_2_8_3 305.05633836268873
R1373 n_2_8_3 n_3_8_3 87.0346179126365
R1374 n_2_8_3 n_2_9_3 287242.02621414885
R1375 n_2_8_3 n_2_8_4 2.828625106073436
R1376 n_2_8_4 n_3_8_4 3.956118996028932
R1377 n_2_8_4 n_2_9_4 13056.455737006763
R1378 n_2_8_15 n_3_8_15 174.06923582527145
R1379 n_2_8_15 n_2_9_15 574484.0524282925
R1380 n_2_9_0 n_3_9_0 2.486703368932474
R1381 n_2_9_0 n_2_10_0 4174.886102131101
R1382 n_2_9_0 n_2_9_1 71.803560384941
R1383 n_2_9_1 n_3_9_1 3.481384716505463
R1384 n_2_9_1 n_2_10_1 5844.840542983541
R1385 n_2_9_1 n_2_9_2 315.5004926004984
R1386 n_2_9_2 n_3_9_2 12.433516844662368
R1387 n_2_9_2 n_2_10_2 20874.430510655508
R1388 n_2_9_2 n_2_9_3 305.05633836268873
R1389 n_2_9_3 n_3_9_3 87.0346179126365
R1390 n_2_9_3 n_2_10_3 146121.01357458843
R1391 n_2_9_3 n_2_9_4 2.828625106073436
R1392 n_2_9_4 n_3_9_4 3.956118996028932
R1393 n_2_9_4 n_2_10_4 6641.864253390381
R1394 n_2_9_15 n_3_9_15 174.06923582527145
R1395 n_2_9_15 n_2_10_15 292242.0271491742
R1396 n_2_10_0 n_3_10_0 142.85711614206238
R1397 n_2_10_0 n_2_11_0 142.8571695722258
R1398 n_2_10_0 n_2_10_1 4124.999263474137
R1399 n_2_10_1 n_3_10_1 199.9999625988873
R1400 n_2_10_1 n_2_11_1 200.00003740111615
R1401 n_2_10_1 n_2_10_2 18124.99676374999
R1402 n_2_10_2 n_3_10_2 714.2855807103119
R1403 n_2_10_2 n_2_11_2 714.2858478611292
R1404 n_2_10_2 n_2_10_3 17524.996870881027
R1405 n_2_10_3 n_3_10_3 4999.999064972178
R1406 n_2_10_3 n_2_11_3 5000.0009350279
R1407 n_2_10_3 n_2_10_4 162.4999709853449
R1408 n_2_10_4 n_3_10_4 227.27268477146268
R1409 n_2_10_4 n_2_11_4 227.2727697739954
R1410 n_2_10_15 n_3_10_15 9999.998129944266
R1411 n_2_10_15 n_2_11_15 10000.001870055708
R1412 n_2_11_0 n_3_11_0 142.85711614206744
R1413 n_2_11_0 n_2_12_0 1646.6785783889486
R1414 n_2_11_0 n_2_11_1 4124.999263474283
R1415 n_2_11_1 n_3_11_1 199.9999625988944
R1416 n_2_11_1 n_2_12_1 2305.3500097445276
R1417 n_2_11_1 n_2_11_2 18124.996763750634
R1418 n_2_11_2 n_3_11_2 714.2855807103372
R1419 n_2_11_2 n_2_12_2 8233.392891944743
R1420 n_2_11_2 n_2_11_3 17524.99687088165
R1421 n_2_11_3 n_3_11_3 4999.999064972356
R1422 n_2_11_3 n_2_12_3 57633.75024361315
R1423 n_2_11_3 n_2_11_4 162.49997098535067
R1424 n_2_11_4 n_3_11_4 227.27268477147072
R1425 n_2_11_4 n_2_12_4 2619.7159201642335
R1426 n_2_11_15 n_3_11_15 9999.998129944623
R1427 n_2_11_15 n_2_12_15 115267.50048722525
R1428 n_2_12_0 n_3_12_0 6.477753800407753
R1429 n_2_12_0 n_2_13_0 3150.499987205676
R1430 n_2_12_0 n_2_12_1 187.04514256802355
R1431 n_2_12_1 n_3_12_1 9.068855320570853
R1432 n_2_12_1 n_2_13_1 4410.699982087946
R1433 n_2_12_1 n_2_12_2 821.865020374649
R1434 n_2_12_2 n_3_12_2 32.388769002038764
R1435 n_2_12_2 n_2_13_2 15752.49993602838
R1436 n_2_12_2 n_2_12_3 794.6584541829366
R1437 n_2_12_3 n_3_12_3 226.72138301427108
R1438 n_2_12_3 n_2_13_3 110267.49955219857
R1439 n_2_12_3 n_2_12_4 7.36844501025548
R1440 n_2_12_4 n_3_12_4 10.305517409739597
R1441 n_2_12_4 n_2_13_4 5012.1590705544795
R1442 n_2_12_4 n_2_12_5 6.450763214106447
R1443 n_2_12_5 n_3_12_5 43.18502533605164
R1444 n_2_12_5 n_2_13_5 21003.333248037823
R1445 n_2_12_5 n_2_12_6 1.5114758995395858
R1446 n_2_12_6 n_3_12_6 7.197504222675273
R1447 n_2_12_6 n_2_13_6 3500.5555413396373
R1448 n_2_12_6 n_2_12_7 2.051288720803721
R1449 n_2_12_7 n_3_12_7 12.338578667443365
R1450 n_2_12_7 n_2_13_7 6000.952356582254
R1451 n_2_12_7 n_2_12_8 1.5114758995395812
R1452 n_2_12_8 n_3_12_8 12.338578667443365
R1453 n_2_12_8 n_2_13_8 6000.952356582254
R1454 n_2_12_8 n_2_12_9 1.5114758995395812
R1455 n_2_12_9 n_3_12_9 12.338578667443365
R1456 n_2_12_9 n_2_13_9 6000.952356582254
R1457 n_2_12_9 n_2_12_10 1.5114758995395812
R1458 n_2_12_10 n_3_12_10 12.338578667443365
R1459 n_2_12_10 n_2_13_10 6000.952356582254
R1460 n_2_12_10 n_2_12_11 1.5114758995395716
R1461 n_2_12_11 n_3_12_11 12.338578667443524
R1462 n_2_12_11 n_2_13_11 6000.952356582329
R1463 n_2_12_11 n_2_12_12 1.5114758995395667
R1464 n_2_12_12 n_3_12_12 12.338578667443443
R1465 n_2_12_12 n_2_13_12 6000.952356582293
R1466 n_2_12_12 n_2_12_13 1.511475899539581
R1467 n_2_12_13 n_3_12_13 12.338578667443288
R1468 n_2_12_13 n_2_13_13 6000.952356582215
R1469 n_2_12_13 n_2_12_14 7.557379497697925
R1470 n_2_12_14 n_3_12_14 1.370953185271482
R1471 n_2_12_14 n_2_13_14 666.7724840646936
R1472 n_2_12_14 n_2_12_15 233.52302647886805
R1473 n_2_12_15 n_3_12_15 453.44276602853824
R1474 n_2_12_15 n_2_13_15 220534.99910439513
R1475 n_2_13_0 n_3_13_0 6.477753800407742
R1476 n_2_13_0 n_2_13_1 187.04514256802332
R1477 n_2_13_1 n_3_13_1 9.068855320570838
R1478 n_2_13_1 n_2_13_2 821.8650203746478
R1479 n_2_13_2 n_3_13_2 32.388769002038714
R1480 n_2_13_2 n_2_13_3 794.6584541829353
R1481 n_2_13_3 n_3_13_3 226.72138301427077
R1482 n_2_13_3 n_2_13_4 7.368445010255471
R1483 n_2_13_4 n_3_13_4 10.30551740973958
R1484 n_2_13_4 n_2_13_5 6.450763214106437
R1485 n_2_13_5 n_3_13_5 43.185025336051574
R1486 n_2_13_5 n_2_13_6 1.5114758995395834
R1487 n_2_13_6 n_3_13_6 7.197504222675262
R1488 n_2_13_6 n_2_13_7 2.051288720803718
R1489 n_2_13_7 n_3_13_7 12.338578667443345
R1490 n_2_13_7 n_2_13_8 1.5114758995395787
R1491 n_2_13_8 n_3_13_8 12.338578667443345
R1492 n_2_13_8 n_2_13_9 1.5114758995395787
R1493 n_2_13_9 n_3_13_9 12.338578667443345
R1494 n_2_13_9 n_2_13_10 1.5114758995395787
R1495 n_2_13_10 n_3_13_10 12.338578667443345
R1496 n_2_13_10 n_2_13_11 1.511475899539569
R1497 n_2_13_11 n_3_13_11 12.338578667443501
R1498 n_2_13_11 n_2_13_12 1.511475899539564
R1499 n_2_13_12 n_3_13_12 12.338578667443425
R1500 n_2_13_12 n_2_13_13 1.5114758995395787
R1501 n_2_13_13 n_3_13_13 12.338578667443267
R1502 n_2_13_13 n_2_13_14 7.557379497697912
R1503 n_2_13_14 n_3_13_14 1.3709531852714798
R1504 n_2_13_14 n_2_13_15 233.52302647886765
R1505 n_2_13_15 n_3_13_15 453.44276602853745
R1506 n_3_0_0 n_4_0_0 125.67181420979054
R1507 n_3_0_0 n_3_1_0 3150.5002585262537
R1508 n_3_0_0 n_3_0_1 187.04512645972574
R1509 n_3_0_1 n_4_0_1 175.94053989370673
R1510 n_3_0_1 n_3_1_1 4410.700361936755
R1511 n_3_0_1 n_3_0_2 821.8649495957645
R1512 n_3_0_2 n_4_0_2 628.3590710489526
R1513 n_3_0_2 n_3_1_2 15752.501292631268
R1514 n_3_0_2 n_3_0_3 794.6583857470772
R1515 n_3_0_3 n_4_0_3 4398.513497342664
R1516 n_3_0_3 n_3_1_3 110267.50904841878
R1517 n_3_0_3 n_3_0_4 7.368444375686172
R1518 n_3_0_4 n_4_0_4 199.93243169739387
R1519 n_3_0_4 n_3_1_4 5012.159502200853
R1520 n_3_0_4 n_3_0_5 6.450762658567747
R1521 n_3_0_5 n_4_0_5 837.812094731936
R1522 n_3_0_5 n_3_1_5 21003.33505684167
R1523 n_3_0_5 n_3_0_6 1.5114757693715226
R1524 n_3_0_6 n_4_0_6 139.63534912198935
R1525 n_3_0_6 n_3_1_6 3500.5558428069457
R1526 n_3_0_6 n_3_0_7 2.051288544147064
R1527 n_3_0_7 n_4_0_7 239.37488420912533
R1528 n_3_0_7 n_3_1_7 6000.952873383354
R1529 n_3_0_7 n_3_0_8 1.511475769371518
R1530 n_3_0_8 n_4_0_8 239.37488420912533
R1531 n_3_0_8 n_3_1_8 6000.952873383354
R1532 n_3_0_8 n_3_0_9 1.511475769371518
R1533 n_3_0_9 n_4_0_9 239.37488420912533
R1534 n_3_0_9 n_3_1_9 6000.952873383354
R1535 n_3_0_9 n_3_0_10 1.511475769371518
R1536 n_3_0_10 n_4_0_10 239.37488420912533
R1537 n_3_0_10 n_3_1_10 6000.952873383354
R1538 n_3_0_10 n_3_0_11 1.5114757693715082
R1539 n_3_0_11 n_4_0_11 239.3748842091284
R1540 n_3_0_11 n_3_1_11 6000.9528733834295
R1541 n_3_0_11 n_3_0_12 1.5114757693715033
R1542 n_3_0_12 n_4_0_12 239.37488420912695
R1543 n_3_0_12 n_3_1_12 6000.952873383392
R1544 n_3_0_12 n_3_0_13 1.511475769371518
R1545 n_3_0_13 n_4_0_13 239.37488420912385
R1546 n_3_0_13 n_3_1_13 6000.952873383315
R1547 n_3_0_13 n_3_0_14 7.557378846857608
R1548 n_3_0_14 n_4_0_14 26.597209356569426
R1549 n_3_0_14 n_3_1_14 666.772541487038
R1550 n_3_0_14 n_3_0_15 233.5230063679022
R1551 n_3_0_15 n_4_0_15 8797.02699468525
R1552 n_3_0_15 n_3_1_15 220535.01809683556
R1553 n_3_1_0 n_4_1_0 125.67181420979054
R1554 n_3_1_0 n_3_2_0 1646.6785783889504
R1555 n_3_1_0 n_3_1_1 187.04512645972574
R1556 n_3_1_1 n_4_1_1 175.94053989370673
R1557 n_3_1_1 n_3_2_1 2305.350009744531
R1558 n_3_1_1 n_3_1_2 821.8649495957645
R1559 n_3_1_2 n_4_1_2 628.3590710489526
R1560 n_3_1_2 n_3_2_2 8233.392891944752
R1561 n_3_1_2 n_3_1_3 794.6583857470772
R1562 n_3_1_3 n_4_1_3 4398.513497342664
R1563 n_3_1_3 n_3_2_3 57633.75024361321
R1564 n_3_1_3 n_3_1_4 7.368444375686172
R1565 n_3_1_4 n_4_1_4 199.93243169739387
R1566 n_3_1_4 n_3_2_4 2619.7159201642366
R1567 n_3_1_4 n_3_1_5 6.450762658567747
R1568 n_3_1_5 n_4_1_5 837.812094731936
R1569 n_3_1_5 n_3_1_6 1.5114757693715226
R1570 n_3_1_6 n_4_1_6 139.63534912198935
R1571 n_3_1_6 n_3_1_7 2.051288544147064
R1572 n_3_1_7 n_4_1_7 239.37488420912533
R1573 n_3_1_7 n_3_1_8 1.511475769371518
R1574 n_3_1_8 n_4_1_8 239.37488420912533
R1575 n_3_1_8 n_3_1_9 1.511475769371518
R1576 n_3_1_9 n_4_1_9 239.37488420912533
R1577 n_3_1_9 n_3_1_10 1.511475769371518
R1578 n_3_1_10 n_4_1_10 239.37488420912533
R1579 n_3_1_10 n_3_1_11 1.5114757693715082
R1580 n_3_1_11 n_4_1_11 239.3748842091284
R1581 n_3_1_11 n_3_1_12 1.5114757693715033
R1582 n_3_1_12 n_4_1_12 239.37488420912695
R1583 n_3_1_12 n_3_1_13 1.511475769371518
R1584 n_3_1_13 n_4_1_13 239.37488420912385
R1585 n_3_1_13 n_3_1_14 7.557378846857608
R1586 n_3_1_14 n_4_1_14 26.597209356569426
R1587 n_3_1_14 n_3_1_15 233.5230063679022
R1588 n_3_1_15 n_4_1_15 8797.02699468525
R1589 n_3_1_15 n_3_2_15 115267.50048722538
R1590 n_3_2_0 n_4_2_0 2771.5083275850347
R1591 n_3_2_0 n_3_3_0 142.85689825164727
R1592 n_3_2_0 n_3_2_1 4125.007097867931
R1593 n_3_2_1 n_4_2_1 3880.1116586190483
R1594 n_3_2_1 n_3_3_1 199.99965755230616
R1595 n_3_2_1 n_3_2_2 18125.031187601515
R1596 n_3_2_2 n_4_2_2 13857.541637925176
R1597 n_3_2_2 n_3_3_2 714.2844912582364
R1598 n_3_2_2 n_3_2_3 17525.030155184362
R1599 n_3_2_3 n_4_2_3 97002.79146547614
R1600 n_3_2_3 n_3_3_3 4999.9914388076495
R1601 n_3_2_3 n_3_2_4 162.50027961297926
R1602 n_3_2_4 n_4_2_4 4409.217793885278
R1603 n_3_2_4 n_3_3_4 227.2723381276204
R1604 n_3_2_15 n_4_2_15 194005.5829309505
R1605 n_3_2_15 n_3_3_15 9999.982877615208
R1606 n_3_3_0 n_4_3_0 2771.5083275850347
R1607 n_3_3_0 n_3_4_0 4174.8859664708125
R1608 n_3_3_0 n_3_3_1 4125.007097867931
R1609 n_3_3_1 n_4_3_1 3880.1116586190483
R1610 n_3_3_1 n_3_4_1 5844.840353059136
R1611 n_3_3_1 n_3_3_2 18125.031187601515
R1612 n_3_3_2 n_4_3_2 13857.541637925176
R1613 n_3_3_2 n_3_4_2 20874.42983235406
R1614 n_3_3_2 n_3_3_3 17525.030155184362
R1615 n_3_3_3 n_4_3_3 97002.79146547614
R1616 n_3_3_3 n_3_4_3 146121.00882647827
R1617 n_3_3_3 n_3_3_4 162.50027961297926
R1618 n_3_3_4 n_4_3_4 4409.217793885278
R1619 n_3_3_4 n_3_4_4 6641.864037567194
R1620 n_3_3_15 n_4_3_15 194005.5829309505
R1621 n_3_3_15 n_3_4_15 292242.0176529539
R1622 n_3_4_0 n_4_4_0 48.24335106234773
R1623 n_3_4_0 n_3_5_0 8206.915034689977
R1624 n_3_4_0 n_3_4_1 71.803560384941
R1625 n_3_4_1 n_4_4_1 67.54069148728684
R1626 n_3_4_1 n_3_5_1 11489.681048565964
R1627 n_3_4_1 n_3_4_2 315.5004926004983
R1628 n_3_4_2 n_4_4_2 241.21675531173872
R1629 n_3_4_2 n_3_5_2 41034.57517344988
R1630 n_3_4_2 n_3_4_3 305.0563383626887
R1631 n_3_4_3 n_4_4_3 1688.5172871821694
R1632 n_3_4_3 n_3_5_3 287242.02621414885
R1633 n_3_4_3 n_3_4_4 2.828625106073435
R1634 n_3_4_4 n_4_4_4 76.75078578100769
R1635 n_3_4_4 n_3_5_4 13056.455737006765
R1636 n_3_4_15 n_4_4_15 3377.0345743643093
R1637 n_3_4_15 n_3_5_15 574484.0524282926
R1638 n_3_5_0 n_4_5_0 48.24335106234776
R1639 n_3_5_0 n_3_6_0 4174.886089075483
R1640 n_3_5_0 n_3_5_1 71.803560384941
R1641 n_3_5_1 n_4_5_1 67.54069148728686
R1642 n_3_5_1 n_3_6_1 5844.840524705674
R1643 n_3_5_1 n_3_5_2 315.5004926004984
R1644 n_3_5_2 n_4_5_2 241.2167553117388
R1645 n_3_5_2 n_3_6_2 20874.430445377413
R1646 n_3_5_2 n_3_5_3 305.05633836268873
R1647 n_3_5_3 n_4_5_3 1688.51728718217
R1648 n_3_5_3 n_3_6_3 146121.01311764176
R1649 n_3_5_3 n_3_5_4 2.828625106073436
R1650 n_3_5_4 n_4_5_4 76.75078578100772
R1651 n_3_5_4 n_3_6_4 6641.864232620079
R1652 n_3_5_15 n_4_5_15 3377.0345743643106
R1653 n_3_5_15 n_3_6_15 292242.02623528085
R1654 n_3_6_0 n_4_6_0 2771.5035703868944
R1655 n_3_6_0 n_3_7_0 142.85714346099064
R1656 n_3_6_0 n_3_6_1 4125.0000174359875
R1657 n_3_6_1 n_4_6_1 3880.1049985416516
R1658 n_3_6_1 n_3_7_1 200.0000008453869
R1659 n_3_6_1 n_3_6_2 18125.000076612672
R1660 n_3_6_2 n_4_6_2 13857.517851934472
R1661 n_3_6_2 n_3_7_2 714.2857173049533
R1662 n_3_6_2 n_3_6_3 17525.000074076528
R1663 n_3_6_3 n_4_6_3 97002.62496354121
R1664 n_3_6_3 n_3_7_3 5000.000021134669
R1665 n_3_6_3 n_3_6_4 162.5000006868724
R1666 n_3_6_4 n_4_6_4 4409.210225615509
R1667 n_3_6_4 n_3_7_4 227.272728233394
R1668 n_3_6_15 n_4_6_15 194005.24992708073
R1669 n_3_6_15 n_3_7_15 10000.000042269246
R1670 n_3_7_0 n_4_7_0 2771.5035703868944
R1671 n_3_7_0 n_3_8_0 4174.886089075483
R1672 n_3_7_0 n_3_7_1 4125.0000174359875
R1673 n_3_7_1 n_4_7_1 3880.1049985416516
R1674 n_3_7_1 n_3_8_1 5844.840524705674
R1675 n_3_7_1 n_3_7_2 18125.000076612672
R1676 n_3_7_2 n_4_7_2 13857.517851934472
R1677 n_3_7_2 n_3_8_2 20874.430445377413
R1678 n_3_7_2 n_3_7_3 17525.000074076528
R1679 n_3_7_3 n_4_7_3 97002.62496354121
R1680 n_3_7_3 n_3_8_3 146121.01311764176
R1681 n_3_7_3 n_3_7_4 162.5000006868724
R1682 n_3_7_4 n_4_7_4 4409.210225615509
R1683 n_3_7_4 n_3_8_4 6641.864232620079
R1684 n_3_7_15 n_4_7_15 194005.24992708073
R1685 n_3_7_15 n_3_8_15 292242.02623528085
R1686 n_3_8_0 n_4_8_0 48.24335106234776
R1687 n_3_8_0 n_3_9_0 8206.915034689975
R1688 n_3_8_0 n_3_8_1 71.803560384941
R1689 n_3_8_1 n_4_8_1 67.54069148728686
R1690 n_3_8_1 n_3_9_1 11489.681048565963
R1691 n_3_8_1 n_3_8_2 315.5004926004984
R1692 n_3_8_2 n_4_8_2 241.2167553117388
R1693 n_3_8_2 n_3_9_2 41034.57517344987
R1694 n_3_8_2 n_3_8_3 305.05633836268873
R1695 n_3_8_3 n_4_8_3 1688.51728718217
R1696 n_3_8_3 n_3_9_3 287242.02621414885
R1697 n_3_8_3 n_3_8_4 2.828625106073436
R1698 n_3_8_4 n_4_8_4 76.75078578100772
R1699 n_3_8_4 n_3_9_4 13056.455737006763
R1700 n_3_8_15 n_4_8_15 3377.0345743643106
R1701 n_3_8_15 n_3_9_15 574484.0524282925
R1702 n_3_9_0 n_4_9_0 48.24335106234776
R1703 n_3_9_0 n_3_10_0 4174.886102131101
R1704 n_3_9_0 n_3_9_1 71.803560384941
R1705 n_3_9_1 n_4_9_1 67.54069148728686
R1706 n_3_9_1 n_3_10_1 5844.840542983541
R1707 n_3_9_1 n_3_9_2 315.5004926004984
R1708 n_3_9_2 n_4_9_2 241.2167553117388
R1709 n_3_9_2 n_3_10_2 20874.430510655508
R1710 n_3_9_2 n_3_9_3 305.05633836268873
R1711 n_3_9_3 n_4_9_3 1688.51728718217
R1712 n_3_9_3 n_3_10_3 146121.01357458843
R1713 n_3_9_3 n_3_9_4 2.828625106073436
R1714 n_3_9_4 n_4_9_4 76.75078578100772
R1715 n_3_9_4 n_3_10_4 6641.864253390381
R1716 n_3_9_15 n_4_9_15 3377.0345743643106
R1717 n_3_9_15 n_3_10_15 292242.0271491742
R1718 n_3_10_0 n_4_10_0 2771.503063815269
R1719 n_3_10_0 n_3_11_0 142.8571695722258
R1720 n_3_10_0 n_3_10_1 4124.999263474137
R1721 n_3_10_1 n_4_10_1 3880.104289341376
R1722 n_3_10_1 n_3_11_1 200.00003740111615
R1723 n_3_10_1 n_3_10_2 18124.99676374999
R1724 n_3_10_2 n_4_10_2 13857.515319076347
R1725 n_3_10_2 n_3_11_2 714.2858478611292
R1726 n_3_10_2 n_3_10_3 17524.996870881027
R1727 n_3_10_3 n_4_10_3 97002.60723353432
R1728 n_3_10_3 n_3_11_3 5000.0009350279
R1729 n_3_10_3 n_3_10_4 162.4999709853449
R1730 n_3_10_4 n_4_10_4 4409.209419706106
R1731 n_3_10_4 n_3_11_4 227.2727697739954
R1732 n_3_10_15 n_4_10_15 194005.2144670669
R1733 n_3_10_15 n_3_11_15 10000.001870055708
R1734 n_3_11_0 n_4_11_0 2771.5030638153676
R1735 n_3_11_0 n_3_12_0 1646.6785783889486
R1736 n_3_11_0 n_3_11_1 4124.999263474283
R1737 n_3_11_1 n_4_11_1 3880.1042893415142
R1738 n_3_11_1 n_3_12_1 2305.3500097445276
R1739 n_3_11_1 n_3_11_2 18124.996763750634
R1740 n_3_11_2 n_4_11_2 13857.515319076836
R1741 n_3_11_2 n_3_12_2 8233.392891944743
R1742 n_3_11_2 n_3_11_3 17524.99687088165
R1743 n_3_11_3 n_4_11_3 97002.60723353777
R1744 n_3_11_3 n_3_12_3 57633.75024361315
R1745 n_3_11_3 n_3_11_4 162.49997098535067
R1746 n_3_11_4 n_4_11_4 4409.209419706262
R1747 n_3_11_4 n_3_12_4 2619.7159201642335
R1748 n_3_11_15 n_4_11_15 194005.2144670738
R1749 n_3_11_15 n_3_12_15 115267.50048722525
R1750 n_3_12_0 n_4_12_0 125.67182503262808
R1751 n_3_12_0 n_3_13_0 3150.499987205676
R1752 n_3_12_0 n_3_12_1 187.04514256802355
R1753 n_3_12_1 n_4_12_1 175.94055504567928
R1754 n_3_12_1 n_3_13_1 4410.699982087946
R1755 n_3_12_1 n_3_12_2 821.865020374649
R1756 n_3_12_2 n_4_12_2 628.3591251631403
R1757 n_3_12_2 n_3_13_2 15752.49993602838
R1758 n_3_12_2 n_3_12_3 794.6584541829366
R1759 n_3_12_3 n_4_12_3 4398.513876141978
R1760 n_3_12_3 n_3_13_3 110267.49955219857
R1761 n_3_12_3 n_3_12_4 7.36844501025548
R1762 n_3_12_4 n_4_12_4 199.93244891554448
R1763 n_3_12_4 n_3_13_4 5012.1590705544795
R1764 n_3_12_4 n_3_12_5 6.450763214106447
R1765 n_3_12_5 n_4_12_5 837.8121668841862
R1766 n_3_12_5 n_3_13_5 21003.333248037823
R1767 n_3_12_5 n_3_12_6 1.5114758995395858
R1768 n_3_12_6 n_4_12_6 139.63536114736436
R1769 n_3_12_6 n_3_13_6 3500.5555413396373
R1770 n_3_12_6 n_3_12_7 2.051288720803721
R1771 n_3_12_7 n_4_12_7 239.37490482405397
R1772 n_3_12_7 n_3_13_7 6000.952356582254
R1773 n_3_12_7 n_3_12_8 1.5114758995395812
R1774 n_3_12_8 n_4_12_8 239.37490482405397
R1775 n_3_12_8 n_3_13_8 6000.952356582254
R1776 n_3_12_8 n_3_12_9 1.5114758995395812
R1777 n_3_12_9 n_4_12_9 239.37490482405397
R1778 n_3_12_9 n_3_13_9 6000.952356582254
R1779 n_3_12_9 n_3_12_10 1.5114758995395812
R1780 n_3_12_10 n_4_12_10 239.37490482405397
R1781 n_3_12_10 n_3_13_10 6000.952356582254
R1782 n_3_12_10 n_3_12_11 1.5114758995395716
R1783 n_3_12_11 n_4_12_11 239.37490482405707
R1784 n_3_12_11 n_3_13_11 6000.952356582329
R1785 n_3_12_11 n_3_12_12 1.5114758995395667
R1786 n_3_12_12 n_4_12_12 239.37490482405548
R1787 n_3_12_12 n_3_13_12 6000.952356582293
R1788 n_3_12_12 n_3_12_13 1.511475899539581
R1789 n_3_12_13 n_4_12_13 239.3749048240525
R1790 n_3_12_13 n_3_13_13 6000.952356582215
R1791 n_3_12_13 n_3_12_14 7.557379497697925
R1792 n_3_12_14 n_4_12_14 26.597211647117053
R1793 n_3_12_14 n_3_13_14 666.7724840646936
R1794 n_3_12_14 n_3_12_15 233.52302647886805
R1795 n_3_12_15 n_4_12_15 8797.027752283877
R1796 n_3_12_15 n_3_13_15 220534.99910439513
R1797 n_3_13_0 n_4_13_0 125.67182503262786
R1798 n_3_13_0 n_3_13_1 187.04514256802332
R1799 n_3_13_1 n_4_13_1 175.940555045679
R1800 n_3_13_1 n_3_13_2 821.8650203746478
R1801 n_3_13_2 n_4_13_2 628.3591251631394
R1802 n_3_13_2 n_3_13_3 794.6584541829353
R1803 n_3_13_3 n_4_13_3 4398.513876141971
R1804 n_3_13_3 n_3_13_4 7.368445010255471
R1805 n_3_13_4 n_4_13_4 199.93244891554414
R1806 n_3_13_4 n_3_13_5 6.450763214106437
R1807 n_3_13_5 n_4_13_5 837.812166884185
R1808 n_3_13_5 n_3_13_6 1.5114758995395834
R1809 n_3_13_6 n_4_13_6 139.63536114736416
R1810 n_3_13_6 n_3_13_7 2.051288720803718
R1811 n_3_13_7 n_4_13_7 239.37490482405357
R1812 n_3_13_7 n_3_13_8 1.5114758995395787
R1813 n_3_13_8 n_4_13_8 239.37490482405357
R1814 n_3_13_8 n_3_13_9 1.5114758995395787
R1815 n_3_13_9 n_4_13_9 239.37490482405357
R1816 n_3_13_9 n_3_13_10 1.5114758995395787
R1817 n_3_13_10 n_4_13_10 239.37490482405357
R1818 n_3_13_10 n_3_13_11 1.511475899539569
R1819 n_3_13_11 n_4_13_11 239.37490482405664
R1820 n_3_13_11 n_3_13_12 1.511475899539564
R1821 n_3_13_12 n_4_13_12 239.3749048240551
R1822 n_3_13_12 n_3_13_13 1.5114758995395787
R1823 n_3_13_13 n_4_13_13 239.37490482405207
R1824 n_3_13_13 n_3_13_14 7.557379497697912
R1825 n_3_13_14 n_4_13_14 26.597211647117007
R1826 n_3_13_14 n_3_13_15 233.52302647886765
R1827 n_3_13_15 n_4_13_15 8797.027752283862
R1828 n_4_0_0 n_5_0_0 244.8658751770365
R1829 n_4_0_0 n_4_1_0 83.34425223829642
R1830 n_4_0_0 n_4_0_1 4.948146300707097
R1831 n_4_0_1 n_5_0_1 342.81222524785096
R1832 n_4_0_1 n_4_1_1 116.68195313361498
R1833 n_4_0_1 n_4_0_2 21.741854957652393
R1834 n_4_0_2 n_5_0_2 1224.3293758851823
R1835 n_4_0_2 n_4_1_2 416.7212611914821
R1836 n_4_0_2 n_4_0_3 21.02212458664045
R1837 n_4_0_3 n_5_0_3 8570.305631196268
R1838 n_4_0_3 n_4_1_3 2917.048828340372
R1839 n_4_0_3 n_4_0_4 0.19492697548240095
R1840 n_4_0_4 n_5_0_4 389.5593468725576
R1841 n_4_0_4 n_4_1_4 132.59312856092598
R1842 n_4_0_4 n_4_0_5 0.17065035582525212
R1843 n_4_0_5 n_5_0_5 1632.439167846908
R1844 n_4_0_5 n_4_1_5 555.6283482553089
R1845 n_4_0_5 n_4_0_6 0.03998502061177455
R1846 n_4_0_6 n_5_0_6 272.0731946411514
R1847 n_4_0_6 n_4_1_6 92.60472470921815
R1848 n_4_0_6 n_4_0_7 0.054265385115979684
R1849 n_4_0_7 n_5_0_7 466.4111908134038
R1850 n_4_0_7 n_4_1_7 158.75095664437444
R1851 n_4_0_7 n_4_0_8 0.039985020611774426
R1852 n_4_0_8 n_5_0_8 466.4111908134038
R1853 n_4_0_8 n_4_1_8 158.75095664437444
R1854 n_4_0_8 n_4_0_9 0.039985020611774426
R1855 n_4_0_9 n_5_0_9 466.4111908134038
R1856 n_4_0_9 n_4_1_9 158.75095664437444
R1857 n_4_0_9 n_4_0_10 0.039985020611774426
R1858 n_4_0_10 n_5_0_10 466.4111908134038
R1859 n_4_0_10 n_4_1_10 158.75095664437444
R1860 n_4_0_10 n_4_0_11 0.03998502061177417
R1861 n_4_0_11 n_5_0_11 466.41119081340975
R1862 n_4_0_11 n_4_1_11 158.7509566443765
R1863 n_4_0_11 n_4_0_12 0.039985020611774044
R1864 n_4_0_12 n_5_0_12 466.4111908134069
R1865 n_4_0_12 n_4_1_12 158.7509566443755
R1866 n_4_0_12 n_4_0_13 0.03998502061177442
R1867 n_4_0_13 n_5_0_13 466.4111908134009
R1868 n_4_0_13 n_4_1_13 158.75095664437345
R1869 n_4_0_13 n_4_0_14 0.19992510305887262
R1870 n_4_0_14 n_5_0_14 51.823465645933645
R1871 n_4_0_14 n_4_1_14 17.638995182708236
R1872 n_4_0_14 n_4_0_15 6.177685684519221
R1873 n_4_0_15 n_5_0_15 17140.611262392384
R1874 n_4_0_15 n_4_1_15 5834.097656680692
R1875 n_4_1_0 n_5_1_0 244.8658751770365
R1876 n_4_1_0 n_4_2_0 43.56171513435996
R1877 n_4_1_0 n_4_1_1 4.948146300707097
R1878 n_4_1_1 n_5_1_1 342.81222524785096
R1879 n_4_1_1 n_4_2_1 60.98640118810393
R1880 n_4_1_1 n_4_1_2 21.741854957652393
R1881 n_4_1_2 n_5_1_2 1224.3293758851823
R1882 n_4_1_2 n_4_2_2 217.80857567179976
R1883 n_4_1_2 n_4_1_3 21.02212458664045
R1884 n_4_1_3 n_5_1_3 8570.305631196268
R1885 n_4_1_3 n_4_2_3 1524.660029702597
R1886 n_4_1_3 n_4_1_4 0.19492697548240095
R1887 n_4_1_4 n_5_1_4 389.5593468725576
R1888 n_4_1_4 n_4_2_4 69.30272862284531
R1889 n_4_1_4 n_4_1_5 0.17065035582525212
R1890 n_4_1_5 n_5_1_5 1632.439167846908
R1891 n_4_1_5 n_4_1_6 0.03998502061177455
R1892 n_4_1_6 n_5_1_6 272.0731946411514
R1893 n_4_1_6 n_4_1_7 0.054265385115979684
R1894 n_4_1_7 n_5_1_7 466.4111908134038
R1895 n_4_1_7 n_4_1_8 0.039985020611774426
R1896 n_4_1_8 n_5_1_8 466.4111908134038
R1897 n_4_1_8 n_4_1_9 0.039985020611774426
R1898 n_4_1_9 n_5_1_9 466.4111908134038
R1899 n_4_1_9 n_4_1_10 0.039985020611774426
R1900 n_4_1_10 n_5_1_10 466.4111908134038
R1901 n_4_1_10 n_4_1_11 0.03998502061177417
R1902 n_4_1_11 n_5_1_11 466.41119081340975
R1903 n_4_1_11 n_4_1_12 0.039985020611774044
R1904 n_4_1_12 n_5_1_12 466.4111908134069
R1905 n_4_1_12 n_4_1_13 0.03998502061177442
R1906 n_4_1_13 n_5_1_13 466.4111908134009
R1907 n_4_1_13 n_4_1_14 0.19992510305887262
R1908 n_4_1_14 n_5_1_14 51.823465645933645
R1909 n_4_1_14 n_4_1_15 6.177685684519221
R1910 n_4_1_15 n_5_1_15 17140.611262392384
R1911 n_4_1_15 n_4_2_15 3049.320059405167
R1912 n_4_2_0 n_5_2_0 5400.159267707013
R1913 n_4_2_0 n_4_3_0 3.7791780304234877
R1914 n_4_2_0 n_4_2_1 109.12414024377487
R1915 n_4_2_1 n_5_2_1 7560.222974789817
R1916 n_4_2_1 n_4_3_1 5.290849242592883
R1917 n_4_2_1 n_4_2_2 479.48485864688956
R1918 n_4_2_2 n_5_2_2 27000.79633853507
R1919 n_4_2_2 n_4_3_2 18.89589015211744
R1920 n_4_2_2 n_4_2_3 463.61225642961324
R1921 n_4_2_3 n_5_2_3 189005.57436974527
R1922 n_4_2_3 n_4_3_3 132.27123106482196
R1923 n_4_2_3 n_4_2_4 4.298829767179014
R1924 n_4_2_4 n_5_2_4 8591.162471352058
R1925 n_4_2_4 n_4_3_4 6.012328684764634
R1926 n_4_2_15 n_5_2_15 378011.14873948717
R1927 n_4_2_15 n_4_3_15 264.54246212964154
R1928 n_4_3_0 n_5_3_0 5400.159267707013
R1929 n_4_3_0 n_4_4_0 110.4436503739356
R1930 n_4_3_0 n_4_3_1 109.12414024377487
R1931 n_4_3_1 n_5_3_1 7560.222974789817
R1932 n_4_3_1 n_4_4_1 154.62111052350983
R1933 n_4_3_1 n_4_3_2 479.48485864688956
R1934 n_4_3_2 n_5_3_2 27000.79633853507
R1935 n_4_3_2 n_4_4_2 552.218251869678
R1936 n_4_3_2 n_4_3_3 463.61225642961324
R1937 n_4_3_3 n_5_3_3 189005.57436974527
R1938 n_4_3_3 n_4_4_3 3865.5277630877426
R1939 n_4_3_3 n_4_3_4 4.298829767179014
R1940 n_4_3_4 n_5_3_4 8591.162471352058
R1941 n_4_3_4 n_4_4_4 175.70580741307916
R1942 n_4_3_15 n_5_3_15 378011.14873948717
R1943 n_4_3_15 n_4_4_15 7731.055526175416
R1944 n_4_4_0 n_5_4_0 93.999998755763
R1945 n_4_4_0 n_4_5_0 217.10812271744766
R1946 n_4_4_0 n_4_4_1 1.8995123178087499
R1947 n_4_4_1 n_5_4_1 131.59999825806824
R1948 n_4_4_1 n_4_5_1 303.95137180442674
R1949 n_4_4_1 n_4_4_2 8.34634200249299
R1950 n_4_4_2 n_5_4_2 469.9999937788151
R1951 n_4_4_2 n_4_5_2 1085.5406135872386
R1952 n_4_4_2 n_4_4_3 8.07004930172081
R1953 n_4_4_3 n_5_4_3 3289.999956451703
R1954 n_4_4_3 n_4_5_3 7598.784295110661
R1955 n_4_4_3 n_4_4_4 0.0748292731257993
R1956 n_4_4_4 n_5_4_4 149.54545256598647
R1957 n_4_4_4 n_4_5_4 345.39928614139365
R1958 n_4_4_4 n_4_4_5 0.0748292731257993
R1959 n_4_4_5 n_5_4_5 3289.999956451703
R1960 n_4_4_5 n_4_5_5 7598.784295110661
R1961 n_4_4_5 n_4_4_6 0.1496585462515986
R1962 n_4_4_6 n_5_4_6 1096.6666521505676
R1963 n_4_4_6 n_4_5_6 2532.92809837022
R1964 n_4_4_6 n_4_4_7 0.21873172144464387
R1965 n_4_4_7 n_5_4_7 1879.9999751152648
R1966 n_4_4_7 n_4_5_7 4342.162454348963
R1967 n_4_4_7 n_4_4_8 0.1611707421171057
R1968 n_4_4_8 n_5_4_8 1879.9999751152648
R1969 n_4_4_8 n_4_5_8 4342.162454348963
R1970 n_4_4_8 n_4_4_9 0.1611707421171057
R1971 n_4_4_9 n_5_4_9 1879.9999751152648
R1972 n_4_4_9 n_4_5_9 4342.162454348963
R1973 n_4_4_9 n_4_4_10 0.1611707421171057
R1974 n_4_4_10 n_5_4_10 1879.9999751152648
R1975 n_4_4_10 n_4_5_10 4342.162454348963
R1976 n_4_4_10 n_4_4_11 0.16117074211710467
R1977 n_4_4_11 n_5_4_11 1879.9999751152884
R1978 n_4_4_11 n_4_5_11 4342.162454349018
R1979 n_4_4_11 n_4_4_12 0.16117074211710414
R1980 n_4_4_12 n_5_4_12 1879.9999751152766
R1981 n_4_4_12 n_4_5_12 4342.162454348991
R1982 n_4_4_12 n_4_4_13 0.1611707421171057
R1983 n_4_4_13 n_5_4_13 1879.9999751152527
R1984 n_4_4_13 n_4_5_13 4342.162454348934
R1985 n_4_4_13 n_4_4_14 0.8058537105855305
R1986 n_4_4_14 n_5_4_14 208.8888861239179
R1987 n_4_4_14 n_4_5_14 482.4624949276615
R1988 n_4_4_14 n_4_4_15 3.0277075126285142
R1989 n_4_4_15 n_5_4_15 6579.999912903348
R1990 n_4_4_15 n_4_5_15 15197.568590221188
R1991 n_4_5_0 n_5_5_0 93.99999875576307
R1992 n_4_5_0 n_4_6_0 110.44365361735528
R1993 n_4_5_0 n_4_5_1 1.8995123178087503
R1994 n_4_5_1 n_5_5_1 131.5999982580683
R1995 n_4_5_1 n_4_6_1 154.6211150642974
R1996 n_4_5_1 n_4_5_2 8.346342002492994
R1997 n_4_5_2 n_5_5_2 469.9999937788153
R1998 n_4_5_2 n_4_6_2 552.2182680867766
R1999 n_4_5_2 n_4_5_3 8.070049301720813
R2000 n_4_5_3 n_5_5_3 3289.999956451704
R2001 n_4_5_3 n_4_6_3 3865.5278766074316
R2002 n_4_5_3 n_4_5_4 0.07482927312579932
R2003 n_4_5_4 n_5_5_4 149.54545256598655
R2004 n_4_5_4 n_4_6_4 175.70581257306506
R2005 n_4_5_4 n_4_5_5 0.07482927312579932
R2006 n_4_5_5 n_5_5_5 3289.999956451704
R2007 n_4_5_5 n_4_5_6 0.14965854625159863
R2008 n_4_5_6 n_5_5_6 1096.666652150568
R2009 n_4_5_6 n_4_5_7 0.21873172144464392
R2010 n_4_5_7 n_5_5_7 1879.9999751152654
R2011 n_4_5_7 n_4_5_8 0.16117074211710572
R2012 n_4_5_8 n_5_5_8 1879.9999751152654
R2013 n_4_5_8 n_4_5_9 0.16117074211710572
R2014 n_4_5_9 n_5_5_9 1879.9999751152654
R2015 n_4_5_9 n_4_5_10 0.16117074211710572
R2016 n_4_5_10 n_5_5_10 1879.9999751152654
R2017 n_4_5_10 n_4_5_11 0.1611707421171047
R2018 n_4_5_11 n_5_5_11 1879.9999751152895
R2019 n_4_5_11 n_4_5_12 0.1611707421171042
R2020 n_4_5_12 n_5_5_12 1879.9999751152773
R2021 n_4_5_12 n_4_5_13 0.16117074211710572
R2022 n_4_5_13 n_5_5_13 1879.9999751152532
R2023 n_4_5_13 n_4_5_14 0.8058537105855306
R2024 n_4_5_14 n_5_5_14 208.88888612391793
R2025 n_4_5_14 n_4_5_15 3.027707512628515
R2026 n_4_5_15 n_5_5_15 6579.9999129033495
R2027 n_4_5_15 n_4_6_15 7731.055753214794
R2028 n_4_6_0 n_5_6_0 5400.149998520494
R2029 n_4_6_0 n_4_7_0 3.779184517262938
R2030 n_4_6_0 n_4_6_1 109.12395293596421
R2031 n_4_6_1 n_5_6_1 7560.209997928691
R2032 n_4_6_1 n_4_7_1 5.290858324168114
R2033 n_4_6_1 n_4_6_2 479.4840356277216
R2034 n_4_6_2 n_5_6_2 27000.749992602472
R2035 n_4_6_2 n_4_7_2 18.895922586314693
R2036 n_4_6_2 n_4_6_3 463.6114606552177
R2037 n_4_6_3 n_5_6_3 189005.24994821713
R2038 n_4_6_3 n_4_7_3 132.27145810420274
R2039 n_4_6_3 n_4_6_4 4.298822388386473
R2040 n_4_6_4 n_5_6_4 8591.14772491896
R2041 n_4_6_4 n_4_7_4 6.012339004736487
R2042 n_4_6_15 n_5_6_15 378010.4998964309
R2043 n_4_6_15 n_4_7_15 264.5429162084031
R2044 n_4_7_0 n_5_7_0 5400.149998520494
R2045 n_4_7_0 n_4_8_0 110.44365361735528
R2046 n_4_7_0 n_4_7_1 109.12395293596421
R2047 n_4_7_1 n_5_7_1 7560.209997928691
R2048 n_4_7_1 n_4_8_1 154.6211150642974
R2049 n_4_7_1 n_4_7_2 479.4840356277216
R2050 n_4_7_2 n_5_7_2 27000.749992602472
R2051 n_4_7_2 n_4_8_2 552.2182680867766
R2052 n_4_7_2 n_4_7_3 463.6114606552177
R2053 n_4_7_3 n_5_7_3 189005.24994821713
R2054 n_4_7_3 n_4_8_3 3865.5278766074316
R2055 n_4_7_3 n_4_7_4 4.298822388386473
R2056 n_4_7_4 n_5_7_4 8591.14772491896
R2057 n_4_7_4 n_4_8_4 175.70581257306506
R2058 n_4_7_15 n_5_7_15 378010.4998964309
R2059 n_4_7_15 n_4_8_15 7731.055753214794
R2060 n_4_8_0 n_5_8_0 93.99999875576307
R2061 n_4_8_0 n_4_9_0 217.10812271744763
R2062 n_4_8_0 n_4_8_1 1.8995123178087503
R2063 n_4_8_1 n_5_8_1 131.5999982580683
R2064 n_4_8_1 n_4_9_1 303.9513718044267
R2065 n_4_8_1 n_4_8_2 8.346342002492994
R2066 n_4_8_2 n_5_8_2 469.9999937788153
R2067 n_4_8_2 n_4_9_2 1085.5406135872383
R2068 n_4_8_2 n_4_8_3 8.070049301720813
R2069 n_4_8_3 n_5_8_3 3289.999956451704
R2070 n_4_8_3 n_4_9_3 7598.78429511066
R2071 n_4_8_3 n_4_8_4 0.07482927312579932
R2072 n_4_8_4 n_5_8_4 149.54545256598655
R2073 n_4_8_4 n_4_9_4 345.39928614139365
R2074 n_4_8_4 n_4_8_5 0.07482927312579932
R2075 n_4_8_5 n_5_8_5 3289.999956451704
R2076 n_4_8_5 n_4_9_5 7598.78429511066
R2077 n_4_8_5 n_4_8_6 0.14965854625159863
R2078 n_4_8_6 n_5_8_6 1096.666652150568
R2079 n_4_8_6 n_4_9_6 2532.92809837022
R2080 n_4_8_6 n_4_8_7 0.21873172144464392
R2081 n_4_8_7 n_5_8_7 1879.9999751152654
R2082 n_4_8_7 n_4_9_7 4342.1624543489625
R2083 n_4_8_7 n_4_8_8 0.16117074211710572
R2084 n_4_8_8 n_5_8_8 1879.9999751152654
R2085 n_4_8_8 n_4_9_8 4342.1624543489625
R2086 n_4_8_8 n_4_8_9 0.16117074211710572
R2087 n_4_8_9 n_5_8_9 1879.9999751152654
R2088 n_4_8_9 n_4_9_9 4342.1624543489625
R2089 n_4_8_9 n_4_8_10 0.16117074211710572
R2090 n_4_8_10 n_5_8_10 1879.9999751152654
R2091 n_4_8_10 n_4_9_10 4342.1624543489625
R2092 n_4_8_10 n_4_8_11 0.1611707421171047
R2093 n_4_8_11 n_5_8_11 1879.9999751152895
R2094 n_4_8_11 n_4_9_11 4342.162454349018
R2095 n_4_8_11 n_4_8_12 0.1611707421171042
R2096 n_4_8_12 n_5_8_12 1879.9999751152773
R2097 n_4_8_12 n_4_9_12 4342.16245434899
R2098 n_4_8_12 n_4_8_13 0.16117074211710572
R2099 n_4_8_13 n_5_8_13 1879.9999751152532
R2100 n_4_8_13 n_4_9_13 4342.162454348934
R2101 n_4_8_13 n_4_8_14 0.8058537105855306
R2102 n_4_8_14 n_5_8_14 208.88888612391793
R2103 n_4_8_14 n_4_9_14 482.46249492766145
R2104 n_4_8_14 n_4_8_15 3.027707512628515
R2105 n_4_8_15 n_5_8_15 6579.9999129033495
R2106 n_4_8_15 n_4_9_15 15197.568590221184
R2107 n_4_9_0 n_5_9_0 93.99999875576307
R2108 n_4_9_0 n_4_10_0 110.44365396273243
R2109 n_4_9_0 n_4_9_1 1.8995123178087503
R2110 n_4_9_1 n_5_9_1 131.5999982580683
R2111 n_4_9_1 n_4_10_1 154.6211155478254
R2112 n_4_9_1 n_4_9_2 8.346342002492994
R2113 n_4_9_2 n_5_9_2 469.9999937788153
R2114 n_4_9_2 n_4_10_2 552.2182698136622
R2115 n_4_9_2 n_4_9_3 8.070049301720813
R2116 n_4_9_3 n_5_9_3 3289.999956451704
R2117 n_4_9_3 n_4_10_3 3865.5278886956316
R2118 n_4_9_3 n_4_9_4 0.07482927312579932
R2119 n_4_9_4 n_5_9_4 149.54545256598655
R2120 n_4_9_4 n_4_10_4 175.7058131225287
R2121 n_4_9_4 n_4_9_5 0.07482927312579932
R2122 n_4_9_5 n_5_9_5 3289.999956451704
R2123 n_4_9_5 n_4_9_6 0.14965854625159863
R2124 n_4_9_6 n_5_9_6 1096.666652150568
R2125 n_4_9_6 n_4_9_7 0.21873172144464392
R2126 n_4_9_7 n_5_9_7 1879.9999751152654
R2127 n_4_9_7 n_4_9_8 0.16117074211710572
R2128 n_4_9_8 n_5_9_8 1879.9999751152654
R2129 n_4_9_8 n_4_9_9 0.16117074211710572
R2130 n_4_9_9 n_5_9_9 1879.9999751152654
R2131 n_4_9_9 n_4_9_10 0.16117074211710572
R2132 n_4_9_10 n_5_9_10 1879.9999751152654
R2133 n_4_9_10 n_4_9_11 0.1611707421171047
R2134 n_4_9_11 n_5_9_11 1879.9999751152895
R2135 n_4_9_11 n_4_9_12 0.1611707421171042
R2136 n_4_9_12 n_5_9_12 1879.9999751152773
R2137 n_4_9_12 n_4_9_13 0.16117074211710572
R2138 n_4_9_13 n_5_9_13 1879.9999751152532
R2139 n_4_9_13 n_4_9_14 0.8058537105855306
R2140 n_4_9_14 n_5_9_14 208.88888612391793
R2141 n_4_9_14 n_4_9_15 3.027707512628515
R2142 n_4_9_15 n_5_9_15 6579.9999129033495
R2143 n_4_9_15 n_4_10_15 7731.055777391194
R2144 n_4_10_0 n_5_10_0 5400.149011488476
R2145 n_4_10_0 n_4_11_0 3.7791852080171653
R2146 n_4_10_0 n_4_10_1 109.12393299043761
R2147 n_4_10_1 n_5_10_1 7560.208616083865
R2148 n_4_10_1 n_4_11_1 5.290859291224032
R2149 n_4_10_1 n_4_10_2 479.4839479882865
R2150 n_4_10_2 n_5_10_2 27000.745057442386
R2151 n_4_10_2 n_4_11_2 18.895926040085826
R2152 n_4_10_2 n_4_10_3 463.6113759169501
R2153 n_4_10_3 n_5_10_3 189005.21540209648
R2154 n_4_10_3 n_4_11_3 132.27148228060065
R2155 n_4_10_3 n_4_10_4 4.298821602653607
R2156 n_4_10_4 n_5_10_4 8591.146154640752
R2157 n_4_10_4 n_4_11_4 6.012340103663666
R2158 n_4_10_15 n_5_10_15 378010.4308041896
R2159 n_4_10_15 n_4_11_15 264.54296456119897
R2160 n_4_11_0 n_5_11_0 5400.149011488667
R2161 n_4_11_0 n_4_12_0 43.5617151343599
R2162 n_4_11_0 n_4_11_1 109.12393299044149
R2163 n_4_11_1 n_5_11_1 7560.2086160841345
R2164 n_4_11_1 n_4_12_1 60.98640118810386
R2165 n_4_11_1 n_4_11_2 479.48394798830344
R2166 n_4_11_2 n_5_11_2 27000.74505744334
R2167 n_4_11_2 n_4_12_2 217.8085756717995
R2168 n_4_11_2 n_4_11_3 463.6113759169665
R2169 n_4_11_3 n_5_11_3 189005.2154021032
R2170 n_4_11_3 n_4_12_3 1524.6600297025952
R2171 n_4_11_3 n_4_11_4 4.29882160265376
R2172 n_4_11_4 n_5_11_4 8591.146154641054
R2173 n_4_11_4 n_4_12_4 69.30272862284522
R2174 n_4_11_15 n_5_11_15 378010.43080420303
R2175 n_4_11_15 n_4_12_15 3049.3200594051627
R2176 n_4_12_0 n_5_12_0 244.86589626484843
R2177 n_4_12_0 n_4_13_0 83.34424506070278
R2178 n_4_12_0 n_4_12_1 4.948146726840704
R2179 n_4_12_1 n_5_12_1 342.8122547707877
R2180 n_4_12_1 n_4_13_1 116.68194308498389
R2181 n_4_12_1 n_4_12_2 21.741856830057635
R2182 n_4_12_2 n_5_12_2 1224.329481324242
R2183 n_4_12_2 n_4_13_2 416.72122530351385
R2184 n_4_12_2 n_4_12_3 21.022126397062625
R2185 n_4_12_3 n_5_12_3 8570.306369269685
R2186 n_4_12_3 n_4_13_3 2917.0485771245944
R2187 n_4_12_3 n_4_12_4 0.19492699226948243
R2188 n_4_12_4 n_5_12_4 389.5593804213494
R2189 n_4_12_4 n_4_13_4 132.59311714202698
R2190 n_4_12_4 n_4_12_5 0.17065037052163481
R2191 n_4_12_5 n_5_12_5 1632.439308432321
R2192 n_4_12_5 n_4_13_5 555.6283004046845
R2193 n_4_12_5 n_4_12_6 0.03998502405527845
R2194 n_4_12_6 n_5_12_6 272.07321807205346
R2195 n_4_12_6 n_4_13_6 92.60471673411408
R2196 n_4_12_6 n_4_12_7 0.05426538978930641
R2197 n_4_12_7 n_5_12_7 466.41123098066464
R2198 n_4_12_7 n_4_13_7 158.7509429727675
R2199 n_4_12_7 n_4_12_8 0.039985024055278325
R2200 n_4_12_8 n_5_12_8 466.41123098066464
R2201 n_4_12_8 n_4_13_8 158.7509429727675
R2202 n_4_12_8 n_4_12_9 0.039985024055278325
R2203 n_4_12_9 n_5_12_9 466.41123098066464
R2204 n_4_12_9 n_4_13_9 158.7509429727675
R2205 n_4_12_9 n_4_12_10 0.039985024055278325
R2206 n_4_12_10 n_5_12_10 466.41123098066464
R2207 n_4_12_10 n_4_13_10 158.7509429727675
R2208 n_4_12_10 n_4_12_11 0.03998502405527807
R2209 n_4_12_11 n_5_12_11 466.41123098067067
R2210 n_4_12_11 n_4_13_11 158.7509429727695
R2211 n_4_12_11 n_4_12_12 0.03998502405527794
R2212 n_4_12_12 n_5_12_12 466.41123098066754
R2213 n_4_12_12 n_4_13_12 158.75094297276854
R2214 n_4_12_12 n_4_12_13 0.039985024055278325
R2215 n_4_12_13 n_5_12_13 466.4112309806617
R2216 n_4_12_13 n_4_13_13 158.7509429727665
R2217 n_4_12_13 n_4_12_14 0.19992512027639214
R2218 n_4_12_14 n_5_12_14 51.823470108962624
R2219 n_4_12_14 n_4_13_14 17.638993663640797
R2220 n_4_12_14 n_4_12_15 6.1776862165405735
R2221 n_4_12_15 n_5_12_15 17140.612738539217
R2222 n_4_12_15 n_4_13_15 5834.097154249136
R2223 n_4_13_0 n_5_13_0 244.865896264848
R2224 n_4_13_0 n_4_13_1 4.948146726840695
R2225 n_4_13_1 n_5_13_1 342.81225477078715
R2226 n_4_13_1 n_4_13_2 21.741856830057603
R2227 n_4_13_2 n_5_13_2 1224.32948132424
R2228 n_4_13_2 n_4_13_3 21.022126397062593
R2229 n_4_13_3 n_5_13_3 8570.306369269674
R2230 n_4_13_3 n_4_13_4 0.1949269922694821
R2231 n_4_13_4 n_5_13_4 389.5593804213487
R2232 n_4_13_4 n_4_13_5 0.1706503705216345
R2233 n_4_13_5 n_5_13_5 1632.4393084323187
R2234 n_4_13_5 n_4_13_6 0.03998502405527838
R2235 n_4_13_6 n_5_13_6 272.0732180720531
R2236 n_4_13_6 n_4_13_7 0.05426538978930631
R2237 n_4_13_7 n_5_13_7 466.41123098066385
R2238 n_4_13_7 n_4_13_8 0.039985024055278255
R2239 n_4_13_8 n_5_13_8 466.41123098066385
R2240 n_4_13_8 n_4_13_9 0.039985024055278255
R2241 n_4_13_9 n_5_13_9 466.41123098066385
R2242 n_4_13_9 n_4_13_10 0.039985024055278255
R2243 n_4_13_10 n_5_13_10 466.41123098066385
R2244 n_4_13_10 n_4_13_11 0.039985024055278
R2245 n_4_13_11 n_5_13_11 466.4112309806698
R2246 n_4_13_11 n_4_13_12 0.039985024055277874
R2247 n_4_13_12 n_5_13_12 466.41123098066686
R2248 n_4_13_12 n_4_13_13 0.039985024055278255
R2249 n_4_13_13 n_5_13_13 466.41123098066095
R2250 n_4_13_13 n_4_13_14 0.19992512027639175
R2251 n_4_13_14 n_5_13_14 51.82347010896254
R2252 n_4_13_14 n_4_13_15 6.177686216540564
R2253 n_4_13_15 n_5_13_15 17140.61273853919
R2254 n_5_0_0 n_6_0_0 125.67181422348104
R2255 n_5_0_0 n_5_1_0 83.34425223829639
R2256 n_5_0_0 n_5_0_1 4.948146300707096
R2257 n_5_0_1 n_6_0_1 175.9405399128734
R2258 n_5_0_1 n_5_1_1 116.68195313361494
R2259 n_5_0_1 n_5_0_2 21.74185495765239
R2260 n_5_0_2 n_6_0_2 628.3590711174052
R2261 n_5_0_2 n_5_1_2 416.721261191482
R2262 n_5_0_2 n_5_0_3 21.022124586640448
R2263 n_5_0_3 n_6_0_3 4398.513497821831
R2264 n_5_0_3 n_5_1_3 2917.0488283403706
R2265 n_5_0_3 n_5_0_4 0.19492697548240093
R2266 n_5_0_4 n_6_0_4 199.93243171917416
R2267 n_5_0_4 n_5_1_4 132.59312856092598
R2268 n_5_0_4 n_5_0_5 0.1706503558252521
R2269 n_5_0_5 n_6_0_5 837.8120948232059
R2270 n_5_0_5 n_5_1_5 555.6283482553088
R2271 n_5_0_5 n_5_0_6 0.039985020611774544
R2272 n_5_0_6 n_6_0_6 139.63534913720102
R2273 n_5_0_6 n_5_1_6 92.60472470921813
R2274 n_5_0_6 n_5_0_7 0.05426538511597968
R2275 n_5_0_7 n_6_0_7 239.37488423520244
R2276 n_5_0_7 n_5_1_7 158.7509566443744
R2277 n_5_0_7 n_5_0_8 0.03998502061177442
R2278 n_5_0_8 n_6_0_8 239.37488423520244
R2279 n_5_0_8 n_5_1_8 158.7509566443744
R2280 n_5_0_8 n_5_0_9 0.03998502061177442
R2281 n_5_0_9 n_6_0_9 239.37488423520244
R2282 n_5_0_9 n_5_1_9 158.7509566443744
R2283 n_5_0_9 n_5_0_10 0.03998502061177442
R2284 n_5_0_10 n_6_0_10 239.37488423520244
R2285 n_5_0_10 n_5_1_10 158.7509566443744
R2286 n_5_0_10 n_5_0_11 0.03998502061177416
R2287 n_5_0_11 n_6_0_11 239.3748842352055
R2288 n_5_0_11 n_5_1_11 158.75095664437646
R2289 n_5_0_11 n_5_0_12 0.03998502061177403
R2290 n_5_0_12 n_6_0_12 239.37488423520406
R2291 n_5_0_12 n_5_1_12 158.75095664437546
R2292 n_5_0_12 n_5_0_13 0.03998502061177442
R2293 n_5_0_13 n_6_0_13 239.37488423520097
R2294 n_5_0_13 n_5_1_13 158.75095664437342
R2295 n_5_0_13 n_5_0_14 0.1999251030588726
R2296 n_5_0_14 n_6_0_14 26.597209359466884
R2297 n_5_0_14 n_5_1_14 17.638995182708236
R2298 n_5_0_14 n_5_0_15 6.177685684519219
R2299 n_5_0_15 n_6_0_15 8797.026995643586
R2300 n_5_0_15 n_5_1_15 5834.097656680689
R2301 n_5_1_0 n_6_1_0 125.67181422348104
R2302 n_5_1_0 n_5_2_0 43.561715134359936
R2303 n_5_1_0 n_5_1_1 4.948146300707096
R2304 n_5_1_1 n_6_1_1 175.9405399128734
R2305 n_5_1_1 n_5_2_1 60.98640118810391
R2306 n_5_1_1 n_5_1_2 21.74185495765239
R2307 n_5_1_2 n_6_1_2 628.3590711174052
R2308 n_5_1_2 n_5_2_2 217.8085756717997
R2309 n_5_1_2 n_5_1_3 21.022124586640448
R2310 n_5_1_3 n_6_1_3 4398.513497821831
R2311 n_5_1_3 n_5_2_3 1524.6600297025961
R2312 n_5_1_3 n_5_1_4 0.19492697548240093
R2313 n_5_1_4 n_6_1_4 199.93243171917416
R2314 n_5_1_4 n_5_2_4 69.30272862284531
R2315 n_5_1_4 n_5_1_5 0.1706503558252521
R2316 n_5_1_5 n_6_1_5 837.8120948232059
R2317 n_5_1_5 n_5_1_6 0.039985020611774544
R2318 n_5_1_6 n_6_1_6 139.63534913720102
R2319 n_5_1_6 n_5_1_7 0.05426538511597968
R2320 n_5_1_7 n_6_1_7 239.37488423520244
R2321 n_5_1_7 n_5_1_8 0.03998502061177442
R2322 n_5_1_8 n_6_1_8 239.37488423520244
R2323 n_5_1_8 n_5_1_9 0.03998502061177442
R2324 n_5_1_9 n_6_1_9 239.37488423520244
R2325 n_5_1_9 n_5_1_10 0.03998502061177442
R2326 n_5_1_10 n_6_1_10 239.37488423520244
R2327 n_5_1_10 n_5_1_11 0.03998502061177416
R2328 n_5_1_11 n_6_1_11 239.3748842352055
R2329 n_5_1_11 n_5_1_12 0.03998502061177403
R2330 n_5_1_12 n_6_1_12 239.37488423520406
R2331 n_5_1_12 n_5_1_13 0.03998502061177442
R2332 n_5_1_13 n_6_1_13 239.37488423520097
R2333 n_5_1_13 n_5_1_14 0.1999251030588726
R2334 n_5_1_14 n_6_1_14 26.597209359466884
R2335 n_5_1_14 n_5_1_15 6.177685684519219
R2336 n_5_1_15 n_6_1_15 8797.026995643586
R2337 n_5_1_15 n_5_2_15 3049.3200594051655
R2338 n_5_2_0 n_6_2_0 2771.508327886959
R2339 n_5_2_0 n_5_3_0 3.7791780304234868
R2340 n_5_2_0 n_5_2_1 109.12414024377486
R2341 n_5_2_1 n_6_2_1 3880.1116590417414
R2342 n_5_2_1 n_5_3_1 5.290849242592881
R2343 n_5_2_1 n_5_2_2 479.4848586468895
R2344 n_5_2_2 n_6_2_2 13857.541639434796
R2345 n_5_2_2 n_5_3_2 18.895890152117435
R2346 n_5_2_2 n_5_2_3 463.6122564296132
R2347 n_5_2_3 n_6_2_3 97002.79147604347
R2348 n_5_2_3 n_5_3_3 132.2712310648219
R2349 n_5_2_3 n_5_2_4 4.298829767179014
R2350 n_5_2_4 n_6_2_4 4409.217794365612
R2351 n_5_2_4 n_5_3_4 6.012328684764634
R2352 n_5_2_15 n_6_2_15 194005.58295208515
R2353 n_5_2_15 n_5_3_15 264.5424621296414
R2354 n_5_3_0 n_6_3_0 2771.508327886959
R2355 n_5_3_0 n_5_4_0 110.44365037393557
R2356 n_5_3_0 n_5_3_1 109.12414024377486
R2357 n_5_3_1 n_6_3_1 3880.1116590417414
R2358 n_5_3_1 n_5_4_1 154.62111052350977
R2359 n_5_3_1 n_5_3_2 479.4848586468895
R2360 n_5_3_2 n_6_3_2 13857.541639434796
R2361 n_5_3_2 n_5_4_2 552.2182518696779
R2362 n_5_3_2 n_5_3_3 463.6122564296132
R2363 n_5_3_3 n_6_3_3 97002.79147604347
R2364 n_5_3_3 n_5_4_3 3865.527763087741
R2365 n_5_3_3 n_5_3_4 4.298829767179014
R2366 n_5_3_4 n_6_3_4 4409.217794365612
R2367 n_5_3_4 n_5_4_4 175.70580741307916
R2368 n_5_3_15 n_6_3_15 194005.58295208515
R2369 n_5_3_15 n_5_4_15 7731.055526175412
R2370 n_5_4_0 n_6_4_0 48.243351067603285
R2371 n_5_4_0 n_5_5_0 217.1081227174476
R2372 n_5_4_0 n_5_4_1 1.8995123178087496
R2373 n_5_4_1 n_6_4_1 67.54069149464462
R2374 n_5_4_1 n_5_5_1 303.9513718044266
R2375 n_5_4_1 n_5_4_2 8.34634200249299
R2376 n_5_4_2 n_6_4_2 241.21675533801647
R2377 n_5_4_2 n_5_5_2 1085.540613587238
R2378 n_5_4_2 n_5_4_3 8.07004930172081
R2379 n_5_4_3 n_6_4_3 1688.517287366114
R2380 n_5_4_3 n_5_5_3 7598.784295110659
R2381 n_5_4_3 n_5_4_4 0.07482927312579929
R2382 n_5_4_4 n_6_4_4 76.7507857893688
R2383 n_5_4_4 n_5_5_4 345.39928614139365
R2384 n_5_4_4 n_5_4_5 0.07482927312579929
R2385 n_5_4_5 n_5_5_5 7598.784295110659
R2386 n_5_4_5 n_5_4_6 0.14965854625159858
R2387 n_5_4_6 n_5_5_6 2532.9280983702192
R2388 n_5_4_6 n_5_4_7 0.2187317214446438
R2389 n_5_4_7 n_5_5_7 4342.162454348962
R2390 n_5_4_7 n_5_4_8 0.16117074211710566
R2391 n_5_4_8 n_5_5_8 4342.162454348962
R2392 n_5_4_8 n_5_4_9 0.16117074211710566
R2393 n_5_4_9 n_5_5_9 4342.162454348962
R2394 n_5_4_9 n_5_4_10 0.16117074211710566
R2395 n_5_4_10 n_5_5_10 4342.162454348962
R2396 n_5_4_10 n_5_4_11 0.16117074211710464
R2397 n_5_4_11 n_5_5_11 4342.162454349017
R2398 n_5_4_11 n_5_4_12 0.16117074211710414
R2399 n_5_4_12 n_5_5_12 4342.16245434899
R2400 n_5_4_12 n_5_4_13 0.16117074211710566
R2401 n_5_4_13 n_5_5_13 4342.162454348934
R2402 n_5_4_13 n_5_4_14 0.8058537105855303
R2403 n_5_4_14 n_5_5_14 482.46249492766145
R2404 n_5_4_14 n_5_4_15 3.027707512628514
R2405 n_5_4_15 n_6_4_15 3377.034574732198
R2406 n_5_4_15 n_5_5_15 15197.56859022118
R2407 n_5_5_0 n_6_5_0 48.24335106760332
R2408 n_5_5_0 n_5_6_0 110.44365361735525
R2409 n_5_5_0 n_5_5_1 1.89951231780875
R2410 n_5_5_1 n_6_5_1 67.54069149464465
R2411 n_5_5_1 n_5_6_1 154.62111506429733
R2412 n_5_5_1 n_5_5_2 8.346342002492992
R2413 n_5_5_2 n_6_5_2 241.21675533801658
R2414 n_5_5_2 n_5_6_2 552.2182680867763
R2415 n_5_5_2 n_5_5_3 8.070049301720811
R2416 n_5_5_3 n_6_5_3 1688.5172873661145
R2417 n_5_5_3 n_5_6_3 3865.5278766074302
R2418 n_5_5_3 n_5_5_4 0.0748292731257993
R2419 n_5_5_4 n_6_5_4 76.75078578936885
R2420 n_5_5_4 n_5_6_4 175.70581257306506
R2421 n_5_5_4 n_5_5_5 0.0748292731257993
R2422 n_5_5_5 n_5_5_6 0.14965854625159863
R2423 n_5_5_6 n_5_5_7 0.2187317214446439
R2424 n_5_5_7 n_5_5_8 0.1611707421171057
R2425 n_5_5_8 n_5_5_9 0.1611707421171057
R2426 n_5_5_9 n_5_5_10 0.1611707421171057
R2427 n_5_5_10 n_5_5_11 0.16117074211710467
R2428 n_5_5_11 n_5_5_12 0.16117074211710414
R2429 n_5_5_12 n_5_5_13 0.1611707421171057
R2430 n_5_5_13 n_5_5_14 0.8058537105855306
R2431 n_5_5_14 n_5_5_15 3.027707512628515
R2432 n_5_5_15 n_6_5_15 3377.034574732199
R2433 n_5_5_15 n_5_6_15 7731.055753214791
R2434 n_5_6_0 n_6_6_0 2771.5035706888175
R2435 n_5_6_0 n_5_7_0 3.7791845172629372
R2436 n_5_6_0 n_5_6_1 109.1239529359642
R2437 n_5_6_1 n_6_6_1 3880.1049989643443
R2438 n_5_6_1 n_5_7_1 5.290858324168112
R2439 n_5_6_1 n_5_6_2 479.4840356277215
R2440 n_5_6_2 n_6_6_2 13857.51785344409
R2441 n_5_6_2 n_5_7_2 18.895922586314686
R2442 n_5_6_2 n_5_6_3 463.61146065521757
R2443 n_5_6_3 n_6_6_3 97002.62497410852
R2444 n_5_6_3 n_5_7_3 132.27145810420268
R2445 n_5_6_3 n_5_6_4 4.298822388386472
R2446 n_5_6_4 n_6_6_4 4409.210226095842
R2447 n_5_6_4 n_5_7_4 6.012339004736487
R2448 n_5_6_15 n_6_6_15 194005.24994821532
R2449 n_5_6_15 n_5_7_15 264.54291620840297
R2450 n_5_7_0 n_6_7_0 2771.5035706888175
R2451 n_5_7_0 n_5_8_0 110.44365361735525
R2452 n_5_7_0 n_5_7_1 109.1239529359642
R2453 n_5_7_1 n_6_7_1 3880.1049989643443
R2454 n_5_7_1 n_5_8_1 154.62111506429733
R2455 n_5_7_1 n_5_7_2 479.4840356277215
R2456 n_5_7_2 n_6_7_2 13857.51785344409
R2457 n_5_7_2 n_5_8_2 552.2182680867763
R2458 n_5_7_2 n_5_7_3 463.61146065521757
R2459 n_5_7_3 n_6_7_3 97002.62497410852
R2460 n_5_7_3 n_5_8_3 3865.5278766074302
R2461 n_5_7_3 n_5_7_4 4.298822388386472
R2462 n_5_7_4 n_6_7_4 4409.210226095842
R2463 n_5_7_4 n_5_8_4 175.70581257306506
R2464 n_5_7_15 n_6_7_15 194005.24994821532
R2465 n_5_7_15 n_5_8_15 7731.055753214791
R2466 n_5_8_0 n_6_8_0 48.24335106760332
R2467 n_5_8_0 n_5_9_0 217.10812271744757
R2468 n_5_8_0 n_5_8_1 1.89951231780875
R2469 n_5_8_1 n_6_8_1 67.54069149464465
R2470 n_5_8_1 n_5_9_1 303.95137180442657
R2471 n_5_8_1 n_5_8_2 8.346342002492992
R2472 n_5_8_2 n_6_8_2 241.21675533801658
R2473 n_5_8_2 n_5_9_2 1085.5406135872379
R2474 n_5_8_2 n_5_8_3 8.070049301720811
R2475 n_5_8_3 n_6_8_3 1688.5172873661145
R2476 n_5_8_3 n_5_9_3 7598.784295110658
R2477 n_5_8_3 n_5_8_4 0.0748292731257993
R2478 n_5_8_4 n_6_8_4 76.75078578936885
R2479 n_5_8_4 n_5_9_4 345.39928614139365
R2480 n_5_8_4 n_5_8_5 0.0748292731257993
R2481 n_5_8_5 n_5_9_5 7598.784295110658
R2482 n_5_8_5 n_5_8_6 0.14965854625159863
R2483 n_5_8_6 n_5_9_6 2532.9280983702192
R2484 n_5_8_6 n_5_8_7 0.2187317214446439
R2485 n_5_8_7 n_5_9_7 4342.162454348961
R2486 n_5_8_7 n_5_8_8 0.1611707421171057
R2487 n_5_8_8 n_5_9_8 4342.162454348961
R2488 n_5_8_8 n_5_8_9 0.1611707421171057
R2489 n_5_8_9 n_5_9_9 4342.162454348961
R2490 n_5_8_9 n_5_8_10 0.1611707421171057
R2491 n_5_8_10 n_5_9_10 4342.162454348961
R2492 n_5_8_10 n_5_8_11 0.16117074211710467
R2493 n_5_8_11 n_5_9_11 4342.162454349016
R2494 n_5_8_11 n_5_8_12 0.16117074211710414
R2495 n_5_8_12 n_5_9_12 4342.162454348989
R2496 n_5_8_12 n_5_8_13 0.1611707421171057
R2497 n_5_8_13 n_5_9_13 4342.162454348933
R2498 n_5_8_13 n_5_8_14 0.8058537105855306
R2499 n_5_8_14 n_5_9_14 482.4624949276614
R2500 n_5_8_14 n_5_8_15 3.027707512628515
R2501 n_5_8_15 n_6_8_15 3377.034574732199
R2502 n_5_8_15 n_5_9_15 15197.568590221179
R2503 n_5_9_0 n_6_9_0 48.24335106760332
R2504 n_5_9_0 n_5_10_0 110.4436539627324
R2505 n_5_9_0 n_5_9_1 1.89951231780875
R2506 n_5_9_1 n_6_9_1 67.54069149464465
R2507 n_5_9_1 n_5_10_1 154.62111554782535
R2508 n_5_9_1 n_5_9_2 8.346342002492992
R2509 n_5_9_2 n_6_9_2 241.21675533801658
R2510 n_5_9_2 n_5_10_2 552.218269813662
R2511 n_5_9_2 n_5_9_3 8.070049301720811
R2512 n_5_9_3 n_6_9_3 1688.5172873661145
R2513 n_5_9_3 n_5_10_3 3865.5278886956303
R2514 n_5_9_3 n_5_9_4 0.0748292731257993
R2515 n_5_9_4 n_6_9_4 76.75078578936885
R2516 n_5_9_4 n_5_10_4 175.7058131225287
R2517 n_5_9_4 n_5_9_5 0.0748292731257993
R2518 n_5_9_5 n_5_9_6 0.14965854625159863
R2519 n_5_9_6 n_5_9_7 0.2187317214446439
R2520 n_5_9_7 n_5_9_8 0.1611707421171057
R2521 n_5_9_8 n_5_9_9 0.1611707421171057
R2522 n_5_9_9 n_5_9_10 0.1611707421171057
R2523 n_5_9_10 n_5_9_11 0.16117074211710467
R2524 n_5_9_11 n_5_9_12 0.16117074211710414
R2525 n_5_9_12 n_5_9_13 0.1611707421171057
R2526 n_5_9_13 n_5_9_14 0.8058537105855306
R2527 n_5_9_14 n_5_9_15 3.027707512628515
R2528 n_5_9_15 n_6_9_15 3377.034574732199
R2529 n_5_9_15 n_5_10_15 7731.055777391191
R2530 n_5_10_0 n_6_10_0 2771.5030641171925
R2531 n_5_10_0 n_5_11_0 3.7791852080171644
R2532 n_5_10_0 n_5_10_1 109.1239329904376
R2533 n_5_10_1 n_6_10_1 3880.104289764068
R2534 n_5_10_1 n_5_11_1 5.29085929122403
R2535 n_5_10_1 n_5_10_2 479.48394798828645
R2536 n_5_10_2 n_6_10_2 13857.515320585964
R2537 n_5_10_2 n_5_11_2 18.895926040085822
R2538 n_5_10_2 n_5_10_3 463.61137591695007
R2539 n_5_10_3 n_6_10_3 97002.60724410163
R2540 n_5_10_3 n_5_11_3 132.2714822806006
R2541 n_5_10_3 n_5_10_4 4.298821602653606
R2542 n_5_10_4 n_6_10_4 4409.209420186438
R2543 n_5_10_4 n_5_11_4 6.012340103663666
R2544 n_5_10_15 n_6_10_15 194005.21448820154
R2545 n_5_10_15 n_5_11_15 264.54296456119886
R2546 n_5_11_0 n_6_11_0 2771.5030641172903
R2547 n_5_11_0 n_5_12_0 43.561715134359886
R2548 n_5_11_0 n_5_11_1 109.12393299044147
R2549 n_5_11_1 n_6_11_1 3880.1042897642064
R2550 n_5_11_1 n_5_12_1 60.98640118810384
R2551 n_5_11_1 n_5_11_2 479.4839479883034
R2552 n_5_11_2 n_6_11_2 13857.515320586452
R2553 n_5_11_2 n_5_12_2 217.80857567179945
R2554 n_5_11_2 n_5_11_3 463.61137591696644
R2555 n_5_11_3 n_6_11_3 97002.60724410508
R2556 n_5_11_3 n_5_12_3 1524.6600297025946
R2557 n_5_11_3 n_5_11_4 4.298821602653759
R2558 n_5_11_4 n_6_11_4 4409.209420186595
R2559 n_5_11_4 n_5_12_4 69.30272862284522
R2560 n_5_11_15 n_6_11_15 194005.21448820844
R2561 n_5_11_15 n_5_12_15 3049.3200594051614
R2562 n_5_12_0 n_6_12_0 125.67182504631857
R2563 n_5_12_0 n_5_13_0 83.34424506070275
R2564 n_5_12_0 n_5_12_1 4.948146726840703
R2565 n_5_12_1 n_6_12_1 175.94055506484597
R2566 n_5_12_1 n_5_13_1 116.68194308498383
R2567 n_5_12_1 n_5_12_2 21.741856830057632
R2568 n_5_12_2 n_6_12_2 628.3591252315928
R2569 n_5_12_2 n_5_13_2 416.72122530351373
R2570 n_5_12_2 n_5_12_3 21.02212639706262
R2571 n_5_12_3 n_6_12_3 4398.513876621144
R2572 n_5_12_3 n_5_13_3 2917.048577124593
R2573 n_5_12_3 n_5_12_4 0.1949269922694824
R2574 n_5_12_4 n_6_12_4 199.9324489373248
R2575 n_5_12_4 n_5_13_4 132.59311714202698
R2576 n_5_12_4 n_5_12_5 0.1706503705216348
R2577 n_5_12_5 n_6_12_5 837.8121669754562
R2578 n_5_12_5 n_5_13_5 555.6283004046845
R2579 n_5_12_5 n_5_12_6 0.03998502405527844
R2580 n_5_12_6 n_6_12_6 139.63536116257603
R2581 n_5_12_6 n_5_13_6 92.60471673411408
R2582 n_5_12_6 n_5_12_7 0.054265389789306395
R2583 n_5_12_7 n_6_12_7 239.37490485013112
R2584 n_5_12_7 n_5_13_7 158.75094297276746
R2585 n_5_12_7 n_5_12_8 0.03998502405527832
R2586 n_5_12_8 n_6_12_8 239.37490485013112
R2587 n_5_12_8 n_5_13_8 158.75094297276746
R2588 n_5_12_8 n_5_12_9 0.03998502405527832
R2589 n_5_12_9 n_6_12_9 239.37490485013112
R2590 n_5_12_9 n_5_13_9 158.75094297276746
R2591 n_5_12_9 n_5_12_10 0.03998502405527832
R2592 n_5_12_10 n_6_12_10 239.37490485013112
R2593 n_5_12_10 n_5_13_10 158.75094297276746
R2594 n_5_12_10 n_5_12_11 0.03998502405527807
R2595 n_5_12_11 n_6_12_11 239.3749048501342
R2596 n_5_12_11 n_5_13_11 158.7509429727695
R2597 n_5_12_11 n_5_12_12 0.039985024055277936
R2598 n_5_12_12 n_6_12_12 239.3749048501326
R2599 n_5_12_12 n_5_13_12 158.75094297276848
R2600 n_5_12_12 n_5_12_13 0.03998502405527832
R2601 n_5_12_13 n_6_12_13 239.37490485012958
R2602 n_5_12_13 n_5_13_13 158.75094297276647
R2603 n_5_12_13 n_5_12_14 0.19992512027639212
R2604 n_5_12_14 n_6_12_14 26.597211650014508
R2605 n_5_12_14 n_5_13_14 17.638993663640797
R2606 n_5_12_14 n_5_12_15 6.177686216540573
R2607 n_5_12_15 n_6_12_15 8797.027753242211
R2608 n_5_12_15 n_5_13_15 5834.097154249133
R2609 n_5_13_0 n_6_13_0 125.67182504631835
R2610 n_5_13_0 n_5_13_1 4.948146726840694
R2611 n_5_13_1 n_6_13_1 175.94055506484568
R2612 n_5_13_1 n_5_13_2 21.7418568300576
R2613 n_5_13_2 n_6_13_2 628.3591252315919
R2614 n_5_13_2 n_5_13_3 21.02212639706259
R2615 n_5_13_3 n_6_13_3 4398.5138766211385
R2616 n_5_13_3 n_5_13_4 0.19492699226948207
R2617 n_5_13_4 n_6_13_4 199.93244893732444
R2618 n_5_13_4 n_5_13_5 0.17065037052163448
R2619 n_5_13_5 n_6_13_5 837.8121669754549
R2620 n_5_13_5 n_5_13_6 0.03998502405527838
R2621 n_5_13_6 n_6_13_6 139.6353611625758
R2622 n_5_13_6 n_5_13_7 0.054265389789306305
R2623 n_5_13_7 n_6_13_7 239.3749048501307
R2624 n_5_13_7 n_5_13_8 0.03998502405527825
R2625 n_5_13_8 n_6_13_8 239.3749048501307
R2626 n_5_13_8 n_5_13_9 0.03998502405527825
R2627 n_5_13_9 n_6_13_9 239.3749048501307
R2628 n_5_13_9 n_5_13_10 0.03998502405527825
R2629 n_5_13_10 n_6_13_10 239.3749048501307
R2630 n_5_13_10 n_5_13_11 0.039985024055278
R2631 n_5_13_11 n_6_13_11 239.37490485013376
R2632 n_5_13_11 n_5_13_12 0.03998502405527787
R2633 n_5_13_12 n_6_13_12 239.37490485013225
R2634 n_5_13_12 n_5_13_13 0.03998502405527825
R2635 n_5_13_13 n_6_13_13 239.3749048501292
R2636 n_5_13_13 n_5_13_14 0.19992512027639173
R2637 n_5_13_14 n_6_13_14 26.597211650014465
R2638 n_5_13_14 n_5_13_15 6.177686216540563
R2639 n_5_13_15 n_6_13_15 8797.027753242197
R2640 n_6_0_0 n_7_0_0 6.477753269925552
R2641 n_6_0_0 n_6_1_0 3150.500245209352
R2642 n_6_0_0 n_6_0_1 187.04512566910162
R2643 n_6_0_1 n_7_0_1 9.06885457789577
R2644 n_6_0_1 n_6_1_1 4410.700343293092
R2645 n_6_0_1 n_6_0_2 821.86494612181
R2646 n_6_0_2 n_7_0_2 32.38876634962776
R2647 n_6_0_2 n_6_1_2 15752.50122604676
R2648 n_6_0_2 n_6_0_3 794.6583823881225
R2649 n_6_0_3 n_7_0_3 226.72136444739405
R2650 n_6_0_3 n_6_1_3 110267.5085823272
R2651 n_6_0_3 n_6_0_4 7.368444344540373
R2652 n_6_0_4 n_7_0_4 10.30551656579064
R2653 n_6_0_4 n_6_1_4 5012.159481014874
R2654 n_6_0_4 n_6_0_5 6.450762631300912
R2655 n_6_0_5 n_7_0_5 43.18502179950363
R2656 n_6_0_5 n_6_1_5 21003.334968062325
R2657 n_6_0_5 n_6_0_6 1.5114757629826405
R2658 n_6_0_6 n_7_0_6 7.197503633250606
R2659 n_6_0_6 n_6_1_6 3500.555828010388
R2660 n_6_0_6 n_6_0_7 2.0512885354764383
R2661 n_6_0_7 n_7_0_7 12.338577657001077
R2662 n_6_0_7 n_6_1_7 6000.952848017826
R2663 n_6_0_7 n_6_0_8 1.5114757629826359
R2664 n_6_0_8 n_7_0_8 12.338577657001077
R2665 n_6_0_8 n_6_1_8 6000.952848017826
R2666 n_6_0_8 n_6_0_9 1.5114757629826359
R2667 n_6_0_9 n_7_0_9 12.338577657001077
R2668 n_6_0_9 n_6_1_9 6000.952848017826
R2669 n_6_0_9 n_6_0_10 1.5114757629826359
R2670 n_6_0_10 n_7_0_10 12.338577657001077
R2671 n_6_0_10 n_6_1_10 6000.952848017826
R2672 n_6_0_10 n_6_0_11 1.5114757629826263
R2673 n_6_0_11 n_7_0_11 12.338577657001235
R2674 n_6_0_11 n_6_1_11 6000.952848017902
R2675 n_6_0_11 n_6_0_12 1.5114757629826214
R2676 n_6_0_12 n_7_0_12 12.33857765700116
R2677 n_6_0_12 n_6_1_12 6000.952848017864
R2678 n_6_0_12 n_6_0_13 1.511475762982636
R2679 n_6_0_13 n_7_0_13 12.338577657001
R2680 n_6_0_13 n_6_1_13 6000.952848017788
R2681 n_6_0_13 n_6_0_14 7.557378814913198
R2682 n_6_0_14 n_7_0_14 1.3709530730001167
R2683 n_6_0_14 n_6_1_14 666.772538668646
R2684 n_6_0_14 n_6_0_15 233.52300538082
R2685 n_6_0_15 n_7_0_15 453.4427288947841
R2686 n_6_0_15 n_6_1_15 220535.01716465247
R2687 n_6_1_0 n_7_1_0 6.477753269925552
R2688 n_6_1_0 n_6_2_0 1646.6785714285777
R2689 n_6_1_0 n_6_1_1 187.04512566910162
R2690 n_6_1_1 n_7_1_1 9.06885457789577
R2691 n_6_1_1 n_6_2_1 2305.3500000000085
R2692 n_6_1_1 n_6_1_2 821.86494612181
R2693 n_6_1_2 n_7_1_2 32.38876634962776
R2694 n_6_1_2 n_6_2_2 8233.392857142888
R2695 n_6_1_2 n_6_1_3 794.6583823881225
R2696 n_6_1_3 n_7_1_3 226.72136444739405
R2697 n_6_1_3 n_6_2_3 57633.750000000146
R2698 n_6_1_3 n_6_1_4 7.368444344540373
R2699 n_6_1_4 n_7_1_4 10.30551656579064
R2700 n_6_1_4 n_6_2_4 2619.7159090909163
R2701 n_6_1_4 n_6_1_5 6.450762631300912
R2702 n_6_1_5 n_7_1_5 43.18502179950363
R2703 n_6_1_5 n_6_1_6 1.5114757629826405
R2704 n_6_1_6 n_7_1_6 7.197503633250606
R2705 n_6_1_6 n_6_1_7 2.0512885354764383
R2706 n_6_1_7 n_7_1_7 12.338577657001077
R2707 n_6_1_7 n_6_1_8 1.5114757629826359
R2708 n_6_1_8 n_7_1_8 12.338577657001077
R2709 n_6_1_8 n_6_1_9 1.5114757629826359
R2710 n_6_1_9 n_7_1_9 12.338577657001077
R2711 n_6_1_9 n_6_1_10 1.5114757629826359
R2712 n_6_1_10 n_7_1_10 12.338577657001077
R2713 n_6_1_10 n_6_1_11 1.5114757629826263
R2714 n_6_1_11 n_7_1_11 12.338577657001235
R2715 n_6_1_11 n_6_1_12 1.5114757629826214
R2716 n_6_1_12 n_7_1_12 12.33857765700116
R2717 n_6_1_12 n_6_1_13 1.511475762982636
R2718 n_6_1_13 n_7_1_13 12.338577657001
R2719 n_6_1_13 n_6_1_14 7.557378814913198
R2720 n_6_1_14 n_7_1_14 1.3709530730001167
R2721 n_6_1_14 n_6_1_15 233.52300538082
R2722 n_6_1_15 n_7_1_15 453.4427288947841
R2723 n_6_1_15 n_6_2_15 115267.49999999929
R2724 n_6_2_0 n_7_2_0 142.8573880669036
R2725 n_6_2_0 n_6_3_0 142.8568976478031
R2726 n_6_2_0 n_6_2_1 4125.00708043187
R2727 n_6_2_1 n_7_2_1 200.000343293665
R2728 n_6_2_1 n_6_3_1 199.9996567069243
R2729 n_6_2_1 n_6_2_2 18125.03111098852
R2730 n_6_2_2 n_7_2_2 714.2869403345181
R2731 n_6_2_2 n_6_3_2 714.2844882390153
R2732 n_6_2_2 n_6_2_3 17525.03008110752
R2733 n_6_2_3 n_7_2_3 5000.008582341621
R2734 n_6_2_3 n_6_3_3 4999.991417673102
R2735 n_6_2_3 n_6_2_4 162.50027892610413
R2736 n_6_2_4 n_7_2_4 227.27311737916457
R2737 n_6_2_4 n_6_3_4 227.27233716695923
R2738 n_6_2_15 n_7_2_15 10000.017164683151
R2739 n_6_2_15 n_6_3_15 9999.982835346116
R2740 n_6_3_0 n_7_3_0 142.8573880669036
R2741 n_6_3_0 n_6_4_0 4174.885948823918
R2742 n_6_3_0 n_6_3_1 4125.00708043187
R2743 n_6_3_1 n_7_3_1 200.000343293665
R2744 n_6_3_1 n_6_4_1 5844.840328353484
R2745 n_6_3_1 n_6_3_2 18125.03111098852
R2746 n_6_3_2 n_7_3_2 714.2869403345181
R2747 n_6_3_2 n_6_4_2 20874.429744119585
R2748 n_6_3_2 n_6_3_3 17525.03008110752
R2749 n_6_3_3 n_7_3_3 5000.008582341621
R2750 n_6_3_3 n_6_4_3 146121.00820883695
R2751 n_6_3_3 n_6_3_4 162.50027892610413
R2752 n_6_3_4 n_7_3_4 227.27311737916457
R2753 n_6_3_4 n_6_4_4 6641.86400949259
R2754 n_6_3_15 n_7_3_15 10000.017164683151
R2755 n_6_3_15 n_6_4_15 292242.01641767134
R2756 n_6_4_0 n_7_4_0 2.4867033794435605
R2757 n_6_4_0 n_6_5_0 8206.91500000003
R2758 n_6_4_0 n_6_4_1 71.80356008143332
R2759 n_6_4_1 n_7_4_1 3.481384731220985
R2760 n_6_4_1 n_6_5_1 11489.681000000042
R2761 n_6_4_1 n_6_4_2 315.50049126690396
R2762 n_6_4_2 n_7_4_2 12.433516897217803
R2763 n_6_4_2 n_6_5_2 41034.57500000015
R2764 n_6_4_2 n_6_4_3 305.05633707324097
R2765 n_6_4_3 n_7_4_3 87.03461828052455
R2766 n_6_4_3 n_6_5_3 287242.0250000007
R2767 n_6_4_3 n_6_4_4 2.8286250941170725
R2768 n_6_4_4 n_7_4_4 3.956119012751116
R2769 n_6_4_4 n_6_5_4 13056.45568181822
R2770 n_6_4_15 n_7_4_15 174.06923656104755
R2771 n_6_4_15 n_6_5_15 574484.0499999964
R2772 n_6_5_0 n_7_5_0 2.486703379443562
R2773 n_6_5_0 n_6_6_0 4174.8860714285875
R2774 n_6_5_0 n_6_5_1 71.80356008143335
R2775 n_6_5_1 n_7_5_1 3.4813847312209862
R2776 n_6_5_1 n_6_6_1 5844.840500000022
R2777 n_6_5_1 n_6_5_2 315.5004912669041
R2778 n_6_5_2 n_7_5_2 12.433516897217809
R2779 n_6_5_2 n_6_6_2 20874.430357142934
R2780 n_6_5_2 n_6_5_3 305.0563370732411
R2781 n_6_5_3 n_7_5_3 87.03461828052458
R2782 n_6_5_3 n_6_6_3 146121.0125000004
R2783 n_6_5_3 n_6_5_4 2.8286250941170734
R2784 n_6_5_4 n_7_5_4 3.956119012751117
R2785 n_6_5_4 n_6_6_4 6641.864204545474
R2786 n_6_5_15 n_7_5_15 174.06923656104763
R2787 n_6_5_15 n_6_6_15 292242.0249999982
R2788 n_6_6_0 n_7_6_0 142.85714285714033
R2789 n_6_6_0 n_6_7_0 142.85714285714545
R2790 n_6_6_0 n_6_6_1 4124.999999999956
R2791 n_6_6_1 n_7_6_1 199.99999999999648
R2792 n_6_6_1 n_6_7_1 200.00000000000358
R2793 n_6_6_1 n_6_6_2 18124.999999999807
R2794 n_6_6_2 n_7_6_2 714.2857142857017
R2795 n_6_6_2 n_6_7_2 714.2857142857272
R2796 n_6_6_2 n_6_6_3 17524.999999999814
R2797 n_6_6_3 n_7_6_3 4999.999999999907
R2798 n_6_6_3 n_6_7_3 5000.000000000085
R2799 n_6_6_3 n_6_6_4 162.4999999999984
R2800 n_6_6_4 n_7_6_4 227.27272727272307
R2801 n_6_6_4 n_6_7_4 227.27272727273117
R2802 n_6_6_15 n_7_6_15 9999.999999999727
R2803 n_6_6_15 n_6_7_15 10000.000000000082
R2804 n_6_7_0 n_7_7_0 142.85714285714033
R2805 n_6_7_0 n_6_8_0 4174.8860714285875
R2806 n_6_7_0 n_6_7_1 4124.999999999956
R2807 n_6_7_1 n_7_7_1 199.99999999999648
R2808 n_6_7_1 n_6_8_1 5844.840500000022
R2809 n_6_7_1 n_6_7_2 18124.999999999807
R2810 n_6_7_2 n_7_7_2 714.2857142857017
R2811 n_6_7_2 n_6_8_2 20874.430357142934
R2812 n_6_7_2 n_6_7_3 17524.999999999814
R2813 n_6_7_3 n_7_7_3 4999.999999999907
R2814 n_6_7_3 n_6_8_3 146121.0125000004
R2815 n_6_7_3 n_6_7_4 162.4999999999984
R2816 n_6_7_4 n_7_7_4 227.27272727272307
R2817 n_6_7_4 n_6_8_4 6641.864204545474
R2818 n_6_7_15 n_7_7_15 9999.999999999727
R2819 n_6_7_15 n_6_8_15 292242.0249999982
R2820 n_6_8_0 n_7_8_0 2.486703379443562
R2821 n_6_8_0 n_6_9_0 8206.91500000003
R2822 n_6_8_0 n_6_8_1 71.80356008143335
R2823 n_6_8_1 n_7_8_1 3.4813847312209862
R2824 n_6_8_1 n_6_9_1 11489.68100000004
R2825 n_6_8_1 n_6_8_2 315.5004912669041
R2826 n_6_8_2 n_7_8_2 12.433516897217809
R2827 n_6_8_2 n_6_9_2 41034.57500000014
R2828 n_6_8_2 n_6_8_3 305.0563370732411
R2829 n_6_8_3 n_7_8_3 87.03461828052458
R2830 n_6_8_3 n_6_9_3 287242.0250000007
R2831 n_6_8_3 n_6_8_4 2.8286250941170734
R2832 n_6_8_4 n_7_8_4 3.956119012751117
R2833 n_6_8_4 n_6_9_4 13056.455681818217
R2834 n_6_8_15 n_7_8_15 174.06923656104763
R2835 n_6_8_15 n_6_9_15 574484.0499999963
R2836 n_6_9_0 n_7_9_0 2.486703379443562
R2837 n_6_9_0 n_6_10_0 4174.886084484207
R2838 n_6_9_0 n_6_9_1 71.80356008143335
R2839 n_6_9_1 n_7_9_1 3.4813847312209862
R2840 n_6_9_1 n_6_10_1 5844.840518277889
R2841 n_6_9_1 n_6_9_2 315.5004912669041
R2842 n_6_9_2 n_7_9_2 12.433516897217809
R2843 n_6_9_2 n_6_10_2 20874.43042242103
R2844 n_6_9_2 n_6_9_3 305.0563370732411
R2845 n_6_9_3 n_7_9_3 87.03461828052458
R2846 n_6_9_3 n_6_10_3 146121.01295694706
R2847 n_6_9_3 n_6_9_4 2.8286250941170734
R2848 n_6_9_4 n_7_9_4 3.956119012751117
R2849 n_6_9_4 n_6_10_4 6641.864225315777
R2850 n_6_9_15 n_7_9_15 174.06923656104763
R2851 n_6_9_15 n_6_10_15 292242.0259138915
R2852 n_6_10_0 n_7_10_0 142.85711674590752
R2853 n_6_10_0 n_6_11_0 142.8571689683805
R2854 n_6_10_0 n_6_10_1 4124.999246038108
R2855 n_6_10_1 n_7_10_1 199.99996344427046
R2856 n_6_10_1 n_6_11_1 200.00003655573266
R2857 n_6_10_1 n_6_10_2 18124.99668713714
R2858 n_6_10_2 n_7_10_2 714.2855837295376
R2859 n_6_10_2 n_6_11_2 714.2858448419024
R2860 n_6_10_2 n_6_10_3 17524.996796804324
R2861 n_6_10_3 n_7_10_3 4999.999086106757
R2862 n_6_10_3 n_6_11_3 5000.000913893312
R2863 n_6_10_3 n_6_10_4 162.49997029847106
R2864 n_6_10_4 n_7_10_4 227.27268573212538
R2865 n_6_10_4 n_6_11_4 227.2727688133324
R2866 n_6_10_15 n_7_10_15 9999.998172213425
R2867 n_6_10_15 n_6_11_15 10000.001827786535
R2868 n_6_11_0 n_7_11_0 142.85711674591258
R2869 n_6_11_0 n_6_12_0 1646.6785714285759
R2870 n_6_11_0 n_6_11_1 4124.999246038255
R2871 n_6_11_1 n_7_11_1 199.9999634442776
R2872 n_6_11_1 n_6_12_1 2305.3500000000054
R2873 n_6_11_1 n_6_11_2 18124.996687137784
R2874 n_6_11_2 n_7_11_2 714.2855837295629
R2875 n_6_11_2 n_6_12_2 8233.392857142877
R2876 n_6_11_2 n_6_11_3 17524.996796804946
R2877 n_6_11_3 n_7_11_3 4999.9990861069355
R2878 n_6_11_3 n_6_12_3 57633.75000000008
R2879 n_6_11_3 n_6_11_4 162.49997029847685
R2880 n_6_11_4 n_7_11_4 227.27268573213343
R2881 n_6_11_4 n_6_12_4 2619.715909090913
R2882 n_6_11_15 n_7_11_15 9999.998172213782
R2883 n_6_11_15 n_6_12_15 115267.49999999914
R2884 n_6_12_0 n_7_12_0 6.477753827788678
R2885 n_6_12_0 n_6_13_0 3150.499973888776
R2886 n_6_12_0 n_6_12_1 187.0451417773994
R2887 n_6_12_1 n_7_12_1 9.06885535890415
R2888 n_6_12_1 n_6_13_1 4410.6999634442855
R2889 n_6_12_1 n_6_12_2 821.8650169006943
R2890 n_6_12_2 n_7_12_2 32.38876913894339
R2891 n_6_12_2 n_6_13_2 15752.499869443878
R2892 n_6_12_2 n_6_12_3 794.6584508239816
R2893 n_6_12_3 n_7_12_3 226.7213839726035
R2894 n_6_12_3 n_6_13_3 110267.49908610703
R2895 n_6_12_3 n_6_12_4 7.368444979109681
R2896 n_6_12_4 n_7_12_4 10.30551745330016
R2897 n_6_12_4 n_6_13_4 5012.159049368502
R2898 n_6_12_4 n_6_12_5 6.450763186839611
R2899 n_6_12_5 n_7_12_5 43.18502551859115
R2900 n_6_12_5 n_6_13_5 21003.33315925848
R2901 n_6_12_5 n_6_12_6 1.5114758931507035
R2902 n_6_12_6 n_7_12_6 7.197504253098524
R2903 n_6_12_6 n_6_13_6 3500.5555265430808
R2904 n_6_12_6 n_6_12_7 2.051288712133095
R2905 n_6_12_7 n_7_12_7 12.338578719597509
R2906 n_6_12_7 n_6_13_7 6000.9523312167275
R2907 n_6_12_7 n_6_12_8 1.5114758931506986
R2908 n_6_12_8 n_7_12_8 12.338578719597509
R2909 n_6_12_8 n_6_13_8 6000.9523312167275
R2910 n_6_12_8 n_6_12_9 1.5114758931506986
R2911 n_6_12_9 n_7_12_9 12.338578719597509
R2912 n_6_12_9 n_6_13_9 6000.9523312167275
R2913 n_6_12_9 n_6_12_10 1.5114758931506986
R2914 n_6_12_10 n_7_12_10 12.338578719597509
R2915 n_6_12_10 n_6_13_10 6000.9523312167275
R2916 n_6_12_10 n_6_12_11 1.5114758931506889
R2917 n_6_12_11 n_7_12_11 12.338578719597669
R2918 n_6_12_11 n_6_13_11 6000.952331216805
R2919 n_6_12_11 n_6_12_12 1.5114758931506842
R2920 n_6_12_12 n_7_12_12 12.338578719597587
R2921 n_6_12_12 n_6_13_12 6000.952331216766
R2922 n_6_12_12 n_6_12_13 1.5114758931506986
R2923 n_6_12_13 n_7_12_13 12.338578719597432
R2924 n_6_12_13 n_6_13_13 6000.952331216689
R2925 n_6_12_13 n_6_12_14 7.557379465753512
R2926 n_6_12_14 n_7_12_14 1.370953191066387
R2927 n_6_12_14 n_6_13_14 666.7724812463018
R2928 n_6_12_14 n_6_12_15 233.5230254917857
R2929 n_6_12_15 n_7_12_15 453.442767945203
R2930 n_6_12_15 n_6_13_15 220534.9981722121
R2931 n_6_13_0 n_7_13_0 6.477753827788668
R2932 n_6_13_0 n_6_13_1 187.0451417773991
R2933 n_6_13_1 n_7_13_1 9.068855358904134
R2934 n_6_13_1 n_6_13_2 821.8650169006928
R2935 n_6_13_2 n_7_13_2 32.38876913894334
R2936 n_6_13_2 n_6_13_3 794.6584508239803
R2937 n_6_13_3 n_7_13_3 226.72138397260318
R2938 n_6_13_3 n_6_13_4 7.368444979109668
R2939 n_6_13_4 n_7_13_4 10.305517453300142
R2940 n_6_13_4 n_6_13_5 6.450763186839599
R2941 n_6_13_5 n_7_13_5 43.18502551859108
R2942 n_6_13_5 n_6_13_6 1.511475893150701
R2943 n_6_13_6 n_7_13_6 7.197504253098512
R2944 n_6_13_6 n_6_13_7 2.051288712133092
R2945 n_6_13_7 n_7_13_7 12.33857871959749
R2946 n_6_13_7 n_6_13_8 1.5114758931506962
R2947 n_6_13_8 n_7_13_8 12.33857871959749
R2948 n_6_13_8 n_6_13_9 1.5114758931506962
R2949 n_6_13_9 n_7_13_9 12.33857871959749
R2950 n_6_13_9 n_6_13_10 1.5114758931506962
R2951 n_6_13_10 n_7_13_10 12.33857871959749
R2952 n_6_13_10 n_6_13_11 1.5114758931506866
R2953 n_6_13_11 n_7_13_11 12.338578719597646
R2954 n_6_13_11 n_6_13_12 1.5114758931506818
R2955 n_6_13_12 n_7_13_12 12.33857871959757
R2956 n_6_13_12 n_6_13_13 1.5114758931506964
R2957 n_6_13_13 n_7_13_13 12.338578719597411
R2958 n_6_13_13 n_6_13_14 7.557379465753501
R2959 n_6_13_14 n_7_13_14 1.3709531910663846
R2960 n_6_13_14 n_6_13_15 233.5230254917853
R2961 n_6_13_15 n_7_13_15 453.44276794520226
R2962 n_7_0_0 n_8_0_0 125.67181420979057
R2963 n_7_0_0 n_7_1_0 3150.500245209352
R2964 n_7_0_0 n_7_0_1 187.04512566910162
R2965 n_7_0_1 n_8_0_1 175.94053989370676
R2966 n_7_0_1 n_7_1_1 4410.700343293092
R2967 n_7_0_1 n_7_0_2 821.86494612181
R2968 n_7_0_2 n_8_0_2 628.3590710489527
R2969 n_7_0_2 n_7_1_2 15752.50122604676
R2970 n_7_0_2 n_7_0_3 794.6583823881225
R2971 n_7_0_3 n_8_0_3 4398.513497342665
R2972 n_7_0_3 n_7_1_3 110267.5085823272
R2973 n_7_0_3 n_7_0_4 7.368444344540373
R2974 n_7_0_4 n_8_0_4 199.9324316973939
R2975 n_7_0_4 n_7_1_4 5012.159481014874
R2976 n_7_0_4 n_7_0_5 6.450762631300912
R2977 n_7_0_5 n_8_0_5 837.8120947319361
R2978 n_7_0_5 n_7_1_5 21003.334968062325
R2979 n_7_0_5 n_7_0_6 1.5114757629826405
R2980 n_7_0_6 n_8_0_6 139.63534912198938
R2981 n_7_0_6 n_7_1_6 3500.555828010388
R2982 n_7_0_6 n_7_0_7 2.0512885354764383
R2983 n_7_0_7 n_8_0_7 239.37488420912536
R2984 n_7_0_7 n_7_1_7 6000.952848017826
R2985 n_7_0_7 n_7_0_8 1.5114757629826359
R2986 n_7_0_8 n_8_0_8 239.37488420912536
R2987 n_7_0_8 n_7_1_8 6000.952848017826
R2988 n_7_0_8 n_7_0_9 1.5114757629826359
R2989 n_7_0_9 n_8_0_9 239.37488420912536
R2990 n_7_0_9 n_7_1_9 6000.952848017826
R2991 n_7_0_9 n_7_0_10 1.5114757629826359
R2992 n_7_0_10 n_8_0_10 239.37488420912536
R2993 n_7_0_10 n_7_1_10 6000.952848017826
R2994 n_7_0_10 n_7_0_11 1.5114757629826263
R2995 n_7_0_11 n_8_0_11 239.37488420912842
R2996 n_7_0_11 n_7_1_11 6000.952848017902
R2997 n_7_0_11 n_7_0_12 1.5114757629826214
R2998 n_7_0_12 n_8_0_12 239.37488420912698
R2999 n_7_0_12 n_7_1_12 6000.952848017864
R3000 n_7_0_12 n_7_0_13 1.511475762982636
R3001 n_7_0_13 n_8_0_13 239.37488420912388
R3002 n_7_0_13 n_7_1_13 6000.952848017788
R3003 n_7_0_13 n_7_0_14 7.557378814913198
R3004 n_7_0_14 n_8_0_14 26.59720935656943
R3005 n_7_0_14 n_7_1_14 666.772538668646
R3006 n_7_0_14 n_7_0_15 233.52300538082
R3007 n_7_0_15 n_8_0_15 8797.026994685253
R3008 n_7_0_15 n_7_1_15 220535.01716465247
R3009 n_7_1_0 n_8_1_0 125.67181420979057
R3010 n_7_1_0 n_7_2_0 1646.6785714285777
R3011 n_7_1_0 n_7_1_1 187.04512566910162
R3012 n_7_1_1 n_8_1_1 175.94053989370676
R3013 n_7_1_1 n_7_2_1 2305.3500000000085
R3014 n_7_1_1 n_7_1_2 821.86494612181
R3015 n_7_1_2 n_8_1_2 628.3590710489527
R3016 n_7_1_2 n_7_2_2 8233.392857142888
R3017 n_7_1_2 n_7_1_3 794.6583823881225
R3018 n_7_1_3 n_8_1_3 4398.513497342665
R3019 n_7_1_3 n_7_2_3 57633.750000000146
R3020 n_7_1_3 n_7_1_4 7.368444344540373
R3021 n_7_1_4 n_8_1_4 199.9324316973939
R3022 n_7_1_4 n_7_2_4 2619.7159090909163
R3023 n_7_1_4 n_7_1_5 6.450762631300912
R3024 n_7_1_5 n_8_1_5 837.8120947319361
R3025 n_7_1_5 n_7_1_6 1.5114757629826405
R3026 n_7_1_6 n_8_1_6 139.63534912198938
R3027 n_7_1_6 n_7_1_7 2.0512885354764383
R3028 n_7_1_7 n_8_1_7 239.37488420912536
R3029 n_7_1_7 n_7_1_8 1.5114757629826359
R3030 n_7_1_8 n_8_1_8 239.37488420912536
R3031 n_7_1_8 n_7_1_9 1.5114757629826359
R3032 n_7_1_9 n_8_1_9 239.37488420912536
R3033 n_7_1_9 n_7_1_10 1.5114757629826359
R3034 n_7_1_10 n_8_1_10 239.37488420912536
R3035 n_7_1_10 n_7_1_11 1.5114757629826263
R3036 n_7_1_11 n_8_1_11 239.37488420912842
R3037 n_7_1_11 n_7_1_12 1.5114757629826214
R3038 n_7_1_12 n_8_1_12 239.37488420912698
R3039 n_7_1_12 n_7_1_13 1.511475762982636
R3040 n_7_1_13 n_8_1_13 239.37488420912388
R3041 n_7_1_13 n_7_1_14 7.557378814913198
R3042 n_7_1_14 n_8_1_14 26.59720935656943
R3043 n_7_1_14 n_7_1_15 233.52300538082
R3044 n_7_1_15 n_8_1_15 8797.026994685253
R3045 n_7_1_15 n_7_2_15 115267.49999999929
R3046 n_7_2_0 n_8_2_0 2771.508327585035
R3047 n_7_2_0 n_7_3_0 142.8568976478031
R3048 n_7_2_0 n_7_2_1 4125.00708043187
R3049 n_7_2_1 n_8_2_1 3880.1116586190487
R3050 n_7_2_1 n_7_3_1 199.9996567069243
R3051 n_7_2_1 n_7_2_2 18125.03111098852
R3052 n_7_2_2 n_8_2_2 13857.541637925178
R3053 n_7_2_2 n_7_3_2 714.2844882390153
R3054 n_7_2_2 n_7_2_3 17525.03008110752
R3055 n_7_2_3 n_8_2_3 97002.79146547616
R3056 n_7_2_3 n_7_3_3 4999.991417673102
R3057 n_7_2_3 n_7_2_4 162.50027892610413
R3058 n_7_2_4 n_8_2_4 4409.217793885279
R3059 n_7_2_4 n_7_3_4 227.27233716695923
R3060 n_7_2_15 n_8_2_15 194005.58293095054
R3061 n_7_2_15 n_7_3_15 9999.982835346116
R3062 n_7_3_0 n_8_3_0 2771.508327585035
R3063 n_7_3_0 n_7_4_0 4174.885948823918
R3064 n_7_3_0 n_7_3_1 4125.00708043187
R3065 n_7_3_1 n_8_3_1 3880.1116586190487
R3066 n_7_3_1 n_7_4_1 5844.840328353484
R3067 n_7_3_1 n_7_3_2 18125.03111098852
R3068 n_7_3_2 n_8_3_2 13857.541637925178
R3069 n_7_3_2 n_7_4_2 20874.429744119585
R3070 n_7_3_2 n_7_3_3 17525.03008110752
R3071 n_7_3_3 n_8_3_3 97002.79146547616
R3072 n_7_3_3 n_7_4_3 146121.00820883695
R3073 n_7_3_3 n_7_3_4 162.50027892610413
R3074 n_7_3_4 n_8_3_4 4409.217793885279
R3075 n_7_3_4 n_7_4_4 6641.86400949259
R3076 n_7_3_15 n_8_3_15 194005.58293095054
R3077 n_7_3_15 n_7_4_15 292242.01641767134
R3078 n_7_4_0 n_8_4_0 48.24335106234774
R3079 n_7_4_0 n_7_5_0 8206.91500000003
R3080 n_7_4_0 n_7_4_1 71.80356008143332
R3081 n_7_4_1 n_8_4_1 67.54069148728685
R3082 n_7_4_1 n_7_5_1 11489.681000000042
R3083 n_7_4_1 n_7_4_2 315.50049126690396
R3084 n_7_4_2 n_8_4_2 241.21675531173875
R3085 n_7_4_2 n_7_5_2 41034.57500000015
R3086 n_7_4_2 n_7_4_3 305.05633707324097
R3087 n_7_4_3 n_8_4_3 1688.5172871821699
R3088 n_7_4_3 n_7_5_3 287242.0250000007
R3089 n_7_4_3 n_7_4_4 2.8286250941170725
R3090 n_7_4_4 n_8_4_4 76.75078578100772
R3091 n_7_4_4 n_7_5_4 13056.45568181822
R3092 n_7_4_15 n_8_4_15 3377.0345743643097
R3093 n_7_4_15 n_7_5_15 574484.0499999964
R3094 n_7_5_0 n_8_5_0 48.24335106234778
R3095 n_7_5_0 n_7_6_0 4174.8860714285875
R3096 n_7_5_0 n_7_5_1 71.80356008143335
R3097 n_7_5_1 n_8_5_1 67.54069148728688
R3098 n_7_5_1 n_7_6_1 5844.840500000022
R3099 n_7_5_1 n_7_5_2 315.5004912669041
R3100 n_7_5_2 n_8_5_2 241.21675531173886
R3101 n_7_5_2 n_7_6_2 20874.430357142934
R3102 n_7_5_2 n_7_5_3 305.0563370732411
R3103 n_7_5_3 n_8_5_3 1688.5172871821703
R3104 n_7_5_3 n_7_6_3 146121.0125000004
R3105 n_7_5_3 n_7_5_4 2.8286250941170734
R3106 n_7_5_4 n_8_5_4 76.75078578100775
R3107 n_7_5_4 n_7_6_4 6641.864204545474
R3108 n_7_5_15 n_8_5_15 3377.0345743643106
R3109 n_7_5_15 n_7_6_15 292242.0249999982
R3110 n_7_6_0 n_8_6_0 2771.503570386895
R3111 n_7_6_0 n_7_7_0 142.85714285714545
R3112 n_7_6_0 n_7_6_1 4124.999999999956
R3113 n_7_6_1 n_8_6_1 3880.1049985416525
R3114 n_7_6_1 n_7_7_1 200.00000000000358
R3115 n_7_6_1 n_7_6_2 18124.999999999807
R3116 n_7_6_2 n_8_6_2 13857.517851934475
R3117 n_7_6_2 n_7_7_2 714.2857142857272
R3118 n_7_6_2 n_7_6_3 17524.999999999814
R3119 n_7_6_3 n_8_6_3 97002.62496354122
R3120 n_7_6_3 n_7_7_3 5000.000000000085
R3121 n_7_6_3 n_7_6_4 162.4999999999984
R3122 n_7_6_4 n_8_6_4 4409.21022561551
R3123 n_7_6_4 n_7_7_4 227.27272727273117
R3124 n_7_6_15 n_8_6_15 194005.24992708073
R3125 n_7_6_15 n_7_7_15 10000.000000000082
R3126 n_7_7_0 n_8_7_0 2771.503570386895
R3127 n_7_7_0 n_7_8_0 4174.8860714285875
R3128 n_7_7_0 n_7_7_1 4124.999999999956
R3129 n_7_7_1 n_8_7_1 3880.1049985416525
R3130 n_7_7_1 n_7_8_1 5844.840500000022
R3131 n_7_7_1 n_7_7_2 18124.999999999807
R3132 n_7_7_2 n_8_7_2 13857.517851934475
R3133 n_7_7_2 n_7_8_2 20874.430357142934
R3134 n_7_7_2 n_7_7_3 17524.999999999814
R3135 n_7_7_3 n_8_7_3 97002.62496354122
R3136 n_7_7_3 n_7_8_3 146121.0125000004
R3137 n_7_7_3 n_7_7_4 162.4999999999984
R3138 n_7_7_4 n_8_7_4 4409.21022561551
R3139 n_7_7_4 n_7_8_4 6641.864204545474
R3140 n_7_7_15 n_8_7_15 194005.24992708073
R3141 n_7_7_15 n_7_8_15 292242.0249999982
R3142 n_7_8_0 n_8_8_0 48.24335106234778
R3143 n_7_8_0 n_7_9_0 8206.91500000003
R3144 n_7_8_0 n_7_8_1 71.80356008143335
R3145 n_7_8_1 n_8_8_1 67.54069148728688
R3146 n_7_8_1 n_7_9_1 11489.68100000004
R3147 n_7_8_1 n_7_8_2 315.5004912669041
R3148 n_7_8_2 n_8_8_2 241.21675531173886
R3149 n_7_8_2 n_7_9_2 41034.57500000014
R3150 n_7_8_2 n_7_8_3 305.0563370732411
R3151 n_7_8_3 n_8_8_3 1688.5172871821703
R3152 n_7_8_3 n_7_9_3 287242.0250000007
R3153 n_7_8_3 n_7_8_4 2.8286250941170734
R3154 n_7_8_4 n_8_8_4 76.75078578100775
R3155 n_7_8_4 n_7_9_4 13056.455681818217
R3156 n_7_8_15 n_8_8_15 3377.0345743643106
R3157 n_7_8_15 n_7_9_15 574484.0499999963
R3158 n_7_9_0 n_8_9_0 48.24335106234778
R3159 n_7_9_0 n_7_10_0 4174.886084484207
R3160 n_7_9_0 n_7_9_1 71.80356008143335
R3161 n_7_9_1 n_8_9_1 67.54069148728688
R3162 n_7_9_1 n_7_10_1 5844.840518277889
R3163 n_7_9_1 n_7_9_2 315.5004912669041
R3164 n_7_9_2 n_8_9_2 241.21675531173886
R3165 n_7_9_2 n_7_10_2 20874.43042242103
R3166 n_7_9_2 n_7_9_3 305.0563370732411
R3167 n_7_9_3 n_8_9_3 1688.5172871821703
R3168 n_7_9_3 n_7_10_3 146121.01295694706
R3169 n_7_9_3 n_7_9_4 2.8286250941170734
R3170 n_7_9_4 n_8_9_4 76.75078578100775
R3171 n_7_9_4 n_7_10_4 6641.864225315777
R3172 n_7_9_15 n_8_9_15 3377.0345743643106
R3173 n_7_9_15 n_7_10_15 292242.0259138915
R3174 n_7_10_0 n_8_10_0 2771.50306381527
R3175 n_7_10_0 n_7_11_0 142.8571689683805
R3176 n_7_10_0 n_7_10_1 4124.999246038108
R3177 n_7_10_1 n_8_10_1 3880.1042893413764
R3178 n_7_10_1 n_7_11_1 200.00003655573266
R3179 n_7_10_1 n_7_10_2 18124.99668713714
R3180 n_7_10_2 n_8_10_2 13857.51531907635
R3181 n_7_10_2 n_7_11_2 714.2858448419024
R3182 n_7_10_2 n_7_10_3 17524.996796804324
R3183 n_7_10_3 n_8_10_3 97002.60723353433
R3184 n_7_10_3 n_7_11_3 5000.000913893312
R3185 n_7_10_3 n_7_10_4 162.49997029847106
R3186 n_7_10_4 n_8_10_4 4409.209419706107
R3187 n_7_10_4 n_7_11_4 227.2727688133324
R3188 n_7_10_15 n_8_10_15 194005.21446706695
R3189 n_7_10_15 n_7_11_15 10000.001827786535
R3190 n_7_11_0 n_8_11_0 2771.5030638153676
R3191 n_7_11_0 n_7_12_0 1646.6785714285759
R3192 n_7_11_0 n_7_11_1 4124.999246038255
R3193 n_7_11_1 n_8_11_1 3880.1042893415147
R3194 n_7_11_1 n_7_12_1 2305.3500000000054
R3195 n_7_11_1 n_7_11_2 18124.996687137784
R3196 n_7_11_2 n_8_11_2 13857.51531907684
R3197 n_7_11_2 n_7_12_2 8233.392857142877
R3198 n_7_11_2 n_7_11_3 17524.996796804946
R3199 n_7_11_3 n_8_11_3 97002.60723353778
R3200 n_7_11_3 n_7_12_3 57633.75000000008
R3201 n_7_11_3 n_7_11_4 162.49997029847685
R3202 n_7_11_4 n_8_11_4 4409.209419706263
R3203 n_7_11_4 n_7_12_4 2619.715909090913
R3204 n_7_11_15 n_8_11_15 194005.21446707385
R3205 n_7_11_15 n_7_12_15 115267.49999999914
R3206 n_7_12_0 n_8_12_0 125.6718250326281
R3207 n_7_12_0 n_7_13_0 3150.499973888776
R3208 n_7_12_0 n_7_12_1 187.0451417773994
R3209 n_7_12_1 n_8_12_1 175.94055504567933
R3210 n_7_12_1 n_7_13_1 4410.6999634442855
R3211 n_7_12_1 n_7_12_2 821.8650169006943
R3212 n_7_12_2 n_8_12_2 628.3591251631404
R3213 n_7_12_2 n_7_13_2 15752.499869443878
R3214 n_7_12_2 n_7_12_3 794.6584508239816
R3215 n_7_12_3 n_8_12_3 4398.513876141978
R3216 n_7_12_3 n_7_13_3 110267.49908610703
R3217 n_7_12_3 n_7_12_4 7.368444979109681
R3218 n_7_12_4 n_8_12_4 199.9324489155445
R3219 n_7_12_4 n_7_13_4 5012.159049368502
R3220 n_7_12_4 n_7_12_5 6.450763186839611
R3221 n_7_12_5 n_8_12_5 837.8121668841864
R3222 n_7_12_5 n_7_13_5 21003.33315925848
R3223 n_7_12_5 n_7_12_6 1.5114758931507035
R3224 n_7_12_6 n_8_12_6 139.63536114736442
R3225 n_7_12_6 n_7_13_6 3500.5555265430808
R3226 n_7_12_6 n_7_12_7 2.051288712133095
R3227 n_7_12_7 n_8_12_7 239.37490482405403
R3228 n_7_12_7 n_7_13_7 6000.9523312167275
R3229 n_7_12_7 n_7_12_8 1.5114758931506986
R3230 n_7_12_8 n_8_12_8 239.37490482405403
R3231 n_7_12_8 n_7_13_8 6000.9523312167275
R3232 n_7_12_8 n_7_12_9 1.5114758931506986
R3233 n_7_12_9 n_8_12_9 239.37490482405403
R3234 n_7_12_9 n_7_13_9 6000.9523312167275
R3235 n_7_12_9 n_7_12_10 1.5114758931506986
R3236 n_7_12_10 n_8_12_10 239.37490482405403
R3237 n_7_12_10 n_7_13_10 6000.9523312167275
R3238 n_7_12_10 n_7_12_11 1.5114758931506889
R3239 n_7_12_11 n_8_12_11 239.37490482405713
R3240 n_7_12_11 n_7_13_11 6000.952331216805
R3241 n_7_12_11 n_7_12_12 1.5114758931506842
R3242 n_7_12_12 n_8_12_12 239.37490482405553
R3243 n_7_12_12 n_7_13_12 6000.952331216766
R3244 n_7_12_12 n_7_12_13 1.5114758931506986
R3245 n_7_12_13 n_8_12_13 239.37490482405252
R3246 n_7_12_13 n_7_13_13 6000.952331216689
R3247 n_7_12_13 n_7_12_14 7.557379465753512
R3248 n_7_12_14 n_8_12_14 26.597211647117057
R3249 n_7_12_14 n_7_13_14 666.7724812463018
R3250 n_7_12_14 n_7_12_15 233.5230254917857
R3251 n_7_12_15 n_8_12_15 8797.027752283879
R3252 n_7_12_15 n_7_13_15 220534.9981722121
R3253 n_7_13_0 n_8_13_0 125.67182503262788
R3254 n_7_13_0 n_7_13_1 187.0451417773991
R3255 n_7_13_1 n_8_13_1 175.94055504567902
R3256 n_7_13_1 n_7_13_2 821.8650169006928
R3257 n_7_13_2 n_8_13_2 628.3591251631395
R3258 n_7_13_2 n_7_13_3 794.6584508239803
R3259 n_7_13_3 n_8_13_3 4398.513876141972
R3260 n_7_13_3 n_7_13_4 7.368444979109668
R3261 n_7_13_4 n_8_13_4 199.93244891554414
R3262 n_7_13_4 n_7_13_5 6.450763186839599
R3263 n_7_13_5 n_8_13_5 837.8121668841852
R3264 n_7_13_5 n_7_13_6 1.511475893150701
R3265 n_7_13_6 n_8_13_6 139.63536114736416
R3266 n_7_13_6 n_7_13_7 2.051288712133092
R3267 n_7_13_7 n_8_13_7 239.3749048240536
R3268 n_7_13_7 n_7_13_8 1.5114758931506962
R3269 n_7_13_8 n_8_13_8 239.3749048240536
R3270 n_7_13_8 n_7_13_9 1.5114758931506962
R3271 n_7_13_9 n_8_13_9 239.3749048240536
R3272 n_7_13_9 n_7_13_10 1.5114758931506962
R3273 n_7_13_10 n_8_13_10 239.3749048240536
R3274 n_7_13_10 n_7_13_11 1.5114758931506866
R3275 n_7_13_11 n_8_13_11 239.37490482405667
R3276 n_7_13_11 n_7_13_12 1.5114758931506818
R3277 n_7_13_12 n_8_13_12 239.3749048240552
R3278 n_7_13_12 n_7_13_13 1.5114758931506964
R3279 n_7_13_13 n_8_13_13 239.37490482405212
R3280 n_7_13_13 n_7_13_14 7.557379465753501
R3281 n_7_13_14 n_8_13_14 26.59721164711701
R3282 n_7_13_14 n_7_13_15 233.5230254917853
R3283 n_7_13_15 n_8_13_15 8797.027752283864
R3284 n_8_0_0 n_9_0_0 244.86587514965558
R3285 n_8_0_0 n_8_1_0 83.34425224761597
R3286 n_8_0_0 n_8_0_1 4.9481463012603975
R3287 n_8_0_1 n_9_0_1 342.81222520951775
R3288 n_8_0_1 n_8_1_1 116.68195314666234
R3289 n_8_0_1 n_8_0_2 21.741854960083568
R3290 n_8_0_2 n_9_0_2 1224.3293757482777
R3291 n_8_0_2 n_8_1_2 416.72126123807976
R3292 n_8_0_2 n_8_0_3 21.022124588991147
R3293 n_8_0_3 n_9_0_3 8570.305630237935
R3294 n_8_0_3 n_8_1_3 2917.048828666556
R3295 n_8_0_3 n_8_0_4 0.19492697550419769
R3296 n_8_0_4 n_9_0_4 389.55934682899715
R3297 n_8_0_4 n_8_1_4 132.59312857575253
R3298 n_8_0_4 n_8_0_5 0.17065035584433424
R3299 n_8_0_5 n_9_0_5 1632.4391676643686
R3300 n_8_0_5 n_8_1_5 555.6283483174392
R3301 n_8_0_5 n_8_0_6 0.039985020616245676
R3302 n_8_0_6 n_9_0_6 272.07319461072814
R3303 n_8_0_6 n_8_1_6 92.6047247195732
R3304 n_8_0_6 n_8_0_7 0.05426538512204764
R3305 n_8_0_7 n_9_0_7 466.41119076124966
R3306 n_8_0_7 n_8_1_7 158.750956662126
R3307 n_8_0_7 n_8_0_8 0.03998502061624555
R3308 n_8_0_8 n_9_0_8 466.41119076124966
R3309 n_8_0_8 n_8_1_8 158.750956662126
R3310 n_8_0_8 n_8_0_9 0.03998502061624555
R3311 n_8_0_9 n_9_0_9 466.41119076124966
R3312 n_8_0_9 n_8_1_9 158.750956662126
R3313 n_8_0_9 n_8_0_10 0.03998502061624555
R3314 n_8_0_10 n_9_0_10 466.41119076124966
R3315 n_8_0_10 n_8_1_10 158.750956662126
R3316 n_8_0_10 n_8_0_11 0.039985020616245294
R3317 n_8_0_11 n_9_0_11 466.4111907612556
R3318 n_8_0_11 n_8_1_11 158.750956662128
R3319 n_8_0_11 n_8_0_12 0.03998502061624516
R3320 n_8_0_12 n_9_0_12 466.4111907612528
R3321 n_8_0_12 n_8_1_12 158.750956662127
R3322 n_8_0_12 n_8_0_13 0.03998502061624555
R3323 n_8_0_13 n_9_0_13 466.41119076124676
R3324 n_8_0_13 n_8_1_13 158.750956662125
R3325 n_8_0_13 n_8_0_14 0.19992510308122824
R3326 n_8_0_14 n_9_0_14 51.82346564013874
R3327 n_8_0_14 n_8_1_14 17.638995184680628
R3328 n_8_0_14 n_8_0_15 6.177685685210011
R3329 n_8_0_15 n_9_0_15 17140.61126047572
R3330 n_8_0_15 n_8_1_15 5834.09765733306
R3331 n_8_1_0 n_9_1_0 244.86587514965558
R3332 n_8_1_0 n_8_2_0 43.56171513923102
R3333 n_8_1_0 n_8_1_1 4.9481463012603975
R3334 n_8_1_1 n_9_1_1 342.81222520951775
R3335 n_8_1_1 n_8_2_1 60.986401194923424
R3336 n_8_1_1 n_8_1_2 21.741854960083568
R3337 n_8_1_2 n_9_1_2 1224.3293757482777
R3338 n_8_1_2 n_8_2_2 217.80857569615506
R3339 n_8_1_2 n_8_1_3 21.022124588991147
R3340 n_8_1_3 n_9_1_3 8570.305630237935
R3341 n_8_1_3 n_8_2_3 1524.660029873084
R3342 n_8_1_3 n_8_1_4 0.19492697550419769
R3343 n_8_1_4 n_9_1_4 389.55934682899715
R3344 n_8_1_4 n_8_2_4 69.30272863059473
R3345 n_8_1_4 n_8_1_5 0.17065035584433424
R3346 n_8_1_5 n_9_1_5 1632.4391676643686
R3347 n_8_1_5 n_8_1_6 0.039985020616245676
R3348 n_8_1_6 n_9_1_6 272.07319461072814
R3349 n_8_1_6 n_8_1_7 0.05426538512204764
R3350 n_8_1_7 n_9_1_7 466.41119076124966
R3351 n_8_1_7 n_8_1_8 0.03998502061624555
R3352 n_8_1_8 n_9_1_8 466.41119076124966
R3353 n_8_1_8 n_8_1_9 0.03998502061624555
R3354 n_8_1_9 n_9_1_9 466.41119076124966
R3355 n_8_1_9 n_8_1_10 0.03998502061624555
R3356 n_8_1_10 n_9_1_10 466.41119076124966
R3357 n_8_1_10 n_8_1_11 0.039985020616245294
R3358 n_8_1_11 n_9_1_11 466.4111907612556
R3359 n_8_1_11 n_8_1_12 0.03998502061624516
R3360 n_8_1_12 n_9_1_12 466.4111907612528
R3361 n_8_1_12 n_8_1_13 0.03998502061624555
R3362 n_8_1_13 n_9_1_13 466.41119076124676
R3363 n_8_1_13 n_8_1_14 0.19992510308122824
R3364 n_8_1_14 n_9_1_14 51.82346564013874
R3365 n_8_1_14 n_8_1_15 6.177685685210011
R3366 n_8_1_15 n_9_1_15 17140.61126047572
R3367 n_8_1_15 n_8_2_15 3049.3200597461414
R3368 n_8_2_0 n_9_2_0 5400.159267103167
R3369 n_8_2_0 n_8_3_0 3.779178030846075
R3370 n_8_2_0 n_8_2_1 109.12414025597714
R3371 n_8_2_1 n_9_2_1 7560.222973944433
R3372 n_8_2_1 n_8_3_1 5.290849243184504
R3373 n_8_2_1 n_8_2_2 479.4848587005056
R3374 n_8_2_2 n_9_2_2 27000.79633551584
R3375 n_8_2_2 n_8_3_2 18.895890154230372
R3376 n_8_2_2 n_8_2_3 463.6122564814544
R3377 n_8_2_3 n_9_2_3 189005.57434861068
R3378 n_8_2_3 n_8_3_3 132.2712310796125
R3379 n_8_2_3 n_8_2_4 4.29882976765971
R3380 n_8_2_4 n_9_2_4 8591.162470391393
R3381 n_8_2_4 n_8_3_4 6.012328685436931
R3382 n_8_2_15 n_9_2_15 378011.1486972179
R3383 n_8_2_15 n_8_3_15 264.5424621592227
R3384 n_8_3_0 n_9_3_0 5400.159267103167
R3385 n_8_3_0 n_8_4_0 110.4436503862854
R3386 n_8_3_0 n_8_3_1 109.12414025597714
R3387 n_8_3_1 n_9_3_1 7560.222973944433
R3388 n_8_3_1 n_8_4_1 154.62111054079952
R3389 n_8_3_1 n_8_3_2 479.4848587005056
R3390 n_8_3_2 n_9_3_2 27000.79633551584
R3391 n_8_3_2 n_8_4_2 552.218251931427
R3392 n_8_3_2 n_8_3_3 463.6122564814544
R3393 n_8_3_3 n_9_3_3 189005.57434861068
R3394 n_8_3_3 n_8_4_3 3865.527763519985
R3395 n_8_3_3 n_8_3_4 4.29882976765971
R3396 n_8_3_4 n_9_3_4 8591.162470391393
R3397 n_8_3_4 n_8_4_4 175.7058074327266
R3398 n_8_3_15 n_9_3_15 378011.1486972179
R3399 n_8_3_15 n_8_4_15 7731.055527039902
R3400 n_8_4_0 n_9_4_0 93.99999874525193
R3401 n_8_4_0 n_8_5_0 217.10812274172469
R3402 n_8_4_0 n_8_4_1 1.899512318021153
R3403 n_8_4_1 n_9_4_1 131.5999982433527
R3404 n_8_4_1 n_8_5_1 303.9513718384145
R3405 n_8_4_1 n_8_4_2 8.34634200342628
R3406 n_8_4_2 n_9_4_2 469.9999937262597
R3407 n_8_4_2 n_8_5_2 1085.5406137086234
R3408 n_8_4_2 n_8_4_3 8.070049302623202
R3409 n_8_4_3 n_9_4_3 3289.999956083815
R3410 n_8_4_3 n_8_5_3 7598.784295960357
R3411 n_8_4_3 n_8_4_4 0.07482927313416671
R3412 n_8_4_4 n_9_4_4 149.54545254926433
R3413 n_8_4_4 n_8_5_4 345.3992861800162
R3414 n_8_4_4 n_8_4_5 0.07482927313416671
R3415 n_8_4_5 n_9_4_5 3289.999956083815
R3416 n_8_4_5 n_8_5_5 7598.784295960357
R3417 n_8_4_5 n_8_4_6 0.14965854626833341
R3418 n_8_4_6 n_9_4_6 1096.6666520279384
R3419 n_8_4_6 n_8_5_6 2532.928098653452
R3420 n_8_4_6 n_8_4_7 0.2187317214691024
R3421 n_8_4_7 n_9_4_7 1879.999974905043
R3422 n_8_4_7 n_8_5_7 4342.162454834503
R3423 n_8_4_7 n_8_4_8 0.16117074213512778
R3424 n_8_4_8 n_9_4_8 1879.999974905043
R3425 n_8_4_8 n_8_5_8 4342.162454834503
R3426 n_8_4_8 n_8_4_9 0.16117074213512778
R3427 n_8_4_9 n_9_4_9 1879.999974905043
R3428 n_8_4_9 n_8_5_9 4342.162454834503
R3429 n_8_4_9 n_8_4_10 0.16117074213512778
R3430 n_8_4_10 n_9_4_10 1879.999974905043
R3431 n_8_4_10 n_8_5_10 4342.162454834503
R3432 n_8_4_10 n_8_4_11 0.16117074213512675
R3433 n_8_4_11 n_9_4_11 1879.999974905067
R3434 n_8_4_11 n_8_5_11 4342.162454834559
R3435 n_8_4_11 n_8_4_12 0.16117074213512622
R3436 n_8_4_12 n_9_4_12 1879.9999749050548
R3437 n_8_4_12 n_8_5_12 4342.162454834532
R3438 n_8_4_12 n_8_4_13 0.16117074213512778
R3439 n_8_4_13 n_9_4_13 1879.9999749050312
R3440 n_8_4_13 n_8_5_13 4342.162454834475
R3441 n_8_4_13 n_8_4_14 0.8058537106756409
R3442 n_8_4_14 n_9_4_14 208.88888610055994
R3443 n_8_4_14 n_8_5_14 482.4624949816105
R3444 n_8_4_14 n_8_4_15 3.0277075129670727
R3445 n_8_4_15 n_9_4_15 6579.999912167572
R3446 n_8_4_15 n_8_5_15 15197.568591920579
R3447 n_8_5_0 n_9_5_0 93.99999874525199
R3448 n_8_5_0 n_8_6_0 110.4436536297051
R3449 n_8_5_0 n_8_5_1 1.8995123180211535
R3450 n_8_5_1 n_9_5_1 131.59999824335276
R3451 n_8_5_1 n_8_6_1 154.6211150815871
R3452 n_8_5_1 n_8_5_2 8.346342003426281
R3453 n_8_5_2 n_9_5_2 469.9999937262599
R3454 n_8_5_2 n_8_6_2 552.2182681485253
R3455 n_8_5_2 n_8_5_3 8.070049302623204
R3456 n_8_5_3 n_9_5_3 3289.999956083816
R3457 n_8_5_3 n_8_6_3 3865.527877039674
R3458 n_8_5_3 n_8_5_4 0.07482927313416673
R3459 n_8_5_4 n_9_5_4 149.54545254926438
R3460 n_8_5_4 n_8_6_4 175.70581259271245
R3461 n_8_5_4 n_8_5_5 0.07482927313416673
R3462 n_8_5_5 n_9_5_5 3289.999956083816
R3463 n_8_5_5 n_8_5_6 0.14965854626833347
R3464 n_8_5_6 n_9_5_6 1096.6666520279387
R3465 n_8_5_6 n_8_5_7 0.2187317214691025
R3466 n_8_5_7 n_9_5_7 1879.999974905044
R3467 n_8_5_7 n_8_5_8 0.16117074213512783
R3468 n_8_5_8 n_9_5_8 1879.999974905044
R3469 n_8_5_8 n_8_5_9 0.16117074213512783
R3470 n_8_5_9 n_9_5_9 1879.999974905044
R3471 n_8_5_9 n_8_5_10 0.16117074213512783
R3472 n_8_5_10 n_9_5_10 1879.999974905044
R3473 n_8_5_10 n_8_5_11 0.1611707421351268
R3474 n_8_5_11 n_9_5_11 1879.999974905068
R3475 n_8_5_11 n_8_5_12 0.16117074213512628
R3476 n_8_5_12 n_9_5_12 1879.9999749050558
R3477 n_8_5_12 n_8_5_13 0.16117074213512783
R3478 n_8_5_13 n_9_5_13 1879.9999749050316
R3479 n_8_5_13 n_8_5_14 0.8058537106756412
R3480 n_8_5_14 n_9_5_14 208.88888610055997
R3481 n_8_5_14 n_8_5_15 3.027707512967073
R3482 n_8_5_15 n_9_5_15 6579.999912167574
R3483 n_8_5_15 n_8_6_15 7731.055754079281
R3484 n_8_6_0 n_9_6_0 5400.149997916649
R3485 n_8_6_0 n_8_7_0 3.7791845176855268
R3486 n_8_6_0 n_8_6_1 109.12395294816648
R3487 n_8_6_1 n_9_6_1 7560.209997083309
R3488 n_8_6_1 n_8_7_1 5.2908583247597365
R3489 n_8_6_1 n_8_6_2 479.4840356813375
R3490 n_8_6_2 n_9_6_2 27000.749989583248
R3491 n_8_6_2 n_8_7_2 18.89592258842763
R3492 n_8_6_2 n_8_6_3 463.6114607070587
R3493 n_8_6_3 n_9_6_3 189005.24992708254
R3494 n_8_6_3 n_8_7_3 132.2714581189933
R3495 n_8_6_3 n_8_6_4 4.298822388867168
R3496 n_8_6_4 n_9_6_4 8591.147723958298
R3497 n_8_6_4 n_8_7_4 6.012339005408786
R3498 n_8_6_15 n_9_6_15 378010.49985416175
R3499 n_8_6_15 n_8_7_15 264.5429162379843
R3500 n_8_7_0 n_9_7_0 5400.149997916649
R3501 n_8_7_0 n_8_8_0 110.4436536297051
R3502 n_8_7_0 n_8_7_1 109.12395294816648
R3503 n_8_7_1 n_9_7_1 7560.209997083309
R3504 n_8_7_1 n_8_8_1 154.6211150815871
R3505 n_8_7_1 n_8_7_2 479.4840356813375
R3506 n_8_7_2 n_9_7_2 27000.749989583248
R3507 n_8_7_2 n_8_8_2 552.2182681485253
R3508 n_8_7_2 n_8_7_3 463.6114607070587
R3509 n_8_7_3 n_9_7_3 189005.24992708254
R3510 n_8_7_3 n_8_8_3 3865.527877039674
R3511 n_8_7_3 n_8_7_4 4.298822388867168
R3512 n_8_7_4 n_9_7_4 8591.147723958298
R3513 n_8_7_4 n_8_8_4 175.70581259271245
R3514 n_8_7_15 n_9_7_15 378010.49985416175
R3515 n_8_7_15 n_8_8_15 7731.055754079281
R3516 n_8_8_0 n_9_8_0 93.99999874525199
R3517 n_8_8_0 n_8_9_0 217.10812274172466
R3518 n_8_8_0 n_8_8_1 1.8995123180211535
R3519 n_8_8_1 n_9_8_1 131.59999824335276
R3520 n_8_8_1 n_8_9_1 303.9513718384145
R3521 n_8_8_1 n_8_8_2 8.346342003426281
R3522 n_8_8_2 n_9_8_2 469.9999937262599
R3523 n_8_8_2 n_8_9_2 1085.5406137086231
R3524 n_8_8_2 n_8_8_3 8.070049302623204
R3525 n_8_8_3 n_9_8_3 3289.999956083816
R3526 n_8_8_3 n_8_9_3 7598.784295960355
R3527 n_8_8_3 n_8_8_4 0.07482927313416673
R3528 n_8_8_4 n_9_8_4 149.54545254926438
R3529 n_8_8_4 n_8_9_4 345.39928618001613
R3530 n_8_8_4 n_8_8_5 0.07482927313416673
R3531 n_8_8_5 n_9_8_5 3289.999956083816
R3532 n_8_8_5 n_8_9_5 7598.784295960355
R3533 n_8_8_5 n_8_8_6 0.14965854626833347
R3534 n_8_8_6 n_9_8_6 1096.6666520279387
R3535 n_8_8_6 n_8_9_6 2532.9280986534513
R3536 n_8_8_6 n_8_8_7 0.2187317214691025
R3537 n_8_8_7 n_9_8_7 1879.999974905044
R3538 n_8_8_7 n_8_9_7 4342.162454834503
R3539 n_8_8_7 n_8_8_8 0.16117074213512783
R3540 n_8_8_8 n_9_8_8 1879.999974905044
R3541 n_8_8_8 n_8_9_8 4342.162454834503
R3542 n_8_8_8 n_8_8_9 0.16117074213512783
R3543 n_8_8_9 n_9_8_9 1879.999974905044
R3544 n_8_8_9 n_8_9_9 4342.162454834503
R3545 n_8_8_9 n_8_8_10 0.16117074213512783
R3546 n_8_8_10 n_9_8_10 1879.999974905044
R3547 n_8_8_10 n_8_9_10 4342.162454834503
R3548 n_8_8_10 n_8_8_11 0.1611707421351268
R3549 n_8_8_11 n_9_8_11 1879.999974905068
R3550 n_8_8_11 n_8_9_11 4342.162454834558
R3551 n_8_8_11 n_8_8_12 0.16117074213512628
R3552 n_8_8_12 n_9_8_12 1879.9999749050558
R3553 n_8_8_12 n_8_9_12 4342.162454834531
R3554 n_8_8_12 n_8_8_13 0.16117074213512783
R3555 n_8_8_13 n_9_8_13 1879.9999749050316
R3556 n_8_8_13 n_8_9_13 4342.162454834474
R3557 n_8_8_13 n_8_8_14 0.8058537106756412
R3558 n_8_8_14 n_9_8_14 208.88888610055997
R3559 n_8_8_14 n_8_9_14 482.46249498161046
R3560 n_8_8_14 n_8_8_15 3.027707512967073
R3561 n_8_8_15 n_9_8_15 6579.999912167574
R3562 n_8_8_15 n_8_9_15 15197.568591920577
R3563 n_8_9_0 n_9_9_0 93.99999874525199
R3564 n_8_9_0 n_8_10_0 110.44365397508224
R3565 n_8_9_0 n_8_9_1 1.8995123180211535
R3566 n_8_9_1 n_9_9_1 131.59999824335276
R3567 n_8_9_1 n_8_10_1 154.62111556511513
R3568 n_8_9_1 n_8_9_2 8.346342003426281
R3569 n_8_9_2 n_9_9_2 469.9999937262599
R3570 n_8_9_2 n_8_10_2 552.2182698754111
R3571 n_8_9_2 n_8_9_3 8.070049302623204
R3572 n_8_9_3 n_9_9_3 3289.999956083816
R3573 n_8_9_3 n_8_10_3 3865.5278891278745
R3574 n_8_9_3 n_8_9_4 0.07482927313416673
R3575 n_8_9_4 n_9_9_4 149.54545254926438
R3576 n_8_9_4 n_8_10_4 175.7058131421761
R3577 n_8_9_4 n_8_9_5 0.07482927313416673
R3578 n_8_9_5 n_9_9_5 3289.999956083816
R3579 n_8_9_5 n_8_9_6 0.14965854626833347
R3580 n_8_9_6 n_9_9_6 1096.6666520279387
R3581 n_8_9_6 n_8_9_7 0.2187317214691025
R3582 n_8_9_7 n_9_9_7 1879.999974905044
R3583 n_8_9_7 n_8_9_8 0.16117074213512783
R3584 n_8_9_8 n_9_9_8 1879.999974905044
R3585 n_8_9_8 n_8_9_9 0.16117074213512783
R3586 n_8_9_9 n_9_9_9 1879.999974905044
R3587 n_8_9_9 n_8_9_10 0.16117074213512783
R3588 n_8_9_10 n_9_9_10 1879.999974905044
R3589 n_8_9_10 n_8_9_11 0.1611707421351268
R3590 n_8_9_11 n_9_9_11 1879.999974905068
R3591 n_8_9_11 n_8_9_12 0.16117074213512628
R3592 n_8_9_12 n_9_9_12 1879.9999749050558
R3593 n_8_9_12 n_8_9_13 0.16117074213512783
R3594 n_8_9_13 n_9_9_13 1879.9999749050316
R3595 n_8_9_13 n_8_9_14 0.8058537106756412
R3596 n_8_9_14 n_9_9_14 208.88888610055997
R3597 n_8_9_14 n_8_9_15 3.027707512967073
R3598 n_8_9_15 n_9_9_15 6579.999912167574
R3599 n_8_9_15 n_8_10_15 7731.055778255681
R3600 n_8_10_0 n_9_10_0 5400.149010884632
R3601 n_8_10_0 n_8_11_0 3.7791852084397535
R3602 n_8_10_0 n_8_10_1 109.12393300263983
R3603 n_8_10_1 n_9_10_1 7560.208615238483
R3604 n_8_10_1 n_8_11_1 5.2908592918156545
R3605 n_8_10_1 n_8_10_2 479.48394804190235
R3606 n_8_10_2 n_9_10_2 27000.74505442316
R3607 n_8_10_2 n_8_11_2 18.895926042198766
R3608 n_8_10_2 n_8_10_3 463.6113759687911
R3609 n_8_10_3 n_9_10_3 189005.21538096192
R3610 n_8_10_3 n_8_11_3 132.27148229539125
R3611 n_8_10_3 n_8_10_4 4.298821603134301
R3612 n_8_10_4 n_9_10_4 8591.146153680089
R3613 n_8_10_4 n_8_11_4 6.012340104335966
R3614 n_8_10_15 n_9_10_15 378010.43076192046
R3615 n_8_10_15 n_8_11_15 264.5429645907801
R3616 n_8_11_0 n_9_11_0 5400.149010884823
R3617 n_8_11_0 n_8_12_0 43.56171513923097
R3618 n_8_11_0 n_8_11_1 109.12393300264372
R3619 n_8_11_1 n_9_11_1 7560.208615238752
R3620 n_8_11_1 n_8_12_1 60.986401194923346
R3621 n_8_11_1 n_8_11_2 479.4839480419194
R3622 n_8_11_2 n_9_11_2 27000.745054424115
R3623 n_8_11_2 n_8_12_2 217.8085756961548
R3624 n_8_11_2 n_8_11_3 463.6113759688076
R3625 n_8_11_3 n_9_11_3 189005.21538096864
R3626 n_8_11_3 n_8_12_3 1524.6600298730823
R3627 n_8_11_3 n_8_11_4 4.298821603134454
R3628 n_8_11_4 n_9_11_4 8591.146153680393
R3629 n_8_11_4 n_8_12_4 69.30272863059466
R3630 n_8_11_15 n_9_11_15 378010.4307619339
R3631 n_8_11_15 n_8_12_15 3049.3200597461378
R3632 n_8_12_0 n_9_12_0 244.86589623746752
R3633 n_8_12_0 n_8_13_0 83.34424507002231
R3634 n_8_12_0 n_8_12_1 4.948146727394006
R3635 n_8_12_1 n_9_12_1 342.8122547324545
R3636 n_8_12_1 n_8_13_1 116.68194309803121
R3637 n_8_12_1 n_8_12_2 21.741856832488814
R3638 n_8_12_2 n_9_12_2 1224.3294811873375
R3639 n_8_12_2 n_8_13_2 416.7212253501115
R3640 n_8_12_2 n_8_12_3 21.022126399413324
R3641 n_8_12_3 n_9_12_3 8570.306368311352
R3642 n_8_12_3 n_8_13_3 2917.048577450778
R3643 n_8_12_3 n_8_12_4 0.19492699229127916
R3644 n_8_12_4 n_9_12_4 389.55938037778884
R3645 n_8_12_4 n_8_13_4 132.59311715685357
R3646 n_8_12_4 n_8_12_5 0.1706503705407169
R3647 n_8_12_5 n_9_12_5 1632.4393082497816
R3648 n_8_12_5 n_8_13_5 555.6283004668148
R3649 n_8_12_5 n_8_12_6 0.039985024059749574
R3650 n_8_12_6 n_9_12_6 272.0732180416303
R3651 n_8_12_6 n_8_13_6 92.60471674446913
R3652 n_8_12_6 n_8_12_7 0.05426538979537436
R3653 n_8_12_7 n_9_12_7 466.4112309285105
R3654 n_8_12_7 n_8_13_7 158.75094299051904
R3655 n_8_12_7 n_8_12_8 0.03998502405974945
R3656 n_8_12_8 n_9_12_8 466.4112309285105
R3657 n_8_12_8 n_8_13_8 158.75094299051904
R3658 n_8_12_8 n_8_12_9 0.03998502405974945
R3659 n_8_12_9 n_9_12_9 466.4112309285105
R3660 n_8_12_9 n_8_13_9 158.75094299051904
R3661 n_8_12_9 n_8_12_10 0.03998502405974945
R3662 n_8_12_10 n_9_12_10 466.4112309285105
R3663 n_8_12_10 n_8_13_10 158.75094299051904
R3664 n_8_12_10 n_8_12_11 0.0399850240597492
R3665 n_8_12_11 n_9_12_11 466.4112309285166
R3666 n_8_12_11 n_8_13_11 158.75094299052105
R3667 n_8_12_11 n_8_12_12 0.03998502405974907
R3668 n_8_12_12 n_9_12_12 466.4112309285135
R3669 n_8_12_12 n_8_13_12 158.75094299052006
R3670 n_8_12_12 n_8_12_13 0.03998502405974945
R3671 n_8_12_13 n_9_12_13 466.4112309285076
R3672 n_8_12_13 n_8_13_13 158.750942990518
R3673 n_8_12_13 n_8_12_14 0.19992512029874773
R3674 n_8_12_14 n_9_12_14 51.82347010316773
R3675 n_8_12_14 n_8_13_14 17.63899366561319
R3676 n_8_12_14 n_8_12_15 6.177686217231363
R3677 n_8_12_15 n_9_12_15 17140.612736622556
R3678 n_8_12_15 n_8_13_15 5834.097154901505
R3679 n_8_13_0 n_9_13_0 244.8658962374671
R3680 n_8_13_0 n_8_13_1 4.948146727393997
R3681 n_8_13_1 n_9_13_1 342.8122547324539
R3682 n_8_13_1 n_8_13_2 21.741856832488775
R3683 n_8_13_2 n_9_13_2 1224.3294811873357
R3684 n_8_13_2 n_8_13_3 21.022126399413285
R3685 n_8_13_3 n_9_13_3 8570.306368311341
R3686 n_8_13_3 n_8_13_4 0.19492699229127886
R3687 n_8_13_4 n_9_13_4 389.55938037778816
R3688 n_8_13_4 n_8_13_5 0.17065037054071666
R3689 n_8_13_5 n_9_13_5 1632.4393082497793
R3690 n_8_13_5 n_8_13_6 0.03998502405974951
R3691 n_8_13_6 n_9_13_6 272.07321804162984
R3692 n_8_13_6 n_8_13_7 0.05426538979537427
R3693 n_8_13_7 n_9_13_7 466.4112309285097
R3694 n_8_13_7 n_8_13_8 0.03998502405974938
R3695 n_8_13_8 n_9_13_8 466.4112309285097
R3696 n_8_13_8 n_8_13_9 0.03998502405974938
R3697 n_8_13_9 n_9_13_9 466.4112309285097
R3698 n_8_13_9 n_8_13_10 0.03998502405974938
R3699 n_8_13_10 n_9_13_10 466.4112309285097
R3700 n_8_13_10 n_8_13_11 0.03998502405974913
R3701 n_8_13_11 n_9_13_11 466.4112309285157
R3702 n_8_13_11 n_8_13_12 0.039985024059749
R3703 n_8_13_12 n_9_13_12 466.4112309285128
R3704 n_8_13_12 n_8_13_13 0.03998502405974938
R3705 n_8_13_13 n_9_13_13 466.4112309285068
R3706 n_8_13_13 n_8_13_14 0.1999251202987474
R3707 n_8_13_14 n_9_13_14 51.82347010316764
R3708 n_8_13_14 n_8_13_15 6.177686217231352
R3709 n_8_13_15 n_9_13_15 17140.612736622526
R3710 n_9_0_0 n_10_0_0 125.67181420979063
R3711 n_9_0_0 n_9_1_0 83.34425224761597
R3712 n_9_0_0 n_9_0_1 4.9481463012603975
R3713 n_9_0_1 n_10_0_1 175.94053989370684
R3714 n_9_0_1 n_9_1_1 116.68195314666234
R3715 n_9_0_1 n_9_0_2 21.741854960083568
R3716 n_9_0_2 n_10_0_2 628.3590710489531
R3717 n_9_0_2 n_9_1_2 416.72126123807976
R3718 n_9_0_2 n_9_0_3 21.022124588991147
R3719 n_9_0_3 n_10_0_3 4398.513497342667
R3720 n_9_0_3 n_9_1_3 2917.048828666556
R3721 n_9_0_3 n_9_0_4 0.19492697550419769
R3722 n_9_0_4 n_10_0_4 199.93243169739398
R3723 n_9_0_4 n_9_1_4 132.59312857575253
R3724 n_9_0_4 n_9_0_5 0.17065035584433424
R3725 n_9_0_5 n_10_0_5 837.8120947319364
R3726 n_9_0_5 n_9_1_5 555.6283483174392
R3727 n_9_0_5 n_9_0_6 0.039985020616245676
R3728 n_9_0_6 n_10_0_6 139.63534912198944
R3729 n_9_0_6 n_9_1_6 92.6047247195732
R3730 n_9_0_6 n_9_0_7 0.05426538512204764
R3731 n_9_0_7 n_10_0_7 239.37488420912547
R3732 n_9_0_7 n_9_1_7 158.750956662126
R3733 n_9_0_7 n_9_0_8 0.03998502061624555
R3734 n_9_0_8 n_10_0_8 239.37488420912547
R3735 n_9_0_8 n_9_1_8 158.750956662126
R3736 n_9_0_8 n_9_0_9 0.03998502061624555
R3737 n_9_0_9 n_10_0_9 239.37488420912547
R3738 n_9_0_9 n_9_1_9 158.750956662126
R3739 n_9_0_9 n_9_0_10 0.03998502061624555
R3740 n_9_0_10 n_10_0_10 239.37488420912547
R3741 n_9_0_10 n_9_1_10 158.750956662126
R3742 n_9_0_10 n_9_0_11 0.039985020616245294
R3743 n_9_0_11 n_10_0_11 239.37488420912854
R3744 n_9_0_11 n_9_1_11 158.750956662128
R3745 n_9_0_11 n_9_0_12 0.03998502061624516
R3746 n_9_0_12 n_10_0_12 239.3748842091271
R3747 n_9_0_12 n_9_1_12 158.750956662127
R3748 n_9_0_12 n_9_0_13 0.03998502061624555
R3749 n_9_0_13 n_10_0_13 239.374884209124
R3750 n_9_0_13 n_9_1_13 158.750956662125
R3751 n_9_0_13 n_9_0_14 0.19992510308122824
R3752 n_9_0_14 n_10_0_14 26.597209356569444
R3753 n_9_0_14 n_9_1_14 17.638995184680628
R3754 n_9_0_14 n_9_0_15 6.177685685210011
R3755 n_9_0_15 n_10_0_15 8797.026994685257
R3756 n_9_0_15 n_9_1_15 5834.09765733306
R3757 n_9_1_0 n_10_1_0 125.67181420979063
R3758 n_9_1_0 n_9_2_0 43.56171513923102
R3759 n_9_1_0 n_9_1_1 4.9481463012603975
R3760 n_9_1_1 n_10_1_1 175.94053989370684
R3761 n_9_1_1 n_9_2_1 60.986401194923424
R3762 n_9_1_1 n_9_1_2 21.741854960083568
R3763 n_9_1_2 n_10_1_2 628.3590710489531
R3764 n_9_1_2 n_9_2_2 217.80857569615506
R3765 n_9_1_2 n_9_1_3 21.022124588991147
R3766 n_9_1_3 n_10_1_3 4398.513497342667
R3767 n_9_1_3 n_9_2_3 1524.660029873084
R3768 n_9_1_3 n_9_1_4 0.19492697550419769
R3769 n_9_1_4 n_10_1_4 199.93243169739398
R3770 n_9_1_4 n_9_2_4 69.30272863059473
R3771 n_9_1_4 n_9_1_5 0.17065035584433424
R3772 n_9_1_5 n_10_1_5 837.8120947319364
R3773 n_9_1_5 n_9_1_6 0.039985020616245676
R3774 n_9_1_6 n_10_1_6 139.63534912198944
R3775 n_9_1_6 n_9_1_7 0.05426538512204764
R3776 n_9_1_7 n_10_1_7 239.37488420912547
R3777 n_9_1_7 n_9_1_8 0.03998502061624555
R3778 n_9_1_8 n_10_1_8 239.37488420912547
R3779 n_9_1_8 n_9_1_9 0.03998502061624555
R3780 n_9_1_9 n_10_1_9 239.37488420912547
R3781 n_9_1_9 n_9_1_10 0.03998502061624555
R3782 n_9_1_10 n_10_1_10 239.37488420912547
R3783 n_9_1_10 n_9_1_11 0.039985020616245294
R3784 n_9_1_11 n_10_1_11 239.37488420912854
R3785 n_9_1_11 n_9_1_12 0.03998502061624516
R3786 n_9_1_12 n_10_1_12 239.3748842091271
R3787 n_9_1_12 n_9_1_13 0.03998502061624555
R3788 n_9_1_13 n_10_1_13 239.374884209124
R3789 n_9_1_13 n_9_1_14 0.19992510308122824
R3790 n_9_1_14 n_10_1_14 26.597209356569444
R3791 n_9_1_14 n_9_1_15 6.177685685210011
R3792 n_9_1_15 n_10_1_15 8797.026994685257
R3793 n_9_1_15 n_9_2_15 3049.3200597461414
R3794 n_9_2_0 n_10_2_0 2771.5083275850366
R3795 n_9_2_0 n_9_3_0 3.779178030846075
R3796 n_9_2_0 n_9_2_1 109.12414025597714
R3797 n_9_2_1 n_10_2_1 3880.1116586190506
R3798 n_9_2_1 n_9_3_1 5.290849243184504
R3799 n_9_2_1 n_9_2_2 479.4848587005056
R3800 n_9_2_2 n_10_2_2 13857.541637925186
R3801 n_9_2_2 n_9_3_2 18.895890154230372
R3802 n_9_2_2 n_9_2_3 463.6122564814544
R3803 n_9_2_3 n_10_2_3 97002.7914654762
R3804 n_9_2_3 n_9_3_3 132.2712310796125
R3805 n_9_2_3 n_9_2_4 4.29882976765971
R3806 n_9_2_4 n_10_2_4 4409.217793885281
R3807 n_9_2_4 n_9_3_4 6.012328685436931
R3808 n_9_2_15 n_10_2_15 194005.58293095062
R3809 n_9_2_15 n_9_3_15 264.5424621592227
R3810 n_9_3_0 n_10_3_0 2771.5083275850366
R3811 n_9_3_0 n_9_4_0 110.4436503862854
R3812 n_9_3_0 n_9_3_1 109.12414025597714
R3813 n_9_3_1 n_10_3_1 3880.1116586190506
R3814 n_9_3_1 n_9_4_1 154.62111054079952
R3815 n_9_3_1 n_9_3_2 479.4848587005056
R3816 n_9_3_2 n_10_3_2 13857.541637925186
R3817 n_9_3_2 n_9_4_2 552.218251931427
R3818 n_9_3_2 n_9_3_3 463.6122564814544
R3819 n_9_3_3 n_10_3_3 97002.7914654762
R3820 n_9_3_3 n_9_4_3 3865.527763519985
R3821 n_9_3_3 n_9_3_4 4.29882976765971
R3822 n_9_3_4 n_10_3_4 4409.217793885281
R3823 n_9_3_4 n_9_4_4 175.7058074327266
R3824 n_9_3_15 n_10_3_15 194005.58293095062
R3825 n_9_3_15 n_9_4_15 7731.055527039902
R3826 n_9_4_0 n_10_4_0 48.24335106234777
R3827 n_9_4_0 n_9_5_0 217.10812274172469
R3828 n_9_4_0 n_9_4_1 1.899512318021153
R3829 n_9_4_1 n_10_4_1 67.54069148728688
R3830 n_9_4_1 n_9_5_1 303.9513718384145
R3831 n_9_4_1 n_9_4_2 8.34634200342628
R3832 n_9_4_2 n_10_4_2 241.21675531173884
R3833 n_9_4_2 n_9_5_2 1085.5406137086234
R3834 n_9_4_2 n_9_4_3 8.070049302623202
R3835 n_9_4_3 n_10_4_3 1688.5172871821705
R3836 n_9_4_3 n_9_5_3 7598.784295960357
R3837 n_9_4_3 n_9_4_4 0.07482927313416671
R3838 n_9_4_4 n_10_4_4 76.75078578100775
R3839 n_9_4_4 n_9_5_4 345.3992861800162
R3840 n_9_4_4 n_9_4_5 0.07482927313416671
R3841 n_9_4_5 n_9_5_5 7598.784295960357
R3842 n_9_4_5 n_9_4_6 0.14965854626833341
R3843 n_9_4_6 n_9_5_6 2532.928098653452
R3844 n_9_4_6 n_9_4_7 0.2187317214691024
R3845 n_9_4_7 n_9_5_7 4342.162454834503
R3846 n_9_4_7 n_9_4_8 0.16117074213512778
R3847 n_9_4_8 n_9_5_8 4342.162454834503
R3848 n_9_4_8 n_9_4_9 0.16117074213512778
R3849 n_9_4_9 n_9_5_9 4342.162454834503
R3850 n_9_4_9 n_9_4_10 0.16117074213512778
R3851 n_9_4_10 n_9_5_10 4342.162454834503
R3852 n_9_4_10 n_9_4_11 0.16117074213512675
R3853 n_9_4_11 n_9_5_11 4342.162454834559
R3854 n_9_4_11 n_9_4_12 0.16117074213512622
R3855 n_9_4_12 n_9_5_12 4342.162454834532
R3856 n_9_4_12 n_9_4_13 0.16117074213512778
R3857 n_9_4_13 n_9_5_13 4342.162454834475
R3858 n_9_4_13 n_9_4_14 0.8058537106756409
R3859 n_9_4_14 n_9_5_14 482.4624949816105
R3860 n_9_4_14 n_9_4_15 3.0277075129670727
R3861 n_9_4_15 n_10_4_15 3377.034574364311
R3862 n_9_4_15 n_9_5_15 15197.568591920579
R3863 n_9_5_0 n_10_5_0 48.2433510623478
R3864 n_9_5_0 n_9_6_0 110.4436536297051
R3865 n_9_5_0 n_9_5_1 1.8995123180211535
R3866 n_9_5_1 n_10_5_1 67.5406914872869
R3867 n_9_5_1 n_9_6_1 154.6211150815871
R3868 n_9_5_1 n_9_5_2 8.346342003426281
R3869 n_9_5_2 n_10_5_2 241.21675531173898
R3870 n_9_5_2 n_9_6_2 552.2182681485253
R3871 n_9_5_2 n_9_5_3 8.070049302623204
R3872 n_9_5_3 n_10_5_3 1688.517287182171
R3873 n_9_5_3 n_9_6_3 3865.527877039674
R3874 n_9_5_3 n_9_5_4 0.07482927313416673
R3875 n_9_5_4 n_10_5_4 76.75078578100778
R3876 n_9_5_4 n_9_6_4 175.70581259271245
R3877 n_9_5_4 n_9_5_5 0.07482927313416673
R3878 n_9_5_5 n_9_5_6 0.14965854626833347
R3879 n_9_5_6 n_9_5_7 0.2187317214691025
R3880 n_9_5_7 n_9_5_8 0.16117074213512783
R3881 n_9_5_8 n_9_5_9 0.16117074213512783
R3882 n_9_5_9 n_9_5_10 0.16117074213512783
R3883 n_9_5_10 n_9_5_11 0.1611707421351268
R3884 n_9_5_11 n_9_5_12 0.16117074213512628
R3885 n_9_5_12 n_9_5_13 0.16117074213512783
R3886 n_9_5_13 n_9_5_14 0.8058537106756412
R3887 n_9_5_14 n_9_5_15 3.027707512967073
R3888 n_9_5_15 n_10_5_15 3377.034574364312
R3889 n_9_5_15 n_9_6_15 7731.055754079281
R3890 n_9_6_0 n_10_6_0 2771.503570386896
R3891 n_9_6_0 n_9_7_0 3.7791845176855268
R3892 n_9_6_0 n_9_6_1 109.12395294816648
R3893 n_9_6_1 n_10_6_1 3880.1049985416544
R3894 n_9_6_1 n_9_7_1 5.2908583247597365
R3895 n_9_6_1 n_9_6_2 479.4840356813375
R3896 n_9_6_2 n_10_6_2 13857.51785193448
R3897 n_9_6_2 n_9_7_2 18.89592258842763
R3898 n_9_6_2 n_9_6_3 463.6114607070587
R3899 n_9_6_3 n_10_6_3 97002.62496354127
R3900 n_9_6_3 n_9_7_3 132.2714581189933
R3901 n_9_6_3 n_9_6_4 4.298822388867168
R3902 n_9_6_4 n_10_6_4 4409.210225615513
R3903 n_9_6_4 n_9_7_4 6.012339005408786
R3904 n_9_6_15 n_10_6_15 194005.24992708082
R3905 n_9_6_15 n_9_7_15 264.5429162379843
R3906 n_9_7_0 n_10_7_0 2771.503570386896
R3907 n_9_7_0 n_9_8_0 110.4436536297051
R3908 n_9_7_0 n_9_7_1 109.12395294816648
R3909 n_9_7_1 n_10_7_1 3880.1049985416544
R3910 n_9_7_1 n_9_8_1 154.6211150815871
R3911 n_9_7_1 n_9_7_2 479.4840356813375
R3912 n_9_7_2 n_10_7_2 13857.51785193448
R3913 n_9_7_2 n_9_8_2 552.2182681485253
R3914 n_9_7_2 n_9_7_3 463.6114607070587
R3915 n_9_7_3 n_10_7_3 97002.62496354127
R3916 n_9_7_3 n_9_8_3 3865.527877039674
R3917 n_9_7_3 n_9_7_4 4.298822388867168
R3918 n_9_7_4 n_10_7_4 4409.210225615513
R3919 n_9_7_4 n_9_8_4 175.70581259271245
R3920 n_9_7_15 n_10_7_15 194005.24992708082
R3921 n_9_7_15 n_9_8_15 7731.055754079281
R3922 n_9_8_0 n_10_8_0 48.2433510623478
R3923 n_9_8_0 n_9_9_0 217.10812274172466
R3924 n_9_8_0 n_9_8_1 1.8995123180211535
R3925 n_9_8_1 n_10_8_1 67.5406914872869
R3926 n_9_8_1 n_9_9_1 303.9513718384145
R3927 n_9_8_1 n_9_8_2 8.346342003426281
R3928 n_9_8_2 n_10_8_2 241.21675531173898
R3929 n_9_8_2 n_9_9_2 1085.5406137086231
R3930 n_9_8_2 n_9_8_3 8.070049302623204
R3931 n_9_8_3 n_10_8_3 1688.517287182171
R3932 n_9_8_3 n_9_9_3 7598.784295960355
R3933 n_9_8_3 n_9_8_4 0.07482927313416673
R3934 n_9_8_4 n_10_8_4 76.75078578100778
R3935 n_9_8_4 n_9_9_4 345.39928618001613
R3936 n_9_8_4 n_9_8_5 0.07482927313416673
R3937 n_9_8_5 n_9_9_5 7598.784295960355
R3938 n_9_8_5 n_9_8_6 0.14965854626833347
R3939 n_9_8_6 n_9_9_6 2532.9280986534513
R3940 n_9_8_6 n_9_8_7 0.2187317214691025
R3941 n_9_8_7 n_9_9_7 4342.162454834503
R3942 n_9_8_7 n_9_8_8 0.16117074213512783
R3943 n_9_8_8 n_9_9_8 4342.162454834503
R3944 n_9_8_8 n_9_8_9 0.16117074213512783
R3945 n_9_8_9 n_9_9_9 4342.162454834503
R3946 n_9_8_9 n_9_8_10 0.16117074213512783
R3947 n_9_8_10 n_9_9_10 4342.162454834503
R3948 n_9_8_10 n_9_8_11 0.1611707421351268
R3949 n_9_8_11 n_9_9_11 4342.162454834558
R3950 n_9_8_11 n_9_8_12 0.16117074213512628
R3951 n_9_8_12 n_9_9_12 4342.162454834531
R3952 n_9_8_12 n_9_8_13 0.16117074213512783
R3953 n_9_8_13 n_9_9_13 4342.162454834474
R3954 n_9_8_13 n_9_8_14 0.8058537106756412
R3955 n_9_8_14 n_9_9_14 482.46249498161046
R3956 n_9_8_14 n_9_8_15 3.027707512967073
R3957 n_9_8_15 n_10_8_15 3377.034574364312
R3958 n_9_8_15 n_9_9_15 15197.568591920577
R3959 n_9_9_0 n_10_9_0 48.2433510623478
R3960 n_9_9_0 n_9_10_0 110.44365397508224
R3961 n_9_9_0 n_9_9_1 1.8995123180211535
R3962 n_9_9_1 n_10_9_1 67.5406914872869
R3963 n_9_9_1 n_9_10_1 154.62111556511513
R3964 n_9_9_1 n_9_9_2 8.346342003426281
R3965 n_9_9_2 n_10_9_2 241.21675531173898
R3966 n_9_9_2 n_9_10_2 552.2182698754111
R3967 n_9_9_2 n_9_9_3 8.070049302623204
R3968 n_9_9_3 n_10_9_3 1688.517287182171
R3969 n_9_9_3 n_9_10_3 3865.5278891278745
R3970 n_9_9_3 n_9_9_4 0.07482927313416673
R3971 n_9_9_4 n_10_9_4 76.75078578100778
R3972 n_9_9_4 n_9_10_4 175.7058131421761
R3973 n_9_9_4 n_9_9_5 0.07482927313416673
R3974 n_9_9_5 n_9_9_6 0.14965854626833347
R3975 n_9_9_6 n_9_9_7 0.2187317214691025
R3976 n_9_9_7 n_9_9_8 0.16117074213512783
R3977 n_9_9_8 n_9_9_9 0.16117074213512783
R3978 n_9_9_9 n_9_9_10 0.16117074213512783
R3979 n_9_9_10 n_9_9_11 0.1611707421351268
R3980 n_9_9_11 n_9_9_12 0.16117074213512628
R3981 n_9_9_12 n_9_9_13 0.16117074213512783
R3982 n_9_9_13 n_9_9_14 0.8058537106756412
R3983 n_9_9_14 n_9_9_15 3.027707512967073
R3984 n_9_9_15 n_10_9_15 3377.034574364312
R3985 n_9_9_15 n_9_10_15 7731.055778255681
R3986 n_9_10_0 n_10_10_0 2771.503063815271
R3987 n_9_10_0 n_9_11_0 3.7791852084397535
R3988 n_9_10_0 n_9_10_1 109.12393300263983
R3989 n_9_10_1 n_10_10_1 3880.1042893413783
R3990 n_9_10_1 n_9_11_1 5.2908592918156545
R3991 n_9_10_1 n_9_10_2 479.48394804190235
R3992 n_9_10_2 n_10_10_2 13857.515319076356
R3993 n_9_10_2 n_9_11_2 18.895926042198766
R3994 n_9_10_2 n_9_10_3 463.6113759687911
R3995 n_9_10_3 n_10_10_3 97002.60723353438
R3996 n_9_10_3 n_9_11_3 132.27148229539125
R3997 n_9_10_3 n_9_10_4 4.298821603134301
R3998 n_9_10_4 n_10_10_4 4409.209419706109
R3999 n_9_10_4 n_9_11_4 6.012340104335966
R4000 n_9_10_15 n_10_10_15 194005.21446706704
R4001 n_9_10_15 n_9_11_15 264.5429645907801
R4002 n_9_11_0 n_10_11_0 2771.503063815369
R4003 n_9_11_0 n_9_12_0 43.56171513923097
R4004 n_9_11_0 n_9_11_1 109.12393300264372
R4005 n_9_11_1 n_10_11_1 3880.1042893415165
R4006 n_9_11_1 n_9_12_1 60.986401194923346
R4007 n_9_11_1 n_9_11_2 479.4839480419194
R4008 n_9_11_2 n_10_11_2 13857.515319076845
R4009 n_9_11_2 n_9_12_2 217.8085756961548
R4010 n_9_11_2 n_9_11_3 463.6113759688076
R4011 n_9_11_3 n_10_11_3 97002.60723353783
R4012 n_9_11_3 n_9_12_3 1524.6600298730823
R4013 n_9_11_3 n_9_11_4 4.298821603134454
R4014 n_9_11_4 n_10_11_4 4409.209419706265
R4015 n_9_11_4 n_9_12_4 69.30272863059466
R4016 n_9_11_15 n_10_11_15 194005.21446707394
R4017 n_9_11_15 n_9_12_15 3049.3200597461378
R4018 n_9_12_0 n_10_12_0 125.67182503262816
R4019 n_9_12_0 n_9_13_0 83.34424507002231
R4020 n_9_12_0 n_9_12_1 4.948146727394006
R4021 n_9_12_1 n_10_12_1 175.94055504567942
R4022 n_9_12_1 n_9_13_1 116.68194309803121
R4023 n_9_12_1 n_9_12_2 21.741856832488814
R4024 n_9_12_2 n_10_12_2 628.3591251631407
R4025 n_9_12_2 n_9_13_2 416.7212253501115
R4026 n_9_12_2 n_9_12_3 21.022126399413324
R4027 n_9_12_3 n_10_12_3 4398.51387614198
R4028 n_9_12_3 n_9_13_3 2917.048577450778
R4029 n_9_12_3 n_9_12_4 0.19492699229127916
R4030 n_9_12_4 n_10_12_4 199.9324489155446
R4031 n_9_12_4 n_9_13_4 132.59311715685357
R4032 n_9_12_4 n_9_12_5 0.1706503705407169
R4033 n_9_12_5 n_10_12_5 837.8121668841867
R4034 n_9_12_5 n_9_13_5 555.6283004668148
R4035 n_9_12_5 n_9_12_6 0.039985024059749574
R4036 n_9_12_6 n_10_12_6 139.63536114736448
R4037 n_9_12_6 n_9_13_6 92.60471674446913
R4038 n_9_12_6 n_9_12_7 0.05426538979537436
R4039 n_9_12_7 n_10_12_7 239.3749048240541
R4040 n_9_12_7 n_9_13_7 158.75094299051904
R4041 n_9_12_7 n_9_12_8 0.03998502405974945
R4042 n_9_12_8 n_10_12_8 239.3749048240541
R4043 n_9_12_8 n_9_13_8 158.75094299051904
R4044 n_9_12_8 n_9_12_9 0.03998502405974945
R4045 n_9_12_9 n_10_12_9 239.3749048240541
R4046 n_9_12_9 n_9_13_9 158.75094299051904
R4047 n_9_12_9 n_9_12_10 0.03998502405974945
R4048 n_9_12_10 n_10_12_10 239.3749048240541
R4049 n_9_12_10 n_9_13_10 158.75094299051904
R4050 n_9_12_10 n_9_12_11 0.0399850240597492
R4051 n_9_12_11 n_10_12_11 239.37490482405724
R4052 n_9_12_11 n_9_13_11 158.75094299052105
R4053 n_9_12_11 n_9_12_12 0.03998502405974907
R4054 n_9_12_12 n_10_12_12 239.37490482405565
R4055 n_9_12_12 n_9_13_12 158.75094299052006
R4056 n_9_12_12 n_9_12_13 0.03998502405974945
R4057 n_9_12_13 n_10_12_13 239.37490482405263
R4058 n_9_12_13 n_9_13_13 158.750942990518
R4059 n_9_12_13 n_9_12_14 0.19992512029874773
R4060 n_9_12_14 n_10_12_14 26.59721164711707
R4061 n_9_12_14 n_9_13_14 17.63899366561319
R4062 n_9_12_14 n_9_12_15 6.177686217231363
R4063 n_9_12_15 n_10_12_15 8797.027752283884
R4064 n_9_12_15 n_9_13_15 5834.097154901505
R4065 n_9_13_0 n_10_13_0 125.67182503262794
R4066 n_9_13_0 n_9_13_1 4.948146727393997
R4067 n_9_13_1 n_10_13_1 175.94055504567908
R4068 n_9_13_1 n_9_13_2 21.741856832488775
R4069 n_9_13_2 n_10_13_2 628.3591251631398
R4070 n_9_13_2 n_9_13_3 21.022126399413285
R4071 n_9_13_3 n_10_13_3 4398.513876141974
R4072 n_9_13_3 n_9_13_4 0.19492699229127886
R4073 n_9_13_4 n_10_13_4 199.93244891554423
R4074 n_9_13_4 n_9_13_5 0.17065037054071666
R4075 n_9_13_5 n_10_13_5 837.8121668841856
R4076 n_9_13_5 n_9_13_6 0.03998502405974951
R4077 n_9_13_6 n_10_13_6 139.63536114736425
R4078 n_9_13_6 n_9_13_7 0.05426538979537427
R4079 n_9_13_7 n_10_13_7 239.37490482405371
R4080 n_9_13_7 n_9_13_8 0.03998502405974938
R4081 n_9_13_8 n_10_13_8 239.37490482405371
R4082 n_9_13_8 n_9_13_9 0.03998502405974938
R4083 n_9_13_9 n_10_13_9 239.37490482405371
R4084 n_9_13_9 n_9_13_10 0.03998502405974938
R4085 n_9_13_10 n_10_13_10 239.37490482405371
R4086 n_9_13_10 n_9_13_11 0.03998502405974913
R4087 n_9_13_11 n_10_13_11 239.37490482405678
R4088 n_9_13_11 n_9_13_12 0.039985024059749
R4089 n_9_13_12 n_10_13_12 239.37490482405528
R4090 n_9_13_12 n_9_13_13 0.03998502405974938
R4091 n_9_13_13 n_10_13_13 239.37490482405224
R4092 n_9_13_13 n_9_13_14 0.1999251202987474
R4093 n_9_13_14 n_10_13_14 26.59721164711702
R4094 n_9_13_14 n_9_13_15 6.177686217231352
R4095 n_9_13_15 n_10_13_15 8797.027752283868
R4096 n_10_0_0 n_11_0_0 6.4777532699256675
R4097 n_10_0_0 n_10_1_0 3150.5002452092954
R4098 n_10_0_0 n_10_0_1 187.0451256690983
R4099 n_10_0_1 n_11_0_1 9.068854577895932
R4100 n_10_0_1 n_10_1_1 4410.700343293014
R4101 n_10_0_1 n_10_0_2 821.8649461217955
R4102 n_10_0_2 n_11_0_2 32.388766349628334
R4103 n_10_0_2 n_10_1_2 15752.50122604648
R4104 n_10_0_2 n_10_0_3 794.6583823881084
R4105 n_10_0_3 n_11_0_3 226.7213644473981
R4106 n_10_0_3 n_10_1_3 110267.50858232524
R4107 n_10_0_3 n_10_0_4 7.368444344540243
R4108 n_10_0_4 n_11_0_4 10.305516565790823
R4109 n_10_0_4 n_10_1_4 5012.159481014784
R4110 n_10_0_4 n_10_0_5 6.450762631300798
R4111 n_10_0_5 n_11_0_5 43.1850217995044
R4112 n_10_0_5 n_10_1_5 21003.33496806195
R4113 n_10_0_5 n_10_0_6 1.5114757629826137
R4114 n_10_0_6 n_11_0_6 7.197503633250734
R4115 n_10_0_6 n_10_1_6 3500.5558280103255
R4116 n_10_0_6 n_10_0_7 2.051288535476402
R4117 n_10_0_7 n_11_0_7 12.338577657001295
R4118 n_10_0_7 n_10_1_7 6000.95284801772
R4119 n_10_0_7 n_10_0_8 1.511475762982609
R4120 n_10_0_8 n_11_0_8 12.338577657001295
R4121 n_10_0_8 n_10_1_8 6000.95284801772
R4122 n_10_0_8 n_10_0_9 1.511475762982609
R4123 n_10_0_9 n_11_0_9 12.338577657001295
R4124 n_10_0_9 n_10_1_9 6000.95284801772
R4125 n_10_0_9 n_10_0_10 1.511475762982609
R4126 n_10_0_10 n_11_0_10 12.338577657001295
R4127 n_10_0_10 n_10_1_10 6000.95284801772
R4128 n_10_0_10 n_10_0_11 1.5114757629825992
R4129 n_10_0_11 n_11_0_11 12.338577657001453
R4130 n_10_0_11 n_10_1_11 6000.952848017796
R4131 n_10_0_11 n_10_0_12 1.5114757629825943
R4132 n_10_0_12 n_11_0_12 12.338577657001379
R4133 n_10_0_12 n_10_1_12 6000.952848017758
R4134 n_10_0_12 n_10_0_13 1.511475762982609
R4135 n_10_0_13 n_11_0_13 12.338577657001219
R4136 n_10_0_13 n_10_1_13 6000.952848017681
R4137 n_10_0_13 n_10_0_14 7.557378814913063
R4138 n_10_0_14 n_11_0_14 1.3709530730001411
R4139 n_10_0_14 n_10_1_14 666.7725386686341
R4140 n_10_0_14 n_10_0_15 233.52300538081585
R4141 n_10_0_15 n_11_0_15 453.4427288947922
R4142 n_10_0_15 n_10_1_15 220535.01716464857
R4143 n_10_1_0 n_11_1_0 6.4777532699256675
R4144 n_10_1_0 n_10_2_0 1646.678571428548
R4145 n_10_1_0 n_10_1_1 187.0451256690983
R4146 n_10_1_1 n_11_1_1 9.068854577895932
R4147 n_10_1_1 n_10_2_1 2305.3499999999676
R4148 n_10_1_1 n_10_1_2 821.8649461217955
R4149 n_10_1_2 n_11_1_2 32.388766349628334
R4150 n_10_1_2 n_10_2_2 8233.39285714274
R4151 n_10_1_2 n_10_1_3 794.6583823881084
R4152 n_10_1_3 n_11_1_3 226.7213644473981
R4153 n_10_1_3 n_10_2_3 57633.74999999913
R4154 n_10_1_3 n_10_1_4 7.368444344540243
R4155 n_10_1_4 n_11_1_4 10.305516565790823
R4156 n_10_1_4 n_10_2_4 2619.71590909087
R4157 n_10_1_4 n_10_1_5 6.450762631300798
R4158 n_10_1_5 n_11_1_5 43.1850217995044
R4159 n_10_1_5 n_10_1_6 1.5114757629826137
R4160 n_10_1_6 n_11_1_6 7.197503633250734
R4161 n_10_1_6 n_10_1_7 2.051288535476402
R4162 n_10_1_7 n_11_1_7 12.338577657001295
R4163 n_10_1_7 n_10_1_8 1.511475762982609
R4164 n_10_1_8 n_11_1_8 12.338577657001295
R4165 n_10_1_8 n_10_1_9 1.511475762982609
R4166 n_10_1_9 n_11_1_9 12.338577657001295
R4167 n_10_1_9 n_10_1_10 1.511475762982609
R4168 n_10_1_10 n_11_1_10 12.338577657001295
R4169 n_10_1_10 n_10_1_11 1.5114757629825992
R4170 n_10_1_11 n_11_1_11 12.338577657001453
R4171 n_10_1_11 n_10_1_12 1.5114757629825943
R4172 n_10_1_12 n_11_1_12 12.338577657001379
R4173 n_10_1_12 n_10_1_13 1.511475762982609
R4174 n_10_1_13 n_11_1_13 12.338577657001219
R4175 n_10_1_13 n_10_1_14 7.557378814913063
R4176 n_10_1_14 n_11_1_14 1.3709530730001411
R4177 n_10_1_14 n_10_1_15 233.52300538081585
R4178 n_10_1_15 n_11_1_15 453.4427288947922
R4179 n_10_1_15 n_10_2_15 115267.49999999725
R4180 n_10_2_0 n_11_2_0 142.85738806690614
R4181 n_10_2_0 n_10_3_0 142.8568976478005
R4182 n_10_2_0 n_10_2_1 4125.007080431797
R4183 n_10_2_1 n_11_2_1 200.00034329366855
R4184 n_10_2_1 n_10_3_1 199.99965670692075
R4185 n_10_2_1 n_10_2_2 18125.0311109882
R4186 n_10_2_2 n_11_2_2 714.2869403345308
R4187 n_10_2_2 n_10_3_2 714.2844882390027
R4188 n_10_2_2 n_10_2_3 17525.03008110721
R4189 n_10_2_3 n_11_2_3 5000.00858234171
R4190 n_10_2_3 n_10_3_3 4999.9914176730135
R4191 n_10_2_3 n_10_2_4 162.50027892610123
R4192 n_10_2_4 n_11_2_4 227.2731173791686
R4193 n_10_2_4 n_10_3_4 227.2723371669552
R4194 n_10_2_15 n_11_2_15 10000.01716468333
R4195 n_10_2_15 n_10_3_15 9999.98283534594
R4196 n_10_3_0 n_11_3_0 142.85738806690614
R4197 n_10_3_0 n_10_4_0 4174.885948823842
R4198 n_10_3_0 n_10_3_1 4125.007080431797
R4199 n_10_3_1 n_11_3_1 200.00034329366855
R4200 n_10_3_1 n_10_4_1 5844.84032835338
R4201 n_10_3_1 n_10_3_2 18125.0311109882
R4202 n_10_3_2 n_11_3_2 714.2869403345308
R4203 n_10_3_2 n_10_4_2 20874.429744119218
R4204 n_10_3_2 n_10_3_3 17525.03008110721
R4205 n_10_3_3 n_11_3_3 5000.00858234171
R4206 n_10_3_3 n_10_4_3 146121.00820883436
R4207 n_10_3_3 n_10_3_4 162.50027892610123
R4208 n_10_3_4 n_11_3_4 227.2731173791686
R4209 n_10_3_4 n_10_4_4 6641.864009492471
R4210 n_10_3_15 n_11_3_15 10000.01716468333
R4211 n_10_3_15 n_10_4_15 292242.01641766616
R4212 n_10_4_0 n_11_4_0 2.4867033794436044
R4213 n_10_4_0 n_10_5_0 8206.914999999884
R4214 n_10_4_0 n_10_4_1 71.80356008143205
R4215 n_10_4_1 n_11_4_1 3.4813847312210466
R4216 n_10_4_1 n_10_5_1 11489.680999999837
R4217 n_10_4_1 n_10_4_2 315.5004912668984
R4218 n_10_4_2 n_11_4_2 12.433516897218023
R4219 n_10_4_2 n_10_5_2 41034.57499999942
R4220 n_10_4_2 n_10_4_3 305.05633707323557
R4221 n_10_4_3 n_11_4_3 87.03461828052609
R4222 n_10_4_3 n_10_5_3 287242.02499999566
R4223 n_10_4_3 n_10_4_4 2.828625094117023
R4224 n_10_4_4 n_11_4_4 3.956119012751186
R4225 n_10_4_4 n_10_5_4 13056.455681817986
R4226 n_10_4_15 n_11_4_15 174.06923656105064
R4227 n_10_4_15 n_10_5_15 574484.0499999863
R4228 n_10_5_0 n_11_5_0 2.486703379443606
R4229 n_10_5_0 n_10_6_0 4174.886071428513
R4230 n_10_5_0 n_10_5_1 71.80356008143207
R4231 n_10_5_1 n_11_5_1 3.481384731221048
R4232 n_10_5_1 n_10_6_1 5844.8404999999175
R4233 n_10_5_1 n_10_5_2 315.5004912668985
R4234 n_10_5_2 n_11_5_2 12.433516897218029
R4235 n_10_5_2 n_10_6_2 20874.430357142566
R4236 n_10_5_2 n_10_5_3 305.0563370732357
R4237 n_10_5_3 n_11_5_3 87.03461828052613
R4238 n_10_5_3 n_10_6_3 146121.0124999978
R4239 n_10_5_3 n_10_5_4 2.8286250941170237
R4240 n_10_5_4 n_11_5_4 3.956119012751188
R4241 n_10_5_4 n_10_6_4 6641.864204545356
R4242 n_10_5_15 n_11_5_15 174.0692365610507
R4243 n_10_5_15 n_10_6_15 292242.02499999304
R4244 n_10_6_0 n_11_6_0 142.85714285714286
R4245 n_10_6_0 n_10_7_0 142.85714285714286
R4246 n_10_6_0 n_10_6_1 4124.999999999883
R4247 n_10_6_1 n_11_6_1 200.00000000000003
R4248 n_10_6_1 n_10_7_1 200.00000000000003
R4249 n_10_6_1 n_10_6_2 18124.999999999483
R4250 n_10_6_2 n_11_6_2 714.2857142857144
R4251 n_10_6_2 n_10_7_2 714.2857142857144
R4252 n_10_6_2 n_10_6_3 17524.9999999995
R4253 n_10_6_3 n_11_6_3 4999.999999999996
R4254 n_10_6_3 n_10_7_3 4999.999999999996
R4255 n_10_6_3 n_10_6_4 162.49999999999554
R4256 n_10_6_4 n_11_6_4 227.2727272727271
R4257 n_10_6_4 n_10_7_4 227.2727272727271
R4258 n_10_6_15 n_11_6_15 9999.999999999904
R4259 n_10_6_15 n_10_7_15 9999.999999999904
R4260 n_10_7_0 n_11_7_0 142.85714285714286
R4261 n_10_7_0 n_10_8_0 4174.886071428513
R4262 n_10_7_0 n_10_7_1 4124.999999999883
R4263 n_10_7_1 n_11_7_1 200.00000000000003
R4264 n_10_7_1 n_10_8_1 5844.8404999999175
R4265 n_10_7_1 n_10_7_2 18124.999999999483
R4266 n_10_7_2 n_11_7_2 714.2857142857144
R4267 n_10_7_2 n_10_8_2 20874.430357142566
R4268 n_10_7_2 n_10_7_3 17524.9999999995
R4269 n_10_7_3 n_11_7_3 4999.999999999996
R4270 n_10_7_3 n_10_8_3 146121.0124999978
R4271 n_10_7_3 n_10_7_4 162.49999999999554
R4272 n_10_7_4 n_11_7_4 227.2727272727271
R4273 n_10_7_4 n_10_8_4 6641.864204545356
R4274 n_10_7_15 n_11_7_15 9999.999999999904
R4275 n_10_7_15 n_10_8_15 292242.02499999304
R4276 n_10_8_0 n_11_8_0 2.486703379443606
R4277 n_10_8_0 n_10_9_0 8206.914999999883
R4278 n_10_8_0 n_10_8_1 71.80356008143207
R4279 n_10_8_1 n_11_8_1 3.481384731221048
R4280 n_10_8_1 n_10_9_1 11489.680999999835
R4281 n_10_8_1 n_10_8_2 315.5004912668985
R4282 n_10_8_2 n_11_8_2 12.433516897218029
R4283 n_10_8_2 n_10_9_2 41034.574999999415
R4284 n_10_8_2 n_10_8_3 305.0563370732357
R4285 n_10_8_3 n_11_8_3 87.03461828052613
R4286 n_10_8_3 n_10_9_3 287242.0249999956
R4287 n_10_8_3 n_10_8_4 2.8286250941170237
R4288 n_10_8_4 n_11_8_4 3.956119012751188
R4289 n_10_8_4 n_10_9_4 13056.455681817984
R4290 n_10_8_15 n_11_8_15 174.0692365610507
R4291 n_10_8_15 n_10_9_15 574484.0499999862
R4292 n_10_9_0 n_11_9_0 2.486703379443606
R4293 n_10_9_0 n_10_10_0 4174.886084484132
R4294 n_10_9_0 n_10_9_1 71.80356008143207
R4295 n_10_9_1 n_11_9_1 3.481384731221048
R4296 n_10_9_1 n_10_10_1 5844.840518277784
R4297 n_10_9_1 n_10_9_2 315.5004912668985
R4298 n_10_9_2 n_11_9_2 12.433516897218029
R4299 n_10_9_2 n_10_10_2 20874.430422420657
R4300 n_10_9_2 n_10_9_3 305.0563370732357
R4301 n_10_9_3 n_11_9_3 87.03461828052613
R4302 n_10_9_3 n_10_10_3 146121.01295694447
R4303 n_10_9_3 n_10_9_4 2.8286250941170237
R4304 n_10_9_4 n_11_9_4 3.956119012751188
R4305 n_10_9_4 n_10_10_4 6641.864225315659
R4306 n_10_9_15 n_11_9_15 174.0692365610507
R4307 n_10_9_15 n_10_10_15 292242.0259138864
R4308 n_10_10_0 n_11_10_0 142.85711674591005
R4309 n_10_10_0 n_10_11_0 142.85716896837795
R4310 n_10_10_0 n_10_10_1 4124.9992460380345
R4311 n_10_10_1 n_11_10_1 199.99996344427402
R4312 n_10_10_1 n_10_11_1 200.0000365557291
R4313 n_10_10_1 n_10_10_2 18124.99668713682
R4314 n_10_10_2 n_11_10_2 714.2855837295502
R4315 n_10_10_2 n_10_11_2 714.2858448418897
R4316 n_10_10_2 n_10_10_3 17524.996796804015
R4317 n_10_10_3 n_11_10_3 4999.999086106846
R4318 n_10_10_3 n_10_11_3 5000.000913893224
R4319 n_10_10_3 n_10_10_4 162.49997029846818
R4320 n_10_10_4 n_11_10_4 227.27268573212942
R4321 n_10_10_4 n_10_11_4 227.27276881332836
R4322 n_10_10_15 n_11_10_15 9999.998172213604
R4323 n_10_10_15 n_10_11_15 10000.00182778636
R4324 n_10_11_0 n_11_11_0 142.8571167459151
R4325 n_10_11_0 n_10_12_0 1646.678571428546
R4326 n_10_11_0 n_10_11_1 4124.999246038181
R4327 n_10_11_1 n_11_11_1 199.99996344428115
R4328 n_10_11_1 n_10_12_1 2305.3499999999644
R4329 n_10_11_1 n_10_11_2 18124.99668713746
R4330 n_10_11_2 n_11_11_2 714.2855837295756
R4331 n_10_11_2 n_10_12_2 8233.392857142731
R4332 n_10_11_2 n_10_11_3 17524.996796804633
R4333 n_10_11_3 n_11_11_3 4999.999086107024
R4334 n_10_11_3 n_10_12_3 57633.74999999906
R4335 n_10_11_3 n_10_11_4 162.49997029847395
R4336 n_10_11_4 n_11_11_4 227.27268573213746
R4337 n_10_11_4 n_10_12_4 2619.7159090908667
R4338 n_10_11_15 n_11_11_15 9999.998172213958
R4339 n_10_11_15 n_10_12_15 115267.4999999971
R4340 n_10_12_0 n_11_12_0 6.477753827788794
R4341 n_10_12_0 n_10_13_0 3150.499973888719
R4342 n_10_12_0 n_10_12_1 187.04514177739605
R4343 n_10_12_1 n_11_12_1 9.06885535890431
R4344 n_10_12_1 n_10_13_1 4410.699963444207
R4345 n_10_12_1 n_10_12_2 821.8650169006796
R4346 n_10_12_2 n_11_12_2 32.388769138943964
R4347 n_10_12_2 n_10_13_2 15752.499869443598
R4348 n_10_12_2 n_10_12_3 794.6584508239675
R4349 n_10_12_3 n_11_12_3 226.72138397260753
R4350 n_10_12_3 n_10_13_3 110267.49908610508
R4351 n_10_12_3 n_10_12_4 7.368444979109548
R4352 n_10_12_4 n_11_12_4 10.305517453300343
R4353 n_10_12_4 n_10_13_4 5012.1590493684125
R4354 n_10_12_4 n_10_12_5 6.450763186839494
R4355 n_10_12_5 n_11_12_5 43.185025518591914
R4356 n_10_12_5 n_10_13_5 21003.33315925811
R4357 n_10_12_5 n_10_12_6 1.5114758931506769
R4358 n_10_12_6 n_11_12_6 7.197504253098652
R4359 n_10_12_6 n_10_13_6 3500.5555265430185
R4360 n_10_12_6 n_10_12_7 2.0512887121330587
R4361 n_10_12_7 n_11_12_7 12.338578719597729
R4362 n_10_12_7 n_10_13_7 6000.952331216622
R4363 n_10_12_7 n_10_12_8 1.511475893150672
R4364 n_10_12_8 n_11_12_8 12.338578719597729
R4365 n_10_12_8 n_10_13_8 6000.952331216622
R4366 n_10_12_8 n_10_12_9 1.511475893150672
R4367 n_10_12_9 n_11_12_9 12.338578719597729
R4368 n_10_12_9 n_10_13_9 6000.952331216622
R4369 n_10_12_9 n_10_12_10 1.511475893150672
R4370 n_10_12_10 n_11_12_10 12.338578719597729
R4371 n_10_12_10 n_10_13_10 6000.952331216622
R4372 n_10_12_10 n_10_12_11 1.5114758931506622
R4373 n_10_12_11 n_11_12_11 12.338578719597889
R4374 n_10_12_11 n_10_13_11 6000.9523312166975
R4375 n_10_12_11 n_10_12_12 1.5114758931506573
R4376 n_10_12_12 n_11_12_12 12.338578719597805
R4377 n_10_12_12 n_10_13_12 6000.95233121666
R4378 n_10_12_12 n_10_12_13 1.511475893150672
R4379 n_10_12_13 n_11_12_13 12.33857871959765
R4380 n_10_12_13 n_10_13_13 6000.952331216584
R4381 n_10_12_13 n_10_12_14 7.557379465753378
R4382 n_10_12_14 n_11_12_14 1.3709531910664112
R4383 n_10_12_14 n_10_13_14 666.7724812462898
R4384 n_10_12_14 n_10_12_15 233.52302549178157
R4385 n_10_12_15 n_11_12_15 453.4427679452111
R4386 n_10_12_15 n_10_13_15 220534.9981722082
R4387 n_10_13_0 n_11_13_0 6.477753827788782
R4388 n_10_13_0 n_10_13_1 187.04514177739577
R4389 n_10_13_1 n_11_13_1 9.068855358904296
R4390 n_10_13_1 n_10_13_2 821.8650169006784
R4391 n_10_13_2 n_11_13_2 32.388769138943914
R4392 n_10_13_2 n_10_13_3 794.6584508239663
R4393 n_10_13_3 n_11_13_3 226.72138397260719
R4394 n_10_13_3 n_10_13_4 7.368444979109538
R4395 n_10_13_4 n_11_13_4 10.305517453300325
R4396 n_10_13_4 n_10_13_5 6.4507631868394855
R4397 n_10_13_5 n_11_13_5 43.18502551859185
R4398 n_10_13_5 n_10_13_6 1.511475893150674
R4399 n_10_13_6 n_11_13_6 7.19750425309864
R4400 n_10_13_6 n_10_13_7 2.051288712133055
R4401 n_10_13_7 n_11_13_7 12.338578719597708
R4402 n_10_13_7 n_10_13_8 1.5114758931506693
R4403 n_10_13_8 n_11_13_8 12.338578719597708
R4404 n_10_13_8 n_10_13_9 1.5114758931506693
R4405 n_10_13_9 n_11_13_9 12.338578719597708
R4406 n_10_13_9 n_10_13_10 1.5114758931506693
R4407 n_10_13_10 n_11_13_10 12.338578719597708
R4408 n_10_13_10 n_10_13_11 1.5114758931506596
R4409 n_10_13_11 n_11_13_11 12.338578719597864
R4410 n_10_13_11 n_10_13_12 1.5114758931506547
R4411 n_10_13_12 n_11_13_12 12.338578719597788
R4412 n_10_13_12 n_10_13_13 1.5114758931506693
R4413 n_10_13_13 n_11_13_13 12.33857871959763
R4414 n_10_13_13 n_10_13_14 7.557379465753366
R4415 n_10_13_14 n_11_13_14 1.370953191066409
R4416 n_10_13_14 n_10_13_15 233.52302549178117
R4417 n_10_13_15 n_11_13_15 453.4427679452103
R4418 n_11_0_0 n_12_0_0 125.67181420979068
R4419 n_11_0_0 n_11_1_0 3150.5002452092954
R4420 n_11_0_0 n_11_0_1 187.0451256690983
R4421 n_11_0_1 n_12_0_1 175.9405398937069
R4422 n_11_0_1 n_11_1_1 4410.700343293014
R4423 n_11_0_1 n_11_0_2 821.8649461217955
R4424 n_11_0_2 n_12_0_2 628.3590710489534
R4425 n_11_0_2 n_11_1_2 15752.50122604648
R4426 n_11_0_2 n_11_0_3 794.6583823881084
R4427 n_11_0_3 n_12_0_3 4398.513497342668
R4428 n_11_0_3 n_11_1_3 110267.50858232524
R4429 n_11_0_3 n_11_0_4 7.368444344540243
R4430 n_11_0_4 n_12_0_4 199.93243169739407
R4431 n_11_0_4 n_11_1_4 5012.159481014784
R4432 n_11_0_4 n_11_0_5 6.450762631300798
R4433 n_11_0_5 n_12_0_5 837.8120947319369
R4434 n_11_0_5 n_11_1_5 21003.33496806195
R4435 n_11_0_5 n_11_0_6 1.5114757629826137
R4436 n_11_0_6 n_12_0_6 139.6353491219895
R4437 n_11_0_6 n_11_1_6 3500.5558280103255
R4438 n_11_0_6 n_11_0_7 2.051288535476402
R4439 n_11_0_7 n_12_0_7 239.37488420912558
R4440 n_11_0_7 n_11_1_7 6000.95284801772
R4441 n_11_0_7 n_11_0_8 1.511475762982609
R4442 n_11_0_8 n_12_0_8 239.37488420912558
R4443 n_11_0_8 n_11_1_8 6000.95284801772
R4444 n_11_0_8 n_11_0_9 1.511475762982609
R4445 n_11_0_9 n_12_0_9 239.37488420912558
R4446 n_11_0_9 n_11_1_9 6000.95284801772
R4447 n_11_0_9 n_11_0_10 1.511475762982609
R4448 n_11_0_10 n_12_0_10 239.37488420912558
R4449 n_11_0_10 n_11_1_10 6000.95284801772
R4450 n_11_0_10 n_11_0_11 1.5114757629825992
R4451 n_11_0_11 n_12_0_11 239.37488420912865
R4452 n_11_0_11 n_11_1_11 6000.952848017796
R4453 n_11_0_11 n_11_0_12 1.5114757629825943
R4454 n_11_0_12 n_12_0_12 239.3748842091272
R4455 n_11_0_12 n_11_1_12 6000.952848017758
R4456 n_11_0_12 n_11_0_13 1.511475762982609
R4457 n_11_0_13 n_12_0_13 239.3748842091241
R4458 n_11_0_13 n_11_1_13 6000.952848017681
R4459 n_11_0_13 n_11_0_14 7.557378814913063
R4460 n_11_0_14 n_12_0_14 26.597209356569458
R4461 n_11_0_14 n_11_1_14 666.7725386686341
R4462 n_11_0_14 n_11_0_15 233.52300538081585
R4463 n_11_0_15 n_12_0_15 8797.02699468526
R4464 n_11_0_15 n_11_1_15 220535.01716464857
R4465 n_11_1_0 n_12_1_0 125.67181420979068
R4466 n_11_1_0 n_11_2_0 1646.678571428548
R4467 n_11_1_0 n_11_1_1 187.0451256690983
R4468 n_11_1_1 n_12_1_1 175.9405398937069
R4469 n_11_1_1 n_11_2_1 2305.3499999999676
R4470 n_11_1_1 n_11_1_2 821.8649461217955
R4471 n_11_1_2 n_12_1_2 628.3590710489534
R4472 n_11_1_2 n_11_2_2 8233.39285714274
R4473 n_11_1_2 n_11_1_3 794.6583823881084
R4474 n_11_1_3 n_12_1_3 4398.513497342668
R4475 n_11_1_3 n_11_2_3 57633.74999999913
R4476 n_11_1_3 n_11_1_4 7.368444344540243
R4477 n_11_1_4 n_12_1_4 199.93243169739407
R4478 n_11_1_4 n_11_2_4 2619.71590909087
R4479 n_11_1_4 n_11_1_5 6.450762631300798
R4480 n_11_1_5 n_12_1_5 837.8120947319369
R4481 n_11_1_5 n_11_1_6 1.5114757629826137
R4482 n_11_1_6 n_12_1_6 139.6353491219895
R4483 n_11_1_6 n_11_1_7 2.051288535476402
R4484 n_11_1_7 n_12_1_7 239.37488420912558
R4485 n_11_1_7 n_11_1_8 1.511475762982609
R4486 n_11_1_8 n_12_1_8 239.37488420912558
R4487 n_11_1_8 n_11_1_9 1.511475762982609
R4488 n_11_1_9 n_12_1_9 239.37488420912558
R4489 n_11_1_9 n_11_1_10 1.511475762982609
R4490 n_11_1_10 n_12_1_10 239.37488420912558
R4491 n_11_1_10 n_11_1_11 1.5114757629825992
R4492 n_11_1_11 n_12_1_11 239.37488420912865
R4493 n_11_1_11 n_11_1_12 1.5114757629825943
R4494 n_11_1_12 n_12_1_12 239.3748842091272
R4495 n_11_1_12 n_11_1_13 1.511475762982609
R4496 n_11_1_13 n_12_1_13 239.3748842091241
R4497 n_11_1_13 n_11_1_14 7.557378814913063
R4498 n_11_1_14 n_12_1_14 26.597209356569458
R4499 n_11_1_14 n_11_1_15 233.52300538081585
R4500 n_11_1_15 n_12_1_15 8797.02699468526
R4501 n_11_1_15 n_11_2_15 115267.49999999725
R4502 n_11_2_0 n_12_2_0 2771.508327585038
R4503 n_11_2_0 n_11_3_0 142.8568976478005
R4504 n_11_2_0 n_11_2_1 4125.007080431797
R4505 n_11_2_1 n_12_2_1 3880.1116586190524
R4506 n_11_2_1 n_11_3_1 199.99965670692075
R4507 n_11_2_1 n_11_2_2 18125.0311109882
R4508 n_11_2_2 n_12_2_2 13857.541637925193
R4509 n_11_2_2 n_11_3_2 714.2844882390027
R4510 n_11_2_2 n_11_2_3 17525.03008110721
R4511 n_11_2_3 n_12_2_3 97002.79146547624
R4512 n_11_2_3 n_11_3_3 4999.9914176730135
R4513 n_11_2_3 n_11_2_4 162.50027892610123
R4514 n_11_2_4 n_12_2_4 4409.217793885283
R4515 n_11_2_4 n_11_3_4 227.2723371669552
R4516 n_11_2_15 n_12_2_15 194005.5829309507
R4517 n_11_2_15 n_11_3_15 9999.98283534594
R4518 n_11_3_0 n_12_3_0 2771.508327585038
R4519 n_11_3_0 n_11_4_0 4174.885948823842
R4520 n_11_3_0 n_11_3_1 4125.007080431797
R4521 n_11_3_1 n_12_3_1 3880.1116586190524
R4522 n_11_3_1 n_11_4_1 5844.84032835338
R4523 n_11_3_1 n_11_3_2 18125.0311109882
R4524 n_11_3_2 n_12_3_2 13857.541637925193
R4525 n_11_3_2 n_11_4_2 20874.429744119218
R4526 n_11_3_2 n_11_3_3 17525.03008110721
R4527 n_11_3_3 n_12_3_3 97002.79146547624
R4528 n_11_3_3 n_11_4_3 146121.00820883436
R4529 n_11_3_3 n_11_3_4 162.50027892610123
R4530 n_11_3_4 n_12_3_4 4409.217793885283
R4531 n_11_3_4 n_11_4_4 6641.864009492471
R4532 n_11_3_15 n_12_3_15 194005.5829309507
R4533 n_11_3_15 n_11_4_15 292242.01641766616
R4534 n_11_4_0 n_12_4_0 48.24335106234779
R4535 n_11_4_0 n_11_5_0 8206.914999999884
R4536 n_11_4_0 n_11_4_1 71.80356008143205
R4537 n_11_4_1 n_12_4_1 67.54069148728692
R4538 n_11_4_1 n_11_5_1 11489.680999999837
R4539 n_11_4_1 n_11_4_2 315.5004912668984
R4540 n_11_4_2 n_12_4_2 241.21675531173895
R4541 n_11_4_2 n_11_5_2 41034.57499999942
R4542 n_11_4_2 n_11_4_3 305.05633707323557
R4543 n_11_4_3 n_12_4_3 1688.5172871821712
R4544 n_11_4_3 n_11_5_3 287242.02499999566
R4545 n_11_4_3 n_11_4_4 2.828625094117023
R4546 n_11_4_4 n_12_4_4 76.75078578100778
R4547 n_11_4_4 n_11_5_4 13056.455681817986
R4548 n_11_4_15 n_12_4_15 3377.0345743643124
R4549 n_11_4_15 n_11_5_15 574484.0499999863
R4550 n_11_5_0 n_12_5_0 48.24335106234782
R4551 n_11_5_0 n_11_6_0 4174.886071428513
R4552 n_11_5_0 n_11_5_1 71.80356008143207
R4553 n_11_5_1 n_12_5_1 67.54069148728694
R4554 n_11_5_1 n_11_6_1 5844.8404999999175
R4555 n_11_5_1 n_11_5_2 315.5004912668985
R4556 n_11_5_2 n_12_5_2 241.21675531173906
R4557 n_11_5_2 n_11_6_2 20874.430357142566
R4558 n_11_5_2 n_11_5_3 305.0563370732357
R4559 n_11_5_3 n_12_5_3 1688.517287182172
R4560 n_11_5_3 n_11_6_3 146121.0124999978
R4561 n_11_5_3 n_11_5_4 2.8286250941170237
R4562 n_11_5_4 n_12_5_4 76.7507857810078
R4563 n_11_5_4 n_11_6_4 6641.864204545356
R4564 n_11_5_15 n_12_5_15 3377.034574364314
R4565 n_11_5_15 n_11_6_15 292242.02499999304
R4566 n_11_6_0 n_12_6_0 2771.5035703868975
R4567 n_11_6_0 n_11_7_0 142.85714285714286
R4568 n_11_6_0 n_11_6_1 4124.999999999883
R4569 n_11_6_1 n_12_6_1 3880.104998541656
R4570 n_11_6_1 n_11_7_1 200.00000000000003
R4571 n_11_6_1 n_11_6_2 18124.999999999483
R4572 n_11_6_2 n_12_6_2 13857.517851934488
R4573 n_11_6_2 n_11_7_2 714.2857142857144
R4574 n_11_6_2 n_11_6_3 17524.9999999995
R4575 n_11_6_3 n_12_6_3 97002.62496354131
R4576 n_11_6_3 n_11_7_3 4999.999999999996
R4577 n_11_6_3 n_11_6_4 162.49999999999554
R4578 n_11_6_4 n_12_6_4 4409.210225615515
R4579 n_11_6_4 n_11_7_4 227.2727272727271
R4580 n_11_6_15 n_12_6_15 194005.2499270809
R4581 n_11_6_15 n_11_7_15 9999.999999999904
R4582 n_11_7_0 n_12_7_0 2771.5035703868975
R4583 n_11_7_0 n_11_8_0 4174.886071428513
R4584 n_11_7_0 n_11_7_1 4124.999999999883
R4585 n_11_7_1 n_12_7_1 3880.104998541656
R4586 n_11_7_1 n_11_8_1 5844.8404999999175
R4587 n_11_7_1 n_11_7_2 18124.999999999483
R4588 n_11_7_2 n_12_7_2 13857.517851934488
R4589 n_11_7_2 n_11_8_2 20874.430357142566
R4590 n_11_7_2 n_11_7_3 17524.9999999995
R4591 n_11_7_3 n_12_7_3 97002.62496354131
R4592 n_11_7_3 n_11_8_3 146121.0124999978
R4593 n_11_7_3 n_11_7_4 162.49999999999554
R4594 n_11_7_4 n_12_7_4 4409.210225615515
R4595 n_11_7_4 n_11_8_4 6641.864204545356
R4596 n_11_7_15 n_12_7_15 194005.2499270809
R4597 n_11_7_15 n_11_8_15 292242.02499999304
R4598 n_11_8_0 n_12_8_0 48.24335106234782
R4599 n_11_8_0 n_11_9_0 8206.914999999883
R4600 n_11_8_0 n_11_8_1 71.80356008143207
R4601 n_11_8_1 n_12_8_1 67.54069148728694
R4602 n_11_8_1 n_11_9_1 11489.680999999835
R4603 n_11_8_1 n_11_8_2 315.5004912668985
R4604 n_11_8_2 n_12_8_2 241.21675531173906
R4605 n_11_8_2 n_11_9_2 41034.574999999415
R4606 n_11_8_2 n_11_8_3 305.0563370732357
R4607 n_11_8_3 n_12_8_3 1688.517287182172
R4608 n_11_8_3 n_11_9_3 287242.0249999956
R4609 n_11_8_3 n_11_8_4 2.8286250941170237
R4610 n_11_8_4 n_12_8_4 76.7507857810078
R4611 n_11_8_4 n_11_9_4 13056.455681817984
R4612 n_11_8_15 n_12_8_15 3377.034574364314
R4613 n_11_8_15 n_11_9_15 574484.0499999862
R4614 n_11_9_0 n_12_9_0 48.24335106234782
R4615 n_11_9_0 n_11_10_0 4174.886084484132
R4616 n_11_9_0 n_11_9_1 71.80356008143207
R4617 n_11_9_1 n_12_9_1 67.54069148728694
R4618 n_11_9_1 n_11_10_1 5844.840518277784
R4619 n_11_9_1 n_11_9_2 315.5004912668985
R4620 n_11_9_2 n_12_9_2 241.21675531173906
R4621 n_11_9_2 n_11_10_2 20874.430422420657
R4622 n_11_9_2 n_11_9_3 305.0563370732357
R4623 n_11_9_3 n_12_9_3 1688.517287182172
R4624 n_11_9_3 n_11_10_3 146121.01295694447
R4625 n_11_9_3 n_11_9_4 2.8286250941170237
R4626 n_11_9_4 n_12_9_4 76.7507857810078
R4627 n_11_9_4 n_11_10_4 6641.864225315659
R4628 n_11_9_15 n_12_9_15 3377.034574364314
R4629 n_11_9_15 n_11_10_15 292242.0259138864
R4630 n_11_10_0 n_12_10_0 2771.5030638152725
R4631 n_11_10_0 n_11_11_0 142.85716896837795
R4632 n_11_10_0 n_11_10_1 4124.9992460380345
R4633 n_11_10_1 n_12_10_1 3880.10428934138
R4634 n_11_10_1 n_11_11_1 200.0000365557291
R4635 n_11_10_1 n_11_10_2 18124.99668713682
R4636 n_11_10_2 n_12_10_2 13857.515319076361
R4637 n_11_10_2 n_11_11_2 714.2858448418897
R4638 n_11_10_2 n_11_10_3 17524.996796804015
R4639 n_11_10_3 n_12_10_3 97002.60723353442
R4640 n_11_10_3 n_11_11_3 5000.000913893224
R4641 n_11_10_3 n_11_10_4 162.49997029846818
R4642 n_11_10_4 n_12_10_4 4409.209419706111
R4643 n_11_10_4 n_11_11_4 227.27276881332836
R4644 n_11_10_15 n_12_10_15 194005.21446706713
R4645 n_11_10_15 n_11_11_15 10000.00182778636
R4646 n_11_11_0 n_12_11_0 2771.5030638153703
R4647 n_11_11_0 n_11_12_0 1646.678571428546
R4648 n_11_11_0 n_11_11_1 4124.999246038181
R4649 n_11_11_1 n_12_11_1 3880.1042893415183
R4650 n_11_11_1 n_11_12_1 2305.3499999999644
R4651 n_11_11_1 n_11_11_2 18124.99668713746
R4652 n_11_11_2 n_12_11_2 13857.515319076852
R4653 n_11_11_2 n_11_12_2 8233.392857142731
R4654 n_11_11_2 n_11_11_3 17524.996796804633
R4655 n_11_11_3 n_12_11_3 97002.60723353787
R4656 n_11_11_3 n_11_12_3 57633.74999999906
R4657 n_11_11_3 n_11_11_4 162.49997029847395
R4658 n_11_11_4 n_12_11_4 4409.209419706267
R4659 n_11_11_4 n_11_12_4 2619.7159090908667
R4660 n_11_11_15 n_12_11_15 194005.21446707402
R4661 n_11_11_15 n_11_12_15 115267.4999999971
R4662 n_11_12_0 n_12_12_0 125.67182503262822
R4663 n_11_12_0 n_11_13_0 3150.499973888719
R4664 n_11_12_0 n_11_12_1 187.04514177739605
R4665 n_11_12_1 n_12_12_1 175.94055504567947
R4666 n_11_12_1 n_11_13_1 4410.699963444207
R4667 n_11_12_1 n_11_12_2 821.8650169006796
R4668 n_11_12_2 n_12_12_2 628.3591251631409
R4669 n_11_12_2 n_11_13_2 15752.499869443598
R4670 n_11_12_2 n_11_12_3 794.6584508239675
R4671 n_11_12_3 n_12_12_3 4398.513876141983
R4672 n_11_12_3 n_11_13_3 110267.49908610508
R4673 n_11_12_3 n_11_12_4 7.368444979109548
R4674 n_11_12_4 n_12_12_4 199.93244891554468
R4675 n_11_12_4 n_11_13_4 5012.1590493684125
R4676 n_11_12_4 n_11_12_5 6.450763186839494
R4677 n_11_12_5 n_12_12_5 837.8121668841871
R4678 n_11_12_5 n_11_13_5 21003.33315925811
R4679 n_11_12_5 n_11_12_6 1.5114758931506769
R4680 n_11_12_6 n_12_12_6 139.63536114736453
R4681 n_11_12_6 n_11_13_6 3500.5555265430185
R4682 n_11_12_6 n_11_12_7 2.0512887121330587
R4683 n_11_12_7 n_12_12_7 239.37490482405423
R4684 n_11_12_7 n_11_13_7 6000.952331216622
R4685 n_11_12_7 n_11_12_8 1.511475893150672
R4686 n_11_12_8 n_12_12_8 239.37490482405423
R4687 n_11_12_8 n_11_13_8 6000.952331216622
R4688 n_11_12_8 n_11_12_9 1.511475893150672
R4689 n_11_12_9 n_12_12_9 239.37490482405423
R4690 n_11_12_9 n_11_13_9 6000.952331216622
R4691 n_11_12_9 n_11_12_10 1.511475893150672
R4692 n_11_12_10 n_12_12_10 239.37490482405423
R4693 n_11_12_10 n_11_13_10 6000.952331216622
R4694 n_11_12_10 n_11_12_11 1.5114758931506622
R4695 n_11_12_11 n_12_12_11 239.37490482405732
R4696 n_11_12_11 n_11_13_11 6000.9523312166975
R4697 n_11_12_11 n_11_12_12 1.5114758931506573
R4698 n_11_12_12 n_12_12_12 239.37490482405573
R4699 n_11_12_12 n_11_13_12 6000.95233121666
R4700 n_11_12_12 n_11_12_13 1.511475893150672
R4701 n_11_12_13 n_12_12_13 239.37490482405272
R4702 n_11_12_13 n_11_13_13 6000.952331216584
R4703 n_11_12_13 n_11_12_14 7.557379465753378
R4704 n_11_12_14 n_12_12_14 26.59721164711708
R4705 n_11_12_14 n_11_13_14 666.7724812462898
R4706 n_11_12_14 n_11_12_15 233.52302549178157
R4707 n_11_12_15 n_12_12_15 8797.027752283888
R4708 n_11_12_15 n_11_13_15 220534.9981722082
R4709 n_11_13_0 n_12_13_0 125.67182503262799
R4710 n_11_13_0 n_11_13_1 187.04514177739577
R4711 n_11_13_1 n_12_13_1 175.94055504567916
R4712 n_11_13_1 n_11_13_2 821.8650169006784
R4713 n_11_13_2 n_12_13_2 628.35912516314
R4714 n_11_13_2 n_11_13_3 794.6584508239663
R4715 n_11_13_3 n_12_13_3 4398.513876141976
R4716 n_11_13_3 n_11_13_4 7.368444979109538
R4717 n_11_13_4 n_12_13_4 199.93244891554434
R4718 n_11_13_4 n_11_13_5 6.4507631868394855
R4719 n_11_13_5 n_12_13_5 837.8121668841859
R4720 n_11_13_5 n_11_13_6 1.511475893150674
R4721 n_11_13_6 n_12_13_6 139.6353611473643
R4722 n_11_13_6 n_11_13_7 2.051288712133055
R4723 n_11_13_7 n_12_13_7 239.37490482405383
R4724 n_11_13_7 n_11_13_8 1.5114758931506693
R4725 n_11_13_8 n_12_13_8 239.37490482405383
R4726 n_11_13_8 n_11_13_9 1.5114758931506693
R4727 n_11_13_9 n_12_13_9 239.37490482405383
R4728 n_11_13_9 n_11_13_10 1.5114758931506693
R4729 n_11_13_10 n_12_13_10 239.37490482405383
R4730 n_11_13_10 n_11_13_11 1.5114758931506596
R4731 n_11_13_11 n_12_13_11 239.3749048240569
R4732 n_11_13_11 n_11_13_12 1.5114758931506547
R4733 n_11_13_12 n_12_13_12 239.37490482405536
R4734 n_11_13_12 n_11_13_13 1.5114758931506693
R4735 n_11_13_13 n_12_13_13 239.37490482405235
R4736 n_11_13_13 n_11_13_14 7.557379465753366
R4737 n_11_13_14 n_12_13_14 26.597211647117035
R4738 n_11_13_14 n_11_13_15 233.52302549178117
R4739 n_11_13_15 n_12_13_15 8797.027752283871
R4740 n_12_0_0 n_13_0_0 244.86587514965555
R4741 n_12_0_0 n_12_1_0 83.34425224761593
R4742 n_12_0_0 n_12_0_1 4.948146301260397
R4743 n_12_0_1 n_13_0_1 342.8122252095177
R4744 n_12_0_1 n_12_1_1 116.6819531466623
R4745 n_12_0_1 n_12_0_2 21.74185496008356
R4746 n_12_0_2 n_13_0_2 1224.3293757482777
R4747 n_12_0_2 n_12_1_2 416.7212612380796
R4748 n_12_0_2 n_12_0_3 21.02212458899114
R4749 n_12_0_3 n_13_0_3 8570.305630237934
R4750 n_12_0_3 n_12_1_3 2917.048828666555
R4751 n_12_0_3 n_12_0_4 0.19492697550419763
R4752 n_12_0_4 n_13_0_4 389.55934682899715
R4753 n_12_0_4 n_12_1_4 132.59312857575247
R4754 n_12_0_4 n_12_0_5 0.1706503558443342
R4755 n_12_0_5 n_13_0_5 1632.4391676643686
R4756 n_12_0_5 n_12_1_5 555.6283483174391
R4757 n_12_0_5 n_12_0_6 0.03998502061624566
R4758 n_12_0_6 n_13_0_6 272.07319461072814
R4759 n_12_0_6 n_12_1_6 92.60472471957317
R4760 n_12_0_6 n_12_0_7 0.05426538512204762
R4761 n_12_0_7 n_13_0_7 466.41119076124966
R4762 n_12_0_7 n_12_1_7 158.75095666212593
R4763 n_12_0_7 n_12_0_8 0.03998502061624554
R4764 n_12_0_8 n_13_0_8 466.41119076124966
R4765 n_12_0_8 n_12_1_8 158.75095666212593
R4766 n_12_0_8 n_12_0_9 0.03998502061624554
R4767 n_12_0_9 n_13_0_9 466.41119076124966
R4768 n_12_0_9 n_12_1_9 158.75095666212593
R4769 n_12_0_9 n_12_0_10 0.03998502061624554
R4770 n_12_0_10 n_13_0_10 466.41119076124966
R4771 n_12_0_10 n_12_1_10 158.75095666212593
R4772 n_12_0_10 n_12_0_11 0.03998502061624528
R4773 n_12_0_11 n_13_0_11 466.4111907612556
R4774 n_12_0_11 n_12_1_11 158.75095666212795
R4775 n_12_0_11 n_12_0_12 0.03998502061624515
R4776 n_12_0_12 n_13_0_12 466.4111907612528
R4777 n_12_0_12 n_12_1_12 158.7509566621269
R4778 n_12_0_12 n_12_0_13 0.03998502061624554
R4779 n_12_0_13 n_13_0_13 466.41119076124676
R4780 n_12_0_13 n_12_1_13 158.75095666212493
R4781 n_12_0_13 n_12_0_14 0.19992510308122818
R4782 n_12_0_14 n_13_0_14 51.82346564013874
R4783 n_12_0_14 n_12_1_14 17.638995184680617
R4784 n_12_0_14 n_12_0_15 6.177685685210008
R4785 n_12_0_15 n_13_0_15 17140.61126047572
R4786 n_12_0_15 n_12_1_15 5834.097657333058
R4787 n_12_1_0 n_13_1_0 244.86587514965555
R4788 n_12_1_0 n_12_2_0 43.561715139231
R4789 n_12_1_0 n_12_1_1 4.948146301260397
R4790 n_12_1_1 n_13_1_1 342.8122252095177
R4791 n_12_1_1 n_12_2_1 60.986401194923396
R4792 n_12_1_1 n_12_1_2 21.74185496008356
R4793 n_12_1_2 n_13_1_2 1224.3293757482777
R4794 n_12_1_2 n_12_2_2 217.80857569615497
R4795 n_12_1_2 n_12_1_3 21.02212458899114
R4796 n_12_1_3 n_13_1_3 8570.305630237934
R4797 n_12_1_3 n_12_2_3 1524.6600298730837
R4798 n_12_1_3 n_12_1_4 0.19492697550419763
R4799 n_12_1_4 n_13_1_4 389.55934682899715
R4800 n_12_1_4 n_12_2_4 69.3027286305947
R4801 n_12_1_4 n_12_1_5 0.1706503558443342
R4802 n_12_1_5 n_13_1_5 1632.4391676643686
R4803 n_12_1_5 n_12_1_6 0.03998502061624566
R4804 n_12_1_6 n_13_1_6 272.07319461072814
R4805 n_12_1_6 n_12_1_7 0.05426538512204762
R4806 n_12_1_7 n_13_1_7 466.41119076124966
R4807 n_12_1_7 n_12_1_8 0.03998502061624554
R4808 n_12_1_8 n_13_1_8 466.41119076124966
R4809 n_12_1_8 n_12_1_9 0.03998502061624554
R4810 n_12_1_9 n_13_1_9 466.41119076124966
R4811 n_12_1_9 n_12_1_10 0.03998502061624554
R4812 n_12_1_10 n_13_1_10 466.41119076124966
R4813 n_12_1_10 n_12_1_11 0.03998502061624528
R4814 n_12_1_11 n_13_1_11 466.4111907612556
R4815 n_12_1_11 n_12_1_12 0.03998502061624515
R4816 n_12_1_12 n_13_1_12 466.4111907612528
R4817 n_12_1_12 n_12_1_13 0.03998502061624554
R4818 n_12_1_13 n_13_1_13 466.41119076124676
R4819 n_12_1_13 n_12_1_14 0.19992510308122818
R4820 n_12_1_14 n_13_1_14 51.82346564013874
R4821 n_12_1_14 n_12_1_15 6.177685685210008
R4822 n_12_1_15 n_13_1_15 17140.61126047572
R4823 n_12_1_15 n_12_2_15 3049.3200597461405
R4824 n_12_2_0 n_13_2_0 5400.159267103167
R4825 n_12_2_0 n_12_3_0 3.779178030846073
R4826 n_12_2_0 n_12_2_1 109.12414025597707
R4827 n_12_2_1 n_13_2_1 7560.222973944432
R4828 n_12_2_1 n_12_3_1 5.2908492431845024
R4829 n_12_2_1 n_12_2_2 479.4848587005053
R4830 n_12_2_2 n_13_2_2 27000.79633551584
R4831 n_12_2_2 n_12_3_2 18.895890154230365
R4832 n_12_2_2 n_12_2_3 463.6122564814541
R4833 n_12_2_3 n_13_2_3 189005.57434861065
R4834 n_12_2_3 n_12_3_3 132.27123107961245
R4835 n_12_2_3 n_12_2_4 4.298829767659707
R4836 n_12_2_4 n_13_2_4 8591.162470391393
R4837 n_12_2_4 n_12_3_4 6.012328685436929
R4838 n_12_2_15 n_13_2_15 378011.1486972179
R4839 n_12_2_15 n_12_3_15 264.54246215922257
R4840 n_12_3_0 n_13_3_0 5400.159267103167
R4841 n_12_3_0 n_12_4_0 110.44365038628534
R4842 n_12_3_0 n_12_3_1 109.12414025597707
R4843 n_12_3_1 n_13_3_1 7560.222973944432
R4844 n_12_3_1 n_12_4_1 154.62111054079946
R4845 n_12_3_1 n_12_3_2 479.4848587005053
R4846 n_12_3_2 n_13_3_2 27000.79633551584
R4847 n_12_3_2 n_12_4_2 552.2182519314266
R4848 n_12_3_2 n_12_3_3 463.6122564814541
R4849 n_12_3_3 n_13_3_3 189005.57434861065
R4850 n_12_3_3 n_12_4_3 3865.527763519984
R4851 n_12_3_3 n_12_3_4 4.298829767659707
R4852 n_12_3_4 n_13_3_4 8591.162470391393
R4853 n_12_3_4 n_12_4_4 175.70580743272654
R4854 n_12_3_15 n_13_3_15 378011.1486972179
R4855 n_12_3_15 n_12_4_15 7731.055527039899
R4856 n_12_4_0 n_13_4_0 93.99999874525193
R4857 n_12_4_0 n_12_5_0 217.10812274172457
R4858 n_12_4_0 n_12_4_1 1.8995123180211522
R4859 n_12_4_1 n_13_4_1 131.59999824335273
R4860 n_12_4_1 n_12_5_1 303.9513718384144
R4861 n_12_4_1 n_12_4_2 8.346342003426276
R4862 n_12_4_2 n_13_4_2 469.9999937262596
R4863 n_12_4_2 n_12_5_2 1085.540613708623
R4864 n_12_4_2 n_12_4_3 8.070049302623199
R4865 n_12_4_3 n_13_4_3 3289.999956083815
R4866 n_12_4_3 n_12_5_3 7598.784295960355
R4867 n_12_4_3 n_12_4_4 0.07482927313416667
R4868 n_12_4_4 n_13_4_4 149.54545254926433
R4869 n_12_4_4 n_12_5_4 345.3992861800161
R4870 n_12_4_4 n_12_4_5 0.07482927313416667
R4871 n_12_4_5 n_13_4_5 3289.999956083815
R4872 n_12_4_5 n_12_5_5 7598.784295960355
R4873 n_12_4_5 n_12_4_6 0.14965854626833333
R4874 n_12_4_6 n_13_4_6 1096.6666520279382
R4875 n_12_4_6 n_12_5_6 2532.928098653451
R4876 n_12_4_6 n_12_4_7 0.21873172146910233
R4877 n_12_4_7 n_13_4_7 1879.999974905043
R4878 n_12_4_7 n_12_5_7 4342.162454834501
R4879 n_12_4_7 n_12_4_8 0.16117074213512772
R4880 n_12_4_8 n_13_4_8 1879.999974905043
R4881 n_12_4_8 n_12_5_8 4342.162454834501
R4882 n_12_4_8 n_12_4_9 0.16117074213512772
R4883 n_12_4_9 n_13_4_9 1879.999974905043
R4884 n_12_4_9 n_12_5_9 4342.162454834501
R4885 n_12_4_9 n_12_4_10 0.16117074213512772
R4886 n_12_4_10 n_13_4_10 1879.999974905043
R4887 n_12_4_10 n_12_5_10 4342.162454834501
R4888 n_12_4_10 n_12_4_11 0.16117074213512667
R4889 n_12_4_11 n_13_4_11 1879.9999749050667
R4890 n_12_4_11 n_12_5_11 4342.162454834557
R4891 n_12_4_11 n_12_4_12 0.16117074213512617
R4892 n_12_4_12 n_13_4_12 1879.9999749050548
R4893 n_12_4_12 n_12_5_12 4342.162454834529
R4894 n_12_4_12 n_12_4_13 0.16117074213512772
R4895 n_12_4_13 n_13_4_13 1879.9999749050312
R4896 n_12_4_13 n_12_5_13 4342.1624548344735
R4897 n_12_4_13 n_12_4_14 0.8058537106756406
R4898 n_12_4_14 n_13_4_14 208.88888610055994
R4899 n_12_4_14 n_12_5_14 482.4624949816102
R4900 n_12_4_14 n_12_4_15 3.027707512967071
R4901 n_12_4_15 n_13_4_15 6579.999912167572
R4902 n_12_4_15 n_12_5_15 15197.568591920572
R4903 n_12_5_0 n_13_5_0 93.99999874525199
R4904 n_12_5_0 n_12_6_0 110.44365362970504
R4905 n_12_5_0 n_12_5_1 1.8995123180211528
R4906 n_12_5_1 n_13_5_1 131.59999824335273
R4907 n_12_5_1 n_12_6_1 154.62111508158705
R4908 n_12_5_1 n_12_5_2 8.346342003426278
R4909 n_12_5_2 n_13_5_2 469.99999372625985
R4910 n_12_5_2 n_12_6_2 552.2182681485251
R4911 n_12_5_2 n_12_5_3 8.0700493026232
R4912 n_12_5_3 n_13_5_3 3289.999956083816
R4913 n_12_5_3 n_12_6_3 3865.527877039673
R4914 n_12_5_3 n_12_5_4 0.0748292731341667
R4915 n_12_5_4 n_13_5_4 149.54545254926438
R4916 n_12_5_4 n_12_6_4 175.7058125927124
R4917 n_12_5_4 n_12_5_5 0.0748292731341667
R4918 n_12_5_5 n_13_5_5 3289.999956083816
R4919 n_12_5_5 n_12_5_6 0.14965854626833341
R4920 n_12_5_6 n_13_5_6 1096.6666520279387
R4921 n_12_5_6 n_12_5_7 0.2187317214691024
R4922 n_12_5_7 n_13_5_7 1879.9999749050437
R4923 n_12_5_7 n_12_5_8 0.16117074213512778
R4924 n_12_5_8 n_13_5_8 1879.9999749050437
R4925 n_12_5_8 n_12_5_9 0.16117074213512778
R4926 n_12_5_9 n_13_5_9 1879.9999749050437
R4927 n_12_5_9 n_12_5_10 0.16117074213512778
R4928 n_12_5_10 n_13_5_10 1879.9999749050437
R4929 n_12_5_10 n_12_5_11 0.16117074213512672
R4930 n_12_5_11 n_13_5_11 1879.999974905068
R4931 n_12_5_11 n_12_5_12 0.16117074213512622
R4932 n_12_5_12 n_13_5_12 1879.9999749050558
R4933 n_12_5_12 n_12_5_13 0.16117074213512778
R4934 n_12_5_13 n_13_5_13 1879.9999749050314
R4935 n_12_5_13 n_12_5_14 0.8058537106756408
R4936 n_12_5_14 n_13_5_14 208.88888610055997
R4937 n_12_5_14 n_12_5_15 3.0277075129670723
R4938 n_12_5_15 n_13_5_15 6579.999912167574
R4939 n_12_5_15 n_12_6_15 7731.055754079277
R4940 n_12_6_0 n_13_6_0 5400.149997916649
R4941 n_12_6_0 n_12_7_0 3.7791845176855245
R4942 n_12_6_0 n_12_6_1 109.1239529481664
R4943 n_12_6_1 n_13_6_1 7560.209997083308
R4944 n_12_6_1 n_12_7_1 5.290858324759735
R4945 n_12_6_1 n_12_6_2 479.4840356813372
R4946 n_12_6_2 n_13_6_2 27000.749989583248
R4947 n_12_6_2 n_12_7_2 18.895922588427624
R4948 n_12_6_2 n_12_6_3 463.6114607070584
R4949 n_12_6_3 n_13_6_3 189005.24992708254
R4950 n_12_6_3 n_12_7_3 132.27145811899325
R4951 n_12_6_3 n_12_6_4 4.2988223888671655
R4952 n_12_6_4 n_13_6_4 8591.147723958296
R4953 n_12_6_4 n_12_7_4 6.0123390054087835
R4954 n_12_6_15 n_13_6_15 378010.49985416175
R4955 n_12_6_15 n_12_7_15 264.5429162379842
R4956 n_12_7_0 n_13_7_0 5400.149997916649
R4957 n_12_7_0 n_12_8_0 110.44365362970504
R4958 n_12_7_0 n_12_7_1 109.1239529481664
R4959 n_12_7_1 n_13_7_1 7560.209997083308
R4960 n_12_7_1 n_12_8_1 154.62111508158705
R4961 n_12_7_1 n_12_7_2 479.4840356813372
R4962 n_12_7_2 n_13_7_2 27000.749989583248
R4963 n_12_7_2 n_12_8_2 552.2182681485251
R4964 n_12_7_2 n_12_7_3 463.6114607070584
R4965 n_12_7_3 n_13_7_3 189005.24992708254
R4966 n_12_7_3 n_12_8_3 3865.527877039673
R4967 n_12_7_3 n_12_7_4 4.2988223888671655
R4968 n_12_7_4 n_13_7_4 8591.147723958296
R4969 n_12_7_4 n_12_8_4 175.7058125927124
R4970 n_12_7_15 n_13_7_15 378010.49985416175
R4971 n_12_7_15 n_12_8_15 7731.055754079277
R4972 n_12_8_0 n_13_8_0 93.99999874525199
R4973 n_12_8_0 n_12_9_0 217.10812274172454
R4974 n_12_8_0 n_12_8_1 1.8995123180211528
R4975 n_12_8_1 n_13_8_1 131.59999824335273
R4976 n_12_8_1 n_12_9_1 303.9513718384144
R4977 n_12_8_1 n_12_8_2 8.346342003426278
R4978 n_12_8_2 n_13_8_2 469.99999372625985
R4979 n_12_8_2 n_12_9_2 1085.5406137086227
R4980 n_12_8_2 n_12_8_3 8.0700493026232
R4981 n_12_8_3 n_13_8_3 3289.999956083816
R4982 n_12_8_3 n_12_9_3 7598.784295960353
R4983 n_12_8_3 n_12_8_4 0.0748292731341667
R4984 n_12_8_4 n_13_8_4 149.54545254926438
R4985 n_12_8_4 n_12_9_4 345.399286180016
R4986 n_12_8_4 n_12_8_5 0.0748292731341667
R4987 n_12_8_5 n_13_8_5 3289.999956083816
R4988 n_12_8_5 n_12_9_5 7598.784295960353
R4989 n_12_8_5 n_12_8_6 0.14965854626833341
R4990 n_12_8_6 n_13_8_6 1096.6666520279387
R4991 n_12_8_6 n_12_9_6 2532.9280986534504
R4992 n_12_8_6 n_12_8_7 0.2187317214691024
R4993 n_12_8_7 n_13_8_7 1879.9999749050437
R4994 n_12_8_7 n_12_9_7 4342.162454834501
R4995 n_12_8_7 n_12_8_8 0.16117074213512778
R4996 n_12_8_8 n_13_8_8 1879.9999749050437
R4997 n_12_8_8 n_12_9_8 4342.162454834501
R4998 n_12_8_8 n_12_8_9 0.16117074213512778
R4999 n_12_8_9 n_13_8_9 1879.9999749050437
R5000 n_12_8_9 n_12_9_9 4342.162454834501
R5001 n_12_8_9 n_12_8_10 0.16117074213512778
R5002 n_12_8_10 n_13_8_10 1879.9999749050437
R5003 n_12_8_10 n_12_9_10 4342.162454834501
R5004 n_12_8_10 n_12_8_11 0.16117074213512672
R5005 n_12_8_11 n_13_8_11 1879.999974905068
R5006 n_12_8_11 n_12_9_11 4342.162454834556
R5007 n_12_8_11 n_12_8_12 0.16117074213512622
R5008 n_12_8_12 n_13_8_12 1879.9999749050558
R5009 n_12_8_12 n_12_9_12 4342.162454834528
R5010 n_12_8_12 n_12_8_13 0.16117074213512778
R5011 n_12_8_13 n_13_8_13 1879.9999749050314
R5012 n_12_8_13 n_12_9_13 4342.1624548344735
R5013 n_12_8_13 n_12_8_14 0.8058537106756408
R5014 n_12_8_14 n_13_8_14 208.88888610055997
R5015 n_12_8_14 n_12_9_14 482.4624949816101
R5016 n_12_8_14 n_12_8_15 3.0277075129670723
R5017 n_12_8_15 n_13_8_15 6579.999912167574
R5018 n_12_8_15 n_12_9_15 15197.56859192057
R5019 n_12_9_0 n_13_9_0 93.99999874525199
R5020 n_12_9_0 n_12_10_0 110.44365397508219
R5021 n_12_9_0 n_12_9_1 1.8995123180211528
R5022 n_12_9_1 n_13_9_1 131.59999824335273
R5023 n_12_9_1 n_12_10_1 154.62111556511508
R5024 n_12_9_1 n_12_9_2 8.346342003426278
R5025 n_12_9_2 n_13_9_2 469.99999372625985
R5026 n_12_9_2 n_12_10_2 552.2182698754109
R5027 n_12_9_2 n_12_9_3 8.0700493026232
R5028 n_12_9_3 n_13_9_3 3289.999956083816
R5029 n_12_9_3 n_12_10_3 3865.5278891278736
R5030 n_12_9_3 n_12_9_4 0.0748292731341667
R5031 n_12_9_4 n_13_9_4 149.54545254926438
R5032 n_12_9_4 n_12_10_4 175.70581314217605
R5033 n_12_9_4 n_12_9_5 0.0748292731341667
R5034 n_12_9_5 n_13_9_5 3289.999956083816
R5035 n_12_9_5 n_12_9_6 0.14965854626833341
R5036 n_12_9_6 n_13_9_6 1096.6666520279387
R5037 n_12_9_6 n_12_9_7 0.2187317214691024
R5038 n_12_9_7 n_13_9_7 1879.9999749050437
R5039 n_12_9_7 n_12_9_8 0.16117074213512778
R5040 n_12_9_8 n_13_9_8 1879.9999749050437
R5041 n_12_9_8 n_12_9_9 0.16117074213512778
R5042 n_12_9_9 n_13_9_9 1879.9999749050437
R5043 n_12_9_9 n_12_9_10 0.16117074213512778
R5044 n_12_9_10 n_13_9_10 1879.9999749050437
R5045 n_12_9_10 n_12_9_11 0.16117074213512672
R5046 n_12_9_11 n_13_9_11 1879.999974905068
R5047 n_12_9_11 n_12_9_12 0.16117074213512622
R5048 n_12_9_12 n_13_9_12 1879.9999749050558
R5049 n_12_9_12 n_12_9_13 0.16117074213512778
R5050 n_12_9_13 n_13_9_13 1879.9999749050314
R5051 n_12_9_13 n_12_9_14 0.8058537106756408
R5052 n_12_9_14 n_13_9_14 208.88888610055997
R5053 n_12_9_14 n_12_9_15 3.0277075129670723
R5054 n_12_9_15 n_13_9_15 6579.999912167574
R5055 n_12_9_15 n_12_10_15 7731.055778255677
R5056 n_12_10_0 n_13_10_0 5400.149010884632
R5057 n_12_10_0 n_12_11_0 3.7791852084397517
R5058 n_12_10_0 n_12_10_1 109.1239330026398
R5059 n_12_10_1 n_13_10_1 7560.208615238482
R5060 n_12_10_1 n_12_11_1 5.290859291815652
R5061 n_12_10_1 n_12_10_2 479.4839480419022
R5062 n_12_10_2 n_13_10_2 27000.74505442316
R5063 n_12_10_2 n_12_11_2 18.89592604219876
R5064 n_12_10_2 n_12_10_3 463.6113759687909
R5065 n_12_10_3 n_13_10_3 189005.2153809619
R5066 n_12_10_3 n_12_11_3 132.2714822953912
R5067 n_12_10_3 n_12_10_4 4.298821603134299
R5068 n_12_10_4 n_13_10_4 8591.146153680089
R5069 n_12_10_4 n_12_11_4 6.012340104335963
R5070 n_12_10_15 n_13_10_15 378010.4307619204
R5071 n_12_10_15 n_12_11_15 264.54296459078
R5072 n_12_11_0 n_13_11_0 5400.149010884823
R5073 n_12_11_0 n_12_12_0 43.56171513923095
R5074 n_12_11_0 n_12_11_1 109.12393300264367
R5075 n_12_11_1 n_13_11_1 7560.208615238751
R5076 n_12_11_1 n_12_12_1 60.986401194923324
R5077 n_12_11_1 n_12_11_2 479.48394804191923
R5078 n_12_11_2 n_13_11_2 27000.745054424115
R5079 n_12_11_2 n_12_12_2 217.80857569615472
R5080 n_12_11_2 n_12_11_3 463.6113759688074
R5081 n_12_11_3 n_13_11_3 189005.21538096864
R5082 n_12_11_3 n_12_12_3 1524.660029873082
R5083 n_12_11_3 n_12_11_4 4.298821603134452
R5084 n_12_11_4 n_13_11_4 8591.14615368039
R5085 n_12_11_4 n_12_12_4 69.30272863059463
R5086 n_12_11_15 n_13_11_15 378010.4307619339
R5087 n_12_11_15 n_12_12_15 3049.3200597461364
R5088 n_12_12_0 n_13_12_0 244.8658962374675
R5089 n_12_12_0 n_12_13_0 83.34424507002228
R5090 n_12_12_0 n_12_12_1 4.948146727394002
R5091 n_12_12_1 n_13_12_1 342.81225473245445
R5092 n_12_12_1 n_12_13_1 116.68194309803118
R5093 n_12_12_1 n_12_12_2 21.741856832488796
R5094 n_12_12_2 n_13_12_2 1224.3294811873375
R5095 n_12_12_2 n_12_13_2 416.72122535011135
R5096 n_12_12_2 n_12_12_3 21.022126399413306
R5097 n_12_12_3 n_13_12_3 8570.306368311354
R5098 n_12_12_3 n_12_13_3 2917.0485774507774
R5099 n_12_12_3 n_12_12_4 0.19492699229127902
R5100 n_12_12_4 n_13_12_4 389.5593803777888
R5101 n_12_12_4 n_12_13_4 132.5931171568535
R5102 n_12_12_4 n_12_12_5 0.1706503705407168
R5103 n_12_12_5 n_13_12_5 1632.4393082497816
R5104 n_12_12_5 n_12_13_5 555.6283004668147
R5105 n_12_12_5 n_12_12_6 0.03998502405974956
R5106 n_12_12_6 n_13_12_6 272.0732180416303
R5107 n_12_12_6 n_12_13_6 92.6047167444691
R5108 n_12_12_6 n_12_12_7 0.05426538979537433
R5109 n_12_12_7 n_13_12_7 466.41123092851046
R5110 n_12_12_7 n_12_13_7 158.75094299051898
R5111 n_12_12_7 n_12_12_8 0.03998502405974943
R5112 n_12_12_8 n_13_12_8 466.41123092851046
R5113 n_12_12_8 n_12_13_8 158.75094299051898
R5114 n_12_12_8 n_12_12_9 0.03998502405974943
R5115 n_12_12_9 n_13_12_9 466.41123092851046
R5116 n_12_12_9 n_12_13_9 158.75094299051898
R5117 n_12_12_9 n_12_12_10 0.03998502405974943
R5118 n_12_12_10 n_13_12_10 466.41123092851046
R5119 n_12_12_10 n_12_13_10 158.75094299051898
R5120 n_12_12_10 n_12_12_11 0.03998502405974917
R5121 n_12_12_11 n_13_12_11 466.41123092851655
R5122 n_12_12_11 n_12_13_11 158.750942990521
R5123 n_12_12_11 n_12_12_12 0.03998502405974905
R5124 n_12_12_12 n_13_12_12 466.4112309285134
R5125 n_12_12_12 n_12_13_12 158.75094299051995
R5126 n_12_12_12 n_12_12_13 0.03998502405974943
R5127 n_12_12_13 n_13_12_13 466.41123092850756
R5128 n_12_12_13 n_12_13_13 158.75094299051796
R5129 n_12_12_13 n_12_12_14 0.19992512029874765
R5130 n_12_12_14 n_13_12_14 51.82347010316772
R5131 n_12_12_14 n_12_13_14 17.638993665613178
R5132 n_12_12_14 n_12_12_15 6.177686217231358
R5133 n_12_12_15 n_13_12_15 17140.612736622556
R5134 n_12_12_15 n_12_13_15 5834.097154901502
R5135 n_12_13_0 n_13_13_0 244.8658962374671
R5136 n_12_13_0 n_12_13_1 4.948146727393995
R5137 n_12_13_1 n_13_13_1 342.8122547324539
R5138 n_12_13_1 n_12_13_2 21.741856832488768
R5139 n_12_13_2 n_13_13_2 1224.3294811873354
R5140 n_12_13_2 n_12_13_3 21.022126399413278
R5141 n_12_13_3 n_13_13_3 8570.30636831134
R5142 n_12_13_3 n_12_13_4 0.1949269922912788
R5143 n_12_13_4 n_13_13_4 389.55938037778816
R5144 n_12_13_4 n_12_13_5 0.1706503705407166
R5145 n_12_13_5 n_13_13_5 1632.439308249779
R5146 n_12_13_5 n_12_13_6 0.03998502405974949
R5147 n_12_13_6 n_13_13_6 272.07321804162984
R5148 n_12_13_6 n_12_13_7 0.05426538979537425
R5149 n_12_13_7 n_13_13_7 466.4112309285097
R5150 n_12_13_7 n_12_13_8 0.039985024059749366
R5151 n_12_13_8 n_13_13_8 466.4112309285097
R5152 n_12_13_8 n_12_13_9 0.039985024059749366
R5153 n_12_13_9 n_13_13_9 466.4112309285097
R5154 n_12_13_9 n_12_13_10 0.039985024059749366
R5155 n_12_13_10 n_13_13_10 466.4112309285097
R5156 n_12_13_10 n_12_13_11 0.03998502405974911
R5157 n_12_13_11 n_13_13_11 466.4112309285157
R5158 n_12_13_11 n_12_13_12 0.03998502405974898
R5159 n_12_13_12 n_13_13_12 466.41123092851274
R5160 n_12_13_12 n_12_13_13 0.039985024059749366
R5161 n_12_13_13 n_13_13_13 466.4112309285068
R5162 n_12_13_13 n_12_13_14 0.19992512029874734
R5163 n_12_13_14 n_13_13_14 51.82347010316764
R5164 n_12_13_14 n_12_13_15 6.17768621723135
R5165 n_12_13_15 n_13_13_15 17140.612736622526
R5166 n_13_0_0 n_14_0_0 125.67181420979044
R5167 n_13_0_0 n_13_1_0 83.34425224761601
R5168 n_13_0_0 n_13_0_1 4.948146301260399
R5169 n_13_0_1 n_14_0_1 175.94053989370656
R5170 n_13_0_1 n_13_1_1 116.6819531466624
R5171 n_13_0_1 n_13_0_2 21.74185496008358
R5172 n_13_0_2 n_14_0_2 628.359071048952
R5173 n_13_0_2 n_13_1_2 416.72126123808005
R5174 n_13_0_2 n_13_0_3 21.022124588991158
R5175 n_13_0_3 n_14_0_3 4398.51349734266
R5176 n_13_0_3 n_13_1_3 2917.0488286665573
R5177 n_13_0_3 n_13_0_4 0.19492697550419774
R5178 n_13_0_4 n_14_0_4 199.9324316973937
R5179 n_13_0_4 n_13_1_4 132.59312857575262
R5180 n_13_0_4 n_13_0_5 0.1706503558443343
R5181 n_13_0_5 n_14_0_5 837.8120947319353
R5182 n_13_0_5 n_13_1_5 555.6283483174395
R5183 n_13_0_5 n_13_0_6 0.039985020616245696
R5184 n_13_0_6 n_14_0_6 139.63534912198926
R5185 n_13_0_6 n_13_1_6 92.60472471957324
R5186 n_13_0_6 n_13_0_7 0.05426538512204766
R5187 n_13_0_7 n_14_0_7 239.37488420912516
R5188 n_13_0_7 n_13_1_7 158.75095666212607
R5189 n_13_0_7 n_13_0_8 0.03998502061624557
R5190 n_13_0_8 n_14_0_8 239.37488420912516
R5191 n_13_0_8 n_13_1_8 158.75095666212607
R5192 n_13_0_8 n_13_0_9 0.03998502061624557
R5193 n_13_0_9 n_14_0_9 239.37488420912516
R5194 n_13_0_9 n_13_1_9 158.75095666212607
R5195 n_13_0_9 n_13_0_10 0.03998502061624557
R5196 n_13_0_10 n_14_0_10 239.37488420912516
R5197 n_13_0_10 n_13_1_10 158.75095666212607
R5198 n_13_0_10 n_13_0_11 0.039985020616245315
R5199 n_13_0_11 n_14_0_11 239.37488420912817
R5200 n_13_0_11 n_13_1_11 158.7509566621281
R5201 n_13_0_11 n_13_0_12 0.03998502061624519
R5202 n_13_0_12 n_14_0_12 239.37488420912675
R5203 n_13_0_12 n_13_1_12 158.75095666212707
R5204 n_13_0_12 n_13_0_13 0.039985020616245565
R5205 n_13_0_13 n_14_0_13 239.37488420912362
R5206 n_13_0_13 n_13_1_13 158.75095666212505
R5207 n_13_0_13 n_13_0_14 0.19992510308122835
R5208 n_13_0_14 n_14_0_14 26.597209356569405
R5209 n_13_0_14 n_13_1_14 17.638995184680635
R5210 n_13_0_14 n_13_0_15 6.177685685210013
R5211 n_13_0_15 n_14_0_15 8797.026994685244
R5212 n_13_0_15 n_13_1_15 5834.097657333063
R5213 n_13_1_0 n_14_1_0 125.67181420979044
R5214 n_13_1_0 n_13_2_0 43.56171513923105
R5215 n_13_1_0 n_13_1_1 4.948146301260399
R5216 n_13_1_1 n_14_1_1 175.94053989370656
R5217 n_13_1_1 n_13_2_1 60.98640119492345
R5218 n_13_1_1 n_13_1_2 21.74185496008358
R5219 n_13_1_2 n_14_1_2 628.359071048952
R5220 n_13_1_2 n_13_2_2 217.80857569615523
R5221 n_13_1_2 n_13_1_3 21.022124588991158
R5222 n_13_1_3 n_14_1_3 4398.51349734266
R5223 n_13_1_3 n_13_2_3 1524.660029873085
R5224 n_13_1_3 n_13_1_4 0.19492697550419774
R5225 n_13_1_4 n_14_1_4 199.9324316973937
R5226 n_13_1_4 n_13_2_4 69.30272863059477
R5227 n_13_1_4 n_13_1_5 0.1706503558443343
R5228 n_13_1_5 n_14_1_5 837.8120947319353
R5229 n_13_1_5 n_13_1_6 0.039985020616245696
R5230 n_13_1_6 n_14_1_6 139.63534912198926
R5231 n_13_1_6 n_13_1_7 0.05426538512204766
R5232 n_13_1_7 n_14_1_7 239.37488420912516
R5233 n_13_1_7 n_13_1_8 0.03998502061624557
R5234 n_13_1_8 n_14_1_8 239.37488420912516
R5235 n_13_1_8 n_13_1_9 0.03998502061624557
R5236 n_13_1_9 n_14_1_9 239.37488420912516
R5237 n_13_1_9 n_13_1_10 0.03998502061624557
R5238 n_13_1_10 n_14_1_10 239.37488420912516
R5239 n_13_1_10 n_13_1_11 0.039985020616245315
R5240 n_13_1_11 n_14_1_11 239.37488420912817
R5241 n_13_1_11 n_13_1_12 0.03998502061624519
R5242 n_13_1_12 n_14_1_12 239.37488420912675
R5243 n_13_1_12 n_13_1_13 0.039985020616245565
R5244 n_13_1_13 n_14_1_13 239.37488420912362
R5245 n_13_1_13 n_13_1_14 0.19992510308122835
R5246 n_13_1_14 n_14_1_14 26.597209356569405
R5247 n_13_1_14 n_13_1_15 6.177685685210013
R5248 n_13_1_15 n_14_1_15 8797.026994685244
R5249 n_13_1_15 n_13_2_15 3049.3200597461428
R5250 n_13_2_0 n_14_2_0 2771.5083275850325
R5251 n_13_2_0 n_13_3_0 3.779178030846077
R5252 n_13_2_0 n_13_2_1 109.12414025597718
R5253 n_13_2_1 n_14_2_1 3880.111658619045
R5254 n_13_2_1 n_13_3_1 5.290849243184507
R5255 n_13_2_1 n_13_2_2 479.4848587005058
R5256 n_13_2_2 n_14_2_2 13857.541637925166
R5257 n_13_2_2 n_13_3_2 18.895890154230386
R5258 n_13_2_2 n_13_2_3 463.6122564814546
R5259 n_13_2_3 n_14_2_3 97002.79146547605
R5260 n_13_2_3 n_13_3_3 132.27123107961256
R5261 n_13_2_3 n_13_2_4 4.298829767659711
R5262 n_13_2_4 n_14_2_4 4409.217793885275
R5263 n_13_2_4 n_13_3_4 6.012328685436935
R5264 n_13_2_15 n_14_2_15 194005.58293095033
R5265 n_13_2_15 n_13_3_15 264.5424621592228
R5266 n_13_3_0 n_14_3_0 2771.5083275850325
R5267 n_13_3_0 n_13_4_0 110.44365038628546
R5268 n_13_3_0 n_13_3_1 109.12414025597718
R5269 n_13_3_1 n_14_3_1 3880.111658619045
R5270 n_13_3_1 n_13_4_1 154.6211105407996
R5271 n_13_3_1 n_13_3_2 479.4848587005058
R5272 n_13_3_2 n_14_3_2 13857.541637925166
R5273 n_13_3_2 n_13_4_2 552.2182519314273
R5274 n_13_3_2 n_13_3_3 463.6122564814546
R5275 n_13_3_3 n_14_3_3 97002.79146547605
R5276 n_13_3_3 n_13_4_3 3865.5277635199873
R5277 n_13_3_3 n_13_3_4 4.298829767659711
R5278 n_13_3_4 n_14_3_4 4409.217793885275
R5279 n_13_3_4 n_13_4_4 175.70580743272671
R5280 n_13_3_15 n_14_3_15 194005.58293095033
R5281 n_13_3_15 n_13_4_15 7731.055527039905
R5282 n_13_4_0 n_14_4_0 48.24335106234769
R5283 n_13_4_0 n_13_5_0 217.1081227417248
R5284 n_13_4_0 n_13_4_1 1.8995123180211542
R5285 n_13_4_1 n_14_4_1 67.54069148728678
R5286 n_13_4_1 n_13_5_1 303.9513718384147
R5287 n_13_4_1 n_13_4_2 8.346342003426283
R5288 n_13_4_2 n_14_4_2 241.2167553117385
R5289 n_13_4_2 n_13_5_2 1085.540613708624
R5290 n_13_4_2 n_13_4_3 8.070049302623206
R5291 n_13_4_3 n_14_4_3 1688.517287182168
R5292 n_13_4_3 n_13_5_3 7598.78429596036
R5293 n_13_4_3 n_13_4_4 0.07482927313416675
R5294 n_13_4_4 n_14_4_4 76.75078578100764
R5295 n_13_4_4 n_13_5_4 345.3992861800164
R5296 n_13_4_4 n_13_4_5 0.07482927313416675
R5297 n_13_4_5 n_13_5_5 7598.78429596036
R5298 n_13_4_5 n_13_4_6 0.1496585462683335
R5299 n_13_4_6 n_13_5_6 2532.928098653453
R5300 n_13_4_6 n_13_4_7 0.21873172146910252
R5301 n_13_4_7 n_13_5_7 4342.162454834505
R5302 n_13_4_7 n_13_4_8 0.16117074213512786
R5303 n_13_4_8 n_13_5_8 4342.162454834505
R5304 n_13_4_8 n_13_4_9 0.16117074213512786
R5305 n_13_4_9 n_13_5_9 4342.162454834505
R5306 n_13_4_9 n_13_4_10 0.16117074213512786
R5307 n_13_4_10 n_13_5_10 4342.162454834505
R5308 n_13_4_10 n_13_4_11 0.16117074213512683
R5309 n_13_4_11 n_13_5_11 4342.162454834561
R5310 n_13_4_11 n_13_4_12 0.16117074213512633
R5311 n_13_4_12 n_13_5_12 4342.1624548345335
R5312 n_13_4_12 n_13_4_13 0.16117074213512786
R5313 n_13_4_13 n_13_5_13 4342.162454834477
R5314 n_13_4_13 n_13_4_14 0.8058537106756414
R5315 n_13_4_14 n_13_5_14 482.4624949816107
R5316 n_13_4_14 n_13_4_15 3.027707512967074
R5317 n_13_4_15 n_14_4_15 3377.0345743643065
R5318 n_13_4_15 n_13_5_15 15197.568591920586
R5319 n_13_5_0 n_14_5_0 48.24335106234772
R5320 n_13_5_0 n_13_6_0 110.44365362970515
R5321 n_13_5_0 n_13_5_1 1.8995123180211544
R5322 n_13_5_1 n_14_5_1 67.5406914872868
R5323 n_13_5_1 n_13_6_1 154.62111508158716
R5324 n_13_5_1 n_13_5_2 8.346342003426285
R5325 n_13_5_2 n_14_5_2 241.2167553117386
R5326 n_13_5_2 n_13_6_2 552.2182681485257
R5327 n_13_5_2 n_13_5_3 8.070049302623207
R5328 n_13_5_3 n_14_5_3 1688.5172871821685
R5329 n_13_5_3 n_13_6_3 3865.5278770396762
R5330 n_13_5_3 n_13_5_4 0.07482927313416676
R5331 n_13_5_4 n_14_5_4 76.75078578100768
R5332 n_13_5_4 n_13_6_4 175.70581259271256
R5333 n_13_5_4 n_13_5_5 0.07482927313416676
R5334 n_13_5_5 n_13_5_6 0.14965854626833353
R5335 n_13_5_6 n_13_5_7 0.21873172146910258
R5336 n_13_5_7 n_13_5_8 0.16117074213512791
R5337 n_13_5_8 n_13_5_9 0.16117074213512791
R5338 n_13_5_9 n_13_5_10 0.16117074213512791
R5339 n_13_5_10 n_13_5_11 0.1611707421351269
R5340 n_13_5_11 n_13_5_12 0.1611707421351264
R5341 n_13_5_12 n_13_5_13 0.16117074213512791
R5342 n_13_5_13 n_13_5_14 0.8058537106756416
R5343 n_13_5_14 n_13_5_15 3.027707512967075
R5344 n_13_5_15 n_14_5_15 3377.0345743643074
R5345 n_13_5_15 n_13_6_15 7731.055754079283
R5346 n_13_6_0 n_14_6_0 2771.5035703868916
R5347 n_13_6_0 n_13_7_0 3.7791845176855285
R5348 n_13_6_0 n_13_6_1 109.1239529481665
R5349 n_13_6_1 n_14_6_1 3880.1049985416485
R5350 n_13_6_1 n_13_7_1 5.290858324759739
R5351 n_13_6_1 n_13_6_2 479.48403568133773
R5352 n_13_6_2 n_14_6_2 13857.51785193446
R5353 n_13_6_2 n_13_7_2 18.895922588427645
R5354 n_13_6_2 n_13_6_3 463.61146070705894
R5355 n_13_6_3 n_14_6_3 97002.62496354114
R5356 n_13_6_3 n_13_7_3 132.27145811899337
R5357 n_13_6_3 n_13_6_4 4.298822388867169
R5358 n_13_6_4 n_14_6_4 4409.210225615506
R5359 n_13_6_4 n_13_7_4 6.01233900540879
R5360 n_13_6_15 n_14_6_15 194005.24992708056
R5361 n_13_6_15 n_13_7_15 264.54291623798434
R5362 n_13_7_0 n_14_7_0 2771.5035703868916
R5363 n_13_7_0 n_13_8_0 110.44365362970515
R5364 n_13_7_0 n_13_7_1 109.1239529481665
R5365 n_13_7_1 n_14_7_1 3880.1049985416485
R5366 n_13_7_1 n_13_8_1 154.62111508158716
R5367 n_13_7_1 n_13_7_2 479.48403568133773
R5368 n_13_7_2 n_14_7_2 13857.51785193446
R5369 n_13_7_2 n_13_8_2 552.2182681485257
R5370 n_13_7_2 n_13_7_3 463.61146070705894
R5371 n_13_7_3 n_14_7_3 97002.62496354114
R5372 n_13_7_3 n_13_8_3 3865.5278770396762
R5373 n_13_7_3 n_13_7_4 4.298822388867169
R5374 n_13_7_4 n_14_7_4 4409.210225615506
R5375 n_13_7_4 n_13_8_4 175.70581259271256
R5376 n_13_7_15 n_14_7_15 194005.24992708056
R5377 n_13_7_15 n_13_8_15 7731.055754079283
R5378 n_13_8_0 n_14_8_0 48.24335106234772
R5379 n_13_8_0 n_13_9_0 217.10812274172477
R5380 n_13_8_0 n_13_8_1 1.8995123180211544
R5381 n_13_8_1 n_14_8_1 67.5406914872868
R5382 n_13_8_1 n_13_9_1 303.9513718384146
R5383 n_13_8_1 n_13_8_2 8.346342003426285
R5384 n_13_8_2 n_14_8_2 241.2167553117386
R5385 n_13_8_2 n_13_9_2 1085.5406137086238
R5386 n_13_8_2 n_13_8_3 8.070049302623207
R5387 n_13_8_3 n_14_8_3 1688.5172871821685
R5388 n_13_8_3 n_13_9_3 7598.7842959603595
R5389 n_13_8_3 n_13_8_4 0.07482927313416676
R5390 n_13_8_4 n_14_8_4 76.75078578100768
R5391 n_13_8_4 n_13_9_4 345.39928618001636
R5392 n_13_8_4 n_13_8_5 0.07482927313416676
R5393 n_13_8_5 n_13_9_5 7598.7842959603595
R5394 n_13_8_5 n_13_8_6 0.14965854626833353
R5395 n_13_8_6 n_13_9_6 2532.9280986534527
R5396 n_13_8_6 n_13_8_7 0.21873172146910258
R5397 n_13_8_7 n_13_9_7 4342.162454834504
R5398 n_13_8_7 n_13_8_8 0.16117074213512791
R5399 n_13_8_8 n_13_9_8 4342.162454834504
R5400 n_13_8_8 n_13_8_9 0.16117074213512791
R5401 n_13_8_9 n_13_9_9 4342.162454834504
R5402 n_13_8_9 n_13_8_10 0.16117074213512791
R5403 n_13_8_10 n_13_9_10 4342.162454834504
R5404 n_13_8_10 n_13_8_11 0.1611707421351269
R5405 n_13_8_11 n_13_9_11 4342.16245483456
R5406 n_13_8_11 n_13_8_12 0.1611707421351264
R5407 n_13_8_12 n_13_9_12 4342.162454834533
R5408 n_13_8_12 n_13_8_13 0.16117074213512791
R5409 n_13_8_13 n_13_9_13 4342.162454834477
R5410 n_13_8_13 n_13_8_14 0.8058537106756416
R5411 n_13_8_14 n_13_9_14 482.4624949816106
R5412 n_13_8_14 n_13_8_15 3.027707512967075
R5413 n_13_8_15 n_14_8_15 3377.0345743643074
R5414 n_13_8_15 n_13_9_15 15197.568591920583
R5415 n_13_9_0 n_14_9_0 48.24335106234772
R5416 n_13_9_0 n_13_10_0 110.4436539750823
R5417 n_13_9_0 n_13_9_1 1.8995123180211544
R5418 n_13_9_1 n_14_9_1 67.5406914872868
R5419 n_13_9_1 n_13_10_1 154.6211155651152
R5420 n_13_9_1 n_13_9_2 8.346342003426285
R5421 n_13_9_2 n_14_9_2 241.2167553117386
R5422 n_13_9_2 n_13_10_2 552.2182698754115
R5423 n_13_9_2 n_13_9_3 8.070049302623207
R5424 n_13_9_3 n_14_9_3 1688.5172871821685
R5425 n_13_9_3 n_13_10_3 3865.5278891278767
R5426 n_13_9_3 n_13_9_4 0.07482927313416676
R5427 n_13_9_4 n_14_9_4 76.75078578100768
R5428 n_13_9_4 n_13_10_4 175.70581314217623
R5429 n_13_9_4 n_13_9_5 0.07482927313416676
R5430 n_13_9_5 n_13_9_6 0.14965854626833353
R5431 n_13_9_6 n_13_9_7 0.21873172146910258
R5432 n_13_9_7 n_13_9_8 0.16117074213512791
R5433 n_13_9_8 n_13_9_9 0.16117074213512791
R5434 n_13_9_9 n_13_9_10 0.16117074213512791
R5435 n_13_9_10 n_13_9_11 0.1611707421351269
R5436 n_13_9_11 n_13_9_12 0.1611707421351264
R5437 n_13_9_12 n_13_9_13 0.16117074213512791
R5438 n_13_9_13 n_13_9_14 0.8058537106756416
R5439 n_13_9_14 n_13_9_15 3.027707512967075
R5440 n_13_9_15 n_14_9_15 3377.0345743643074
R5441 n_13_9_15 n_13_10_15 7731.055778255683
R5442 n_13_10_0 n_14_10_0 2771.5030638152666
R5443 n_13_10_0 n_13_11_0 3.7791852084397557
R5444 n_13_10_0 n_13_10_1 109.12393300263989
R5445 n_13_10_1 n_14_10_1 3880.1042893413724
R5446 n_13_10_1 n_13_11_1 5.290859291815657
R5447 n_13_10_1 n_13_10_2 479.4839480419026
R5448 n_13_10_2 n_14_10_2 13857.515319076336
R5449 n_13_10_2 n_13_11_2 18.89592604219878
R5450 n_13_10_2 n_13_10_3 463.6113759687913
R5451 n_13_10_3 n_14_10_3 97002.60723353423
R5452 n_13_10_3 n_13_11_3 132.2714822953913
R5453 n_13_10_3 n_13_10_4 4.298821603134302
R5454 n_13_10_4 n_14_10_4 4409.209419706102
R5455 n_13_10_4 n_13_11_4 6.012340104335969
R5456 n_13_10_15 n_14_10_15 194005.21446706675
R5457 n_13_10_15 n_13_11_15 264.54296459078023
R5458 n_13_11_0 n_14_11_0 2771.5030638153653
R5459 n_13_11_0 n_13_12_0 43.56171513923099
R5460 n_13_11_0 n_13_11_1 109.12393300264377
R5461 n_13_11_1 n_14_11_1 3880.1042893415106
R5462 n_13_11_1 n_13_12_1 60.98640119492338
R5463 n_13_11_1 n_13_11_2 479.4839480419196
R5464 n_13_11_2 n_14_11_2 13857.515319076825
R5465 n_13_11_2 n_13_12_2 217.80857569615495
R5466 n_13_11_2 n_13_11_3 463.61137596880775
R5467 n_13_11_3 n_14_11_3 97002.60723353768
R5468 n_13_11_3 n_13_12_3 1524.6600298730832
R5469 n_13_11_3 n_13_11_4 4.2988216031344555
R5470 n_13_11_4 n_14_11_4 4409.209419706258
R5471 n_13_11_4 n_13_12_4 69.30272863059469
R5472 n_13_11_15 n_14_11_15 194005.21446707365
R5473 n_13_11_15 n_13_12_15 3049.3200597461387
R5474 n_13_12_0 n_14_12_0 125.67182503262798
R5475 n_13_12_0 n_13_13_0 83.34424507002237
R5476 n_13_12_0 n_13_12_1 4.948146727394008
R5477 n_13_12_1 n_14_12_1 175.94055504567913
R5478 n_13_12_1 n_13_13_1 116.6819430980313
R5479 n_13_12_1 n_13_12_2 21.74185683248882
R5480 n_13_12_2 n_14_12_2 628.3591251631398
R5481 n_13_12_2 n_13_13_2 416.7212253501118
R5482 n_13_12_2 n_13_12_3 21.02212639941333
R5483 n_13_12_3 n_14_12_3 4398.513876141974
R5484 n_13_12_3 n_13_13_3 2917.0485774507797
R5485 n_13_12_3 n_13_12_4 0.19492699229127924
R5486 n_13_12_4 n_14_12_4 199.93244891554428
R5487 n_13_12_4 n_13_13_4 132.59311715685362
R5488 n_13_12_4 n_13_12_5 0.170650370540717
R5489 n_13_12_5 n_14_12_5 837.8121668841856
R5490 n_13_12_5 n_13_13_5 555.6283004668152
R5491 n_13_12_5 n_13_12_6 0.0399850240597496
R5492 n_13_12_6 n_14_12_6 139.63536114736425
R5493 n_13_12_6 n_13_13_6 92.60471674446919
R5494 n_13_12_6 n_13_12_7 0.05426538979537439
R5495 n_13_12_7 n_14_12_7 239.37490482405377
R5496 n_13_12_7 n_13_13_7 158.75094299051912
R5497 n_13_12_7 n_13_12_8 0.03998502405974947
R5498 n_13_12_8 n_14_12_8 239.37490482405377
R5499 n_13_12_8 n_13_13_8 158.75094299051912
R5500 n_13_12_8 n_13_12_9 0.03998502405974947
R5501 n_13_12_9 n_14_12_9 239.37490482405377
R5502 n_13_12_9 n_13_13_9 158.75094299051912
R5503 n_13_12_9 n_13_12_10 0.03998502405974947
R5504 n_13_12_10 n_14_12_10 239.37490482405377
R5505 n_13_12_10 n_13_13_10 158.75094299051912
R5506 n_13_12_10 n_13_12_11 0.039985024059749213
R5507 n_13_12_11 n_14_12_11 239.3749048240569
R5508 n_13_12_11 n_13_13_11 158.75094299052114
R5509 n_13_12_11 n_13_12_12 0.03998502405974909
R5510 n_13_12_12 n_14_12_12 239.37490482405528
R5511 n_13_12_12 n_13_13_12 158.75094299052012
R5512 n_13_12_12 n_13_12_13 0.03998502405974947
R5513 n_13_12_13 n_14_12_13 239.37490482405227
R5514 n_13_12_13 n_13_13_13 158.75094299051807
R5515 n_13_12_13 n_13_12_14 0.19992512029874787
R5516 n_13_12_14 n_14_12_14 26.597211647117028
R5517 n_13_12_14 n_13_13_14 17.638993665613196
R5518 n_13_12_14 n_13_12_15 6.177686217231366
R5519 n_13_12_15 n_14_12_15 8797.02775228387
R5520 n_13_12_15 n_13_13_15 5834.097154901507
R5521 n_13_13_0 n_14_13_0 125.67182503262775
R5522 n_13_13_0 n_13_13_1 4.948146727394
R5523 n_13_13_1 n_14_13_1 175.94055504567885
R5524 n_13_13_1 n_13_13_2 21.741856832488782
R5525 n_13_13_2 n_14_13_2 628.3591251631387
R5526 n_13_13_2 n_13_13_3 21.022126399413292
R5527 n_13_13_3 n_14_13_3 4398.513876141968
R5528 n_13_13_3 n_13_13_4 0.19492699229127897
R5529 n_13_13_4 n_14_13_4 199.93244891554394
R5530 n_13_13_4 n_13_13_5 0.17065037054071674
R5531 n_13_13_5 n_14_13_5 837.8121668841843
R5532 n_13_13_5 n_13_13_6 0.039985024059749526
R5533 n_13_13_6 n_14_13_6 139.63536114736402
R5534 n_13_13_6 n_13_13_7 0.05426538979537429
R5535 n_13_13_7 n_14_13_7 239.37490482405337
R5536 n_13_13_7 n_13_13_8 0.0399850240597494
R5537 n_13_13_8 n_14_13_8 239.37490482405337
R5538 n_13_13_8 n_13_13_9 0.0399850240597494
R5539 n_13_13_9 n_14_13_9 239.37490482405337
R5540 n_13_13_9 n_13_13_10 0.0399850240597494
R5541 n_13_13_10 n_14_13_10 239.37490482405337
R5542 n_13_13_10 n_13_13_11 0.039985024059749144
R5543 n_13_13_11 n_14_13_11 239.37490482405642
R5544 n_13_13_11 n_13_13_12 0.03998502405974902
R5545 n_13_13_12 n_14_13_12 239.37490482405494
R5546 n_13_13_12 n_13_13_13 0.0399850240597494
R5547 n_13_13_13 n_14_13_13 239.37490482405187
R5548 n_13_13_13 n_13_13_14 0.19992512029874748
R5549 n_13_13_14 n_14_13_14 26.597211647116985
R5550 n_13_13_14 n_13_13_15 6.177686217231354
R5551 n_13_13_15 n_14_13_15 8797.027752283855
R5552 n_14_0_0 n_15_0_0 6.477753269925552
R5553 n_14_0_0 n_14_1_0 3150.5002452094077
R5554 n_14_0_0 n_14_0_1 187.04512566910492
R5555 n_14_0_1 n_15_0_1 9.06885457789577
R5556 n_14_0_1 n_14_1_1 4410.700343293171
R5557 n_14_0_1 n_14_0_2 821.8649461218246
R5558 n_14_0_2 n_15_0_2 32.38876634962776
R5559 n_14_0_2 n_14_1_2 15752.501226047036
R5560 n_14_0_2 n_14_0_3 794.6583823881366
R5561 n_14_0_3 n_15_0_3 226.72136444739408
R5562 n_14_0_3 n_14_1_3 110267.50858232914
R5563 n_14_0_3 n_14_0_4 7.368444344540503
R5564 n_14_0_4 n_15_0_4 10.30551656579064
R5565 n_14_0_4 n_14_1_4 5012.159481014963
R5566 n_14_0_4 n_14_0_5 6.450762631301027
R5567 n_14_0_5 n_15_0_5 43.18502179950363
R5568 n_14_0_5 n_14_1_5 21003.334968062696
R5569 n_14_0_5 n_14_0_6 1.5114757629826676
R5570 n_14_0_6 n_15_0_6 7.197503633250607
R5571 n_14_0_6 n_14_1_6 3500.5558280104497
R5572 n_14_0_6 n_14_0_7 2.051288535476475
R5573 n_14_0_7 n_15_0_7 12.338577657001077
R5574 n_14_0_7 n_14_1_7 6000.952848017933
R5575 n_14_0_7 n_14_0_8 1.511475762982663
R5576 n_14_0_8 n_15_0_8 12.338577657001077
R5577 n_14_0_8 n_14_1_8 6000.952848017933
R5578 n_14_0_8 n_14_0_9 1.511475762982663
R5579 n_14_0_9 n_15_0_9 12.338577657001077
R5580 n_14_0_9 n_14_1_9 6000.952848017933
R5581 n_14_0_9 n_14_0_10 1.511475762982663
R5582 n_14_0_10 n_15_0_10 12.338577657001077
R5583 n_14_0_10 n_14_1_10 6000.952848017933
R5584 n_14_0_10 n_14_0_11 1.5114757629826534
R5585 n_14_0_11 n_15_0_11 12.338577657001235
R5586 n_14_0_11 n_14_1_11 6000.952848018009
R5587 n_14_0_11 n_14_0_12 1.5114757629826485
R5588 n_14_0_12 n_15_0_12 12.33857765700116
R5589 n_14_0_12 n_14_1_12 6000.9528480179715
R5590 n_14_0_12 n_14_0_13 1.5114757629826627
R5591 n_14_0_13 n_15_0_13 12.338577657001
R5592 n_14_0_13 n_14_1_13 6000.952848017895
R5593 n_14_0_13 n_14_0_14 7.557378814913333
R5594 n_14_0_14 n_15_0_14 1.3709530730001167
R5595 n_14_0_14 n_14_1_14 666.7725386686578
R5596 n_14_0_14 n_14_0_15 233.52300538082412
R5597 n_14_0_15 n_15_0_15 453.4427288947842
R5598 n_14_0_15 n_14_1_15 220535.0171646564
R5599 n_14_1_0 n_15_1_0 6.477753269925552
R5600 n_14_1_0 n_14_2_0 1646.6785714286066
R5601 n_14_1_0 n_14_1_1 187.04512566910492
R5602 n_14_1_1 n_15_1_1 9.06885457789577
R5603 n_14_1_1 n_14_2_1 2305.350000000049
R5604 n_14_1_1 n_14_1_2 821.8649461218246
R5605 n_14_1_2 n_15_1_2 32.38876634962776
R5606 n_14_1_2 n_14_2_2 8233.392857143032
R5607 n_14_1_2 n_14_1_3 794.6583823881366
R5608 n_14_1_3 n_15_1_3 226.72136444739408
R5609 n_14_1_3 n_14_2_3 57633.750000001164
R5610 n_14_1_3 n_14_1_4 7.368444344540503
R5611 n_14_1_4 n_15_1_4 10.30551656579064
R5612 n_14_1_4 n_14_2_4 2619.715909090963
R5613 n_14_1_4 n_14_1_5 6.450762631301027
R5614 n_14_1_5 n_15_1_5 43.18502179950363
R5615 n_14_1_5 n_14_1_6 1.5114757629826676
R5616 n_14_1_6 n_15_1_6 7.197503633250607
R5617 n_14_1_6 n_14_1_7 2.051288535476475
R5618 n_14_1_7 n_15_1_7 12.338577657001077
R5619 n_14_1_7 n_14_1_8 1.511475762982663
R5620 n_14_1_8 n_15_1_8 12.338577657001077
R5621 n_14_1_8 n_14_1_9 1.511475762982663
R5622 n_14_1_9 n_15_1_9 12.338577657001077
R5623 n_14_1_9 n_14_1_10 1.511475762982663
R5624 n_14_1_10 n_15_1_10 12.338577657001077
R5625 n_14_1_10 n_14_1_11 1.5114757629826534
R5626 n_14_1_11 n_15_1_11 12.338577657001235
R5627 n_14_1_11 n_14_1_12 1.5114757629826485
R5628 n_14_1_12 n_15_1_12 12.33857765700116
R5629 n_14_1_12 n_14_1_13 1.5114757629826627
R5630 n_14_1_13 n_15_1_13 12.338577657001
R5631 n_14_1_13 n_14_1_14 7.557378814913333
R5632 n_14_1_14 n_15_1_14 1.3709530730001167
R5633 n_14_1_14 n_14_1_15 233.52300538082412
R5634 n_14_1_15 n_15_1_15 453.4427288947842
R5635 n_14_1_15 n_14_2_15 115267.50000000135
R5636 n_14_2_0 n_15_2_0 142.85738806690358
R5637 n_14_2_0 n_14_3_0 142.8568976478056
R5638 n_14_2_0 n_14_2_1 4125.007080431944
R5639 n_14_2_1 n_15_2_1 200.00034329366503
R5640 n_14_2_1 n_14_3_1 199.99965670692785
R5641 n_14_2_1 n_14_2_2 18125.031110988843
R5642 n_14_2_2 n_15_2_2 714.286940334518
R5643 n_14_2_2 n_14_3_2 714.284488239028
R5644 n_14_2_2 n_14_2_3 17525.030081107834
R5645 n_14_2_3 n_15_2_3 5000.008582341621
R5646 n_14_2_3 n_14_3_3 4999.991417673191
R5647 n_14_2_3 n_14_2_4 162.500278926107
R5648 n_14_2_4 n_15_2_4 227.27311737916457
R5649 n_14_2_4 n_14_3_4 227.27233716696327
R5650 n_14_2_15 n_15_2_15 10000.017164683151
R5651 n_14_2_15 n_14_3_15 9999.982835346296
R5652 n_14_3_0 n_15_3_0 142.85738806690358
R5653 n_14_3_0 n_14_4_0 4174.885948823991
R5654 n_14_3_0 n_14_3_1 4125.007080431944
R5655 n_14_3_1 n_15_3_1 200.00034329366503
R5656 n_14_3_1 n_14_4_1 5844.840328353588
R5657 n_14_3_1 n_14_3_2 18125.031110988843
R5658 n_14_3_2 n_15_3_2 714.286940334518
R5659 n_14_3_2 n_14_4_2 20874.429744119952
R5660 n_14_3_2 n_14_3_3 17525.030081107834
R5661 n_14_3_3 n_15_3_3 5000.008582341621
R5662 n_14_3_3 n_14_4_3 146121.00820883954
R5663 n_14_3_3 n_14_3_4 162.500278926107
R5664 n_14_3_4 n_15_3_4 227.27311737916457
R5665 n_14_3_4 n_14_4_4 6641.864009492708
R5666 n_14_3_15 n_15_3_15 10000.017164683151
R5667 n_14_3_15 n_14_4_15 292242.0164176765
R5668 n_14_4_0 n_15_4_0 2.4867033794435605
R5669 n_14_4_0 n_14_5_0 8206.915000000175
R5670 n_14_4_0 n_14_4_1 71.8035600814346
R5671 n_14_4_1 n_15_4_1 3.481384731220985
R5672 n_14_4_1 n_14_5_1 11489.681000000246
R5673 n_14_4_1 n_14_4_2 315.50049126690965
R5674 n_14_4_2 n_15_4_2 12.433516897217803
R5675 n_14_4_2 n_14_5_2 41034.57500000087
R5676 n_14_4_2 n_14_4_3 305.0563370732464
R5677 n_14_4_3 n_15_4_3 87.03461828052454
R5678 n_14_4_3 n_14_5_3 287242.02500000584
R5679 n_14_4_3 n_14_4_4 2.828625094117123
R5680 n_14_4_4 n_15_4_4 3.956119012751116
R5681 n_14_4_4 n_14_5_4 13056.45568181845
R5682 n_14_4_15 n_15_4_15 174.06923656104755
R5683 n_14_4_15 n_14_5_15 574484.0500000068
R5684 n_14_5_0 n_15_5_0 2.4867033794435622
R5685 n_14_5_0 n_14_6_0 4174.886071428661
R5686 n_14_5_0 n_14_5_1 71.80356008143463
R5687 n_14_5_1 n_15_5_1 3.4813847312209862
R5688 n_14_5_1 n_14_6_1 5844.840500000126
R5689 n_14_5_1 n_14_5_2 315.50049126690976
R5690 n_14_5_2 n_15_5_2 12.433516897217809
R5691 n_14_5_2 n_14_6_2 20874.430357143305
R5692 n_14_5_2 n_14_5_3 305.05633707324654
R5693 n_14_5_3 n_15_5_3 87.03461828052458
R5694 n_14_5_3 n_14_6_3 146121.01250000298
R5695 n_14_5_3 n_14_5_4 2.828625094117124
R5696 n_14_5_4 n_15_5_4 3.9561190127511177
R5697 n_14_5_4 n_14_6_4 6641.864204545592
R5698 n_14_5_15 n_15_5_15 174.0692365610476
R5699 n_14_5_15 n_14_6_15 292242.02500000346
R5700 n_14_6_0 n_15_6_0 142.85714285714033
R5701 n_14_6_0 n_14_7_0 142.85714285714795
R5702 n_14_6_0 n_14_6_1 4125.000000000029
R5703 n_14_6_1 n_15_6_1 199.99999999999648
R5704 n_14_6_1 n_14_7_1 200.00000000000713
R5705 n_14_6_1 n_14_6_2 18125.000000000127
R5706 n_14_6_2 n_15_6_2 714.2857142857017
R5707 n_14_6_2 n_14_7_2 714.2857142857397
R5708 n_14_6_2 n_14_6_3 17525.000000000124
R5709 n_14_6_3 n_15_6_3 4999.999999999907
R5710 n_14_6_3 n_14_7_3 5000.000000000173
R5711 n_14_6_3 n_14_6_4 162.5000000000013
R5712 n_14_6_4 n_15_6_4 227.27272727272307
R5713 n_14_6_4 n_14_7_4 227.27272727273518
R5714 n_14_6_15 n_15_6_15 9999.999999999727
R5715 n_14_6_15 n_14_7_15 10000.00000000026
R5716 n_14_7_0 n_15_7_0 142.85714285714033
R5717 n_14_7_0 n_14_8_0 4174.886071428661
R5718 n_14_7_0 n_14_7_1 4125.000000000029
R5719 n_14_7_1 n_15_7_1 199.99999999999648
R5720 n_14_7_1 n_14_8_1 5844.840500000126
R5721 n_14_7_1 n_14_7_2 18125.000000000127
R5722 n_14_7_2 n_15_7_2 714.2857142857017
R5723 n_14_7_2 n_14_8_2 20874.430357143305
R5724 n_14_7_2 n_14_7_3 17525.000000000124
R5725 n_14_7_3 n_15_7_3 4999.999999999907
R5726 n_14_7_3 n_14_8_3 146121.01250000298
R5727 n_14_7_3 n_14_7_4 162.5000000000013
R5728 n_14_7_4 n_15_7_4 227.27272727272307
R5729 n_14_7_4 n_14_8_4 6641.864204545592
R5730 n_14_7_15 n_15_7_15 9999.999999999727
R5731 n_14_7_15 n_14_8_15 292242.02500000346
R5732 n_14_8_0 n_15_8_0 2.4867033794435622
R5733 n_14_8_0 n_14_9_0 8206.915000000174
R5734 n_14_8_0 n_14_8_1 71.80356008143463
R5735 n_14_8_1 n_15_8_1 3.4813847312209862
R5736 n_14_8_1 n_14_9_1 11489.681000000244
R5737 n_14_8_1 n_14_8_2 315.50049126690976
R5738 n_14_8_2 n_15_8_2 12.433516897217809
R5739 n_14_8_2 n_14_9_2 41034.57500000087
R5740 n_14_8_2 n_14_8_3 305.05633707324654
R5741 n_14_8_3 n_15_8_3 87.03461828052458
R5742 n_14_8_3 n_14_9_3 287242.0250000058
R5743 n_14_8_3 n_14_8_4 2.828625094117124
R5744 n_14_8_4 n_15_8_4 3.9561190127511177
R5745 n_14_8_4 n_14_9_4 13056.455681818448
R5746 n_14_8_15 n_15_8_15 174.0692365610476
R5747 n_14_8_15 n_14_9_15 574484.0500000067
R5748 n_14_9_0 n_15_9_0 2.4867033794435622
R5749 n_14_9_0 n_14_10_0 4174.886084484279
R5750 n_14_9_0 n_14_9_1 71.80356008143463
R5751 n_14_9_1 n_15_9_1 3.4813847312209862
R5752 n_14_9_1 n_14_10_1 5844.840518277992
R5753 n_14_9_1 n_14_9_2 315.50049126690976
R5754 n_14_9_2 n_15_9_2 12.433516897217809
R5755 n_14_9_2 n_14_10_2 20874.4304224214
R5756 n_14_9_2 n_14_9_3 305.05633707324654
R5757 n_14_9_3 n_15_9_3 87.03461828052458
R5758 n_14_9_3 n_14_10_3 146121.01295694965
R5759 n_14_9_3 n_14_9_4 2.828625094117124
R5760 n_14_9_4 n_15_9_4 3.9561190127511177
R5761 n_14_9_4 n_14_10_4 6641.864225315894
R5762 n_14_9_15 n_15_9_15 174.0692365610476
R5763 n_14_9_15 n_14_10_15 292242.0259138968
R5764 n_14_10_0 n_15_10_0 142.8571167459075
R5765 n_14_10_0 n_14_11_0 142.857168968383
R5766 n_14_10_0 n_14_10_1 4124.999246038181
R5767 n_14_10_1 n_15_10_1 199.99996344427046
R5768 n_14_10_1 n_14_11_1 200.00003655573624
R5769 n_14_10_1 n_14_10_2 18124.99668713746
R5770 n_14_10_2 n_15_10_2 714.2855837295376
R5771 n_14_10_2 n_14_11_2 714.2858448419149
R5772 n_14_10_2 n_14_10_3 17524.996796804633
R5773 n_14_10_3 n_15_10_3 4999.999086106758
R5774 n_14_10_3 n_14_11_3 5000.0009138934
R5775 n_14_10_3 n_14_10_4 162.49997029847395
R5776 n_14_10_4 n_15_10_4 227.27268573212538
R5777 n_14_10_4 n_14_11_4 227.27276881333643
R5778 n_14_10_15 n_15_10_15 9999.998172213425
R5779 n_14_10_15 n_14_11_15 10000.001827786715
R5780 n_14_11_0 n_15_11_0 142.85711674591255
R5781 n_14_11_0 n_14_12_0 1646.6785714286045
R5782 n_14_11_0 n_14_11_1 4124.999246038327
R5783 n_14_11_1 n_15_11_1 199.9999634442776
R5784 n_14_11_1 n_14_12_1 2305.3500000000463
R5785 n_14_11_1 n_14_11_2 18124.996687138108
R5786 n_14_11_2 n_15_11_2 714.2855837295629
R5787 n_14_11_2 n_14_12_2 8233.392857143022
R5788 n_14_11_2 n_14_11_3 17524.99679680526
R5789 n_14_11_3 n_15_11_3 4999.999086106935
R5790 n_14_11_3 n_14_12_3 57633.7500000011
R5791 n_14_11_3 n_14_11_4 162.4999702984797
R5792 n_14_11_4 n_15_11_4 227.27268573213343
R5793 n_14_11_4 n_14_12_4 2619.71590909096
R5794 n_14_11_15 n_15_11_15 9999.998172213782
R5795 n_14_11_15 n_14_12_15 115267.50000000121
R5796 n_14_12_0 n_15_12_0 6.477753827788678
R5797 n_14_12_0 n_14_13_0 3150.499973888831
R5798 n_14_12_0 n_14_12_1 187.0451417774027
R5799 n_14_12_1 n_15_12_1 9.068855358904148
R5800 n_14_12_1 n_14_13_1 4410.699963444364
R5801 n_14_12_1 n_14_12_2 821.8650169007088
R5802 n_14_12_2 n_15_12_2 32.38876913894339
R5803 n_14_12_2 n_14_13_2 15752.499869444155
R5804 n_14_12_2 n_14_12_3 794.6584508239957
R5805 n_14_12_3 n_15_12_3 226.7213839726035
R5806 n_14_12_3 n_14_13_3 110267.49908610898
R5807 n_14_12_3 n_14_12_4 7.36844497910981
R5808 n_14_12_4 n_15_12_4 10.30551745330016
R5809 n_14_12_4 n_14_13_4 5012.159049368591
R5810 n_14_12_4 n_14_12_5 6.450763186839724
R5811 n_14_12_5 n_15_12_5 43.18502551859115
R5812 n_14_12_5 n_14_13_5 21003.33315925885
R5813 n_14_12_5 n_14_12_6 1.5114758931507302
R5814 n_14_12_6 n_15_12_6 7.197504253098524
R5815 n_14_12_6 n_14_13_6 3500.5555265431426
R5816 n_14_12_6 n_14_12_7 2.0512887121331316
R5817 n_14_12_7 n_15_12_7 12.33857871959751
R5818 n_14_12_7 n_14_13_7 6000.952331216835
R5819 n_14_12_7 n_14_12_8 1.5114758931507255
R5820 n_14_12_8 n_15_12_8 12.33857871959751
R5821 n_14_12_8 n_14_13_8 6000.952331216835
R5822 n_14_12_8 n_14_12_9 1.5114758931507255
R5823 n_14_12_9 n_15_12_9 12.33857871959751
R5824 n_14_12_9 n_14_13_9 6000.952331216835
R5825 n_14_12_9 n_14_12_10 1.5114758931507255
R5826 n_14_12_10 n_15_12_10 12.33857871959751
R5827 n_14_12_10 n_14_13_10 6000.952331216835
R5828 n_14_12_10 n_14_12_11 1.511475893150716
R5829 n_14_12_11 n_15_12_11 12.33857871959767
R5830 n_14_12_11 n_14_13_11 6000.952331216911
R5831 n_14_12_11 n_14_12_12 1.511475893150711
R5832 n_14_12_12 n_15_12_12 12.338578719597585
R5833 n_14_12_12 n_14_13_12 6000.952331216873
R5834 n_14_12_12 n_14_12_13 1.5114758931507253
R5835 n_14_12_13 n_15_12_13 12.338578719597432
R5836 n_14_12_13 n_14_13_13 6000.952331216797
R5837 n_14_12_13 n_14_12_14 7.557379465753646
R5838 n_14_12_14 n_15_12_14 1.3709531910663868
R5839 n_14_12_14 n_14_13_14 666.7724812463136
R5840 n_14_12_14 n_14_12_15 233.52302549178984
R5841 n_14_12_15 n_15_12_15 453.44276794520306
R5842 n_14_12_15 n_14_13_15 220534.99817221606
R5843 n_14_13_0 n_15_13_0 6.477753827788668
R5844 n_14_13_0 n_14_13_1 187.0451417774024
R5845 n_14_13_1 n_15_13_1 9.068855358904134
R5846 n_14_13_1 n_14_13_2 821.8650169007075
R5847 n_14_13_2 n_15_13_2 32.38876913894334
R5848 n_14_13_2 n_14_13_3 794.6584508239944
R5849 n_14_13_3 n_15_13_3 226.72138397260318
R5850 n_14_13_3 n_14_13_4 7.368444979109798
R5851 n_14_13_4 n_15_13_4 10.305517453300142
R5852 n_14_13_4 n_14_13_5 6.450763186839714
R5853 n_14_13_5 n_15_13_5 43.18502551859108
R5854 n_14_13_5 n_14_13_6 1.5114758931507282
R5855 n_14_13_6 n_15_13_6 7.197504253098513
R5856 n_14_13_6 n_14_13_7 2.0512887121331285
R5857 n_14_13_7 n_15_13_7 12.33857871959749
R5858 n_14_13_7 n_14_13_8 1.5114758931507233
R5859 n_14_13_8 n_15_13_8 12.33857871959749
R5860 n_14_13_8 n_14_13_9 1.5114758931507233
R5861 n_14_13_9 n_15_13_9 12.33857871959749
R5862 n_14_13_9 n_14_13_10 1.5114758931507233
R5863 n_14_13_10 n_15_13_10 12.33857871959749
R5864 n_14_13_10 n_14_13_11 1.5114758931507137
R5865 n_14_13_11 n_15_13_11 12.338578719597646
R5866 n_14_13_11 n_14_13_12 1.5114758931507088
R5867 n_14_13_12 n_15_13_12 12.338578719597567
R5868 n_14_13_12 n_14_13_13 1.511475893150723
R5869 n_14_13_13 n_15_13_13 12.338578719597411
R5870 n_14_13_13 n_14_13_14 7.557379465753635
R5871 n_14_13_14 n_15_13_14 1.3709531910663846
R5872 n_14_13_14 n_14_13_15 233.52302549178947
R5873 n_14_13_15 n_15_13_15 453.44276794520226
R5874 n_15_0_0 n_16_0_0 19.585244109562872
R5875 n_15_0_0 n_15_1_0 3150.5002452092954
R5876 n_15_0_0 n_15_0_1 187.0451256690983
R5877 n_15_0_1 n_16_0_1 27.419341753388018
R5878 n_15_0_1 n_15_1_1 4410.700343293014
R5879 n_15_0_1 n_15_0_2 821.8649461217955
R5880 n_15_0_2 n_16_0_2 97.92622054781435
R5881 n_15_0_2 n_15_1_2 15752.50122604648
R5882 n_15_0_2 n_15_0_3 794.6583823881084
R5883 n_15_0_3 n_16_0_3 685.4835438346998
R5884 n_15_0_3 n_15_1_3 110267.50858232524
R5885 n_15_0_3 n_15_0_4 7.368444344540243
R5886 n_15_0_4 n_16_0_4 31.158342901577267
R5887 n_15_0_4 n_15_1_4 5012.159481014784
R5888 n_15_0_4 n_15_0_5 6.450762631300798
R5889 n_15_0_5 n_16_0_5 130.56829406375232
R5890 n_15_0_5 n_15_1_5 21003.33496806195
R5891 n_15_0_5 n_15_0_6 1.5114757629826137
R5892 n_15_0_6 n_16_0_6 21.761382343958726
R5893 n_15_0_6 n_15_1_6 3500.5558280103255
R5894 n_15_0_6 n_15_0_7 2.051288535476402
R5895 n_15_0_7 n_16_0_7 37.30522687535793
R5896 n_15_0_7 n_15_1_7 6000.95284801772
R5897 n_15_0_7 n_15_0_8 1.511475762982609
R5898 n_15_0_8 n_16_0_8 37.30522687535793
R5899 n_15_0_8 n_15_1_8 6000.95284801772
R5900 n_15_0_8 n_15_0_9 1.511475762982609
R5901 n_15_0_9 n_16_0_9 37.30522687535793
R5902 n_15_0_9 n_15_1_9 6000.95284801772
R5903 n_15_0_9 n_15_0_10 1.511475762982609
R5904 n_15_0_10 n_16_0_10 37.30522687535793
R5905 n_15_0_10 n_15_1_10 6000.95284801772
R5906 n_15_0_10 n_15_0_11 1.5114757629825992
R5907 n_15_0_11 n_16_0_11 37.30522687535841
R5908 n_15_0_11 n_15_1_11 6000.952848017796
R5909 n_15_0_11 n_15_0_12 1.5114757629825943
R5910 n_15_0_12 n_16_0_12 37.30522687535818
R5911 n_15_0_12 n_15_1_12 6000.952848017758
R5912 n_15_0_12 n_15_0_13 1.511475762982609
R5913 n_15_0_13 n_16_0_13 37.3052268753577
R5914 n_15_0_13 n_15_1_13 6000.952848017681
R5915 n_15_0_13 n_15_0_14 7.557378814913063
R5916 n_15_0_14 n_16_0_14 4.145025208373095
R5917 n_15_0_14 n_15_1_14 666.7725386686341
R5918 n_15_0_14 n_15_0_15 233.52300538081585
R5919 n_15_0_15 n_16_0_15 1370.9670876693874
R5920 n_15_0_15 n_15_1_15 220535.01716464857
R5921 n_15_1_0 n_16_1_0 19.585244109562872
R5922 n_15_1_0 n_15_2_0 1646.678571428548
R5923 n_15_1_0 n_15_1_1 187.0451256690983
R5924 n_15_1_1 n_16_1_1 27.419341753388018
R5925 n_15_1_1 n_15_2_1 2305.3499999999676
R5926 n_15_1_1 n_15_1_2 821.8649461217955
R5927 n_15_1_2 n_16_1_2 97.92622054781435
R5928 n_15_1_2 n_15_2_2 8233.39285714274
R5929 n_15_1_2 n_15_1_3 794.6583823881084
R5930 n_15_1_3 n_16_1_3 685.4835438346998
R5931 n_15_1_3 n_15_2_3 57633.74999999913
R5932 n_15_1_3 n_15_1_4 7.368444344540243
R5933 n_15_1_4 n_16_1_4 31.158342901577267
R5934 n_15_1_4 n_15_2_4 2619.71590909087
R5935 n_15_1_4 n_15_1_5 6.450762631300798
R5936 n_15_1_5 n_16_1_5 130.56829406375232
R5937 n_15_1_5 n_15_1_6 1.5114757629826137
R5938 n_15_1_6 n_16_1_6 21.761382343958726
R5939 n_15_1_6 n_15_1_7 2.051288535476402
R5940 n_15_1_7 n_16_1_7 37.30522687535793
R5941 n_15_1_7 n_15_1_8 1.511475762982609
R5942 n_15_1_8 n_16_1_8 37.30522687535793
R5943 n_15_1_8 n_15_1_9 1.511475762982609
R5944 n_15_1_9 n_16_1_9 37.30522687535793
R5945 n_15_1_9 n_15_1_10 1.511475762982609
R5946 n_15_1_10 n_16_1_10 37.30522687535793
R5947 n_15_1_10 n_15_1_11 1.5114757629825992
R5948 n_15_1_11 n_16_1_11 37.30522687535841
R5949 n_15_1_11 n_15_1_12 1.5114757629825943
R5950 n_15_1_12 n_16_1_12 37.30522687535818
R5951 n_15_1_12 n_15_1_13 1.511475762982609
R5952 n_15_1_13 n_16_1_13 37.3052268753577
R5953 n_15_1_13 n_15_1_14 7.557378814913063
R5954 n_15_1_14 n_16_1_14 4.145025208373095
R5955 n_15_1_14 n_15_1_15 233.52300538081585
R5956 n_15_1_15 n_16_1_15 1370.9670876693874
R5957 n_15_1_15 n_15_2_15 115267.49999999725
R5958 n_15_2_0 n_16_2_0 431.9239559701565
R5959 n_15_2_0 n_15_3_0 142.8568976478005
R5960 n_15_2_0 n_15_2_1 4125.007080431797
R5961 n_15_2_1 n_16_2_1 604.6935383582189
R5962 n_15_2_1 n_15_3_1 199.99965670692075
R5963 n_15_2_1 n_15_2_2 18125.0311109882
R5964 n_15_2_2 n_16_2_2 2159.619779850783
R5965 n_15_2_2 n_15_3_2 714.2844882390027
R5966 n_15_2_2 n_15_2_3 17525.03008110721
R5967 n_15_2_3 n_16_2_3 15117.338458955463
R5968 n_15_2_3 n_15_3_3 4999.9914176730135
R5969 n_15_2_3 n_15_2_4 162.50027892610123
R5970 n_15_2_4 n_16_2_4 687.1517481343391
R5971 n_15_2_4 n_15_3_4 227.2723371669552
R5972 n_15_2_15 n_16_2_15 30234.67691791065
R5973 n_15_2_15 n_15_3_15 9999.98283534594
R5974 n_15_3_0 n_16_3_0 431.9239559701565
R5975 n_15_3_0 n_15_4_0 4174.885948823842
R5976 n_15_3_0 n_15_3_1 4125.007080431797
R5977 n_15_3_1 n_16_3_1 604.6935383582189
R5978 n_15_3_1 n_15_4_1 5844.84032835338
R5979 n_15_3_1 n_15_3_2 18125.0311109882
R5980 n_15_3_2 n_16_3_2 2159.619779850783
R5981 n_15_3_2 n_15_4_2 20874.429744119218
R5982 n_15_3_2 n_15_3_3 17525.03008110721
R5983 n_15_3_3 n_16_3_3 15117.338458955463
R5984 n_15_3_3 n_15_4_3 146121.00820883436
R5985 n_15_3_3 n_15_3_4 162.50027892610123
R5986 n_15_3_4 n_16_3_4 687.1517481343391
R5987 n_15_3_4 n_15_4_4 6641.864009492471
R5988 n_15_3_15 n_16_3_15 30234.67691791065
R5989 n_15_3_15 n_15_4_15 292242.01641766616
R5990 n_15_4_0 n_16_4_0 7.518454421626468
R5991 n_15_4_0 n_15_5_0 8206.914999999884
R5992 n_15_4_0 n_15_4_1 71.80356008143205
R5993 n_15_4_1 n_16_4_1 10.525836190277058
R5994 n_15_4_1 n_15_5_1 11489.680999999837
R5995 n_15_4_1 n_15_4_2 315.5004912668984
R5996 n_15_4_2 n_16_4_2 37.59227210813234
R5997 n_15_4_2 n_15_5_2 41034.57499999942
R5998 n_15_4_2 n_15_4_3 305.05633707323557
R5999 n_15_4_3 n_16_4_3 263.1459047569262
R6000 n_15_4_3 n_15_5_3 287242.02499999566
R6001 n_15_4_3 n_15_4_4 2.828625094117023
R6002 n_15_4_4 n_16_4_4 11.96117748895119
R6003 n_15_4_4 n_15_5_4 13056.455681817986
R6004 n_15_4_15 n_16_4_15 526.2918095138477
R6005 n_15_4_15 n_15_5_15 574484.0499999863
R6006 n_15_5_0 n_16_5_0 7.518454421626473
R6007 n_15_5_0 n_15_6_0 4174.886071428513
R6008 n_15_5_0 n_15_5_1 71.80356008143207
R6009 n_15_5_1 n_16_5_1 10.525836190277062
R6010 n_15_5_1 n_15_6_1 5844.8404999999175
R6011 n_15_5_1 n_15_5_2 315.5004912668985
R6012 n_15_5_2 n_16_5_2 37.59227210813236
R6013 n_15_5_2 n_15_6_2 20874.430357142566
R6014 n_15_5_2 n_15_5_3 305.0563370732357
R6015 n_15_5_3 n_16_5_3 263.1459047569263
R6016 n_15_5_3 n_15_6_3 146121.0124999978
R6017 n_15_5_3 n_15_5_4 2.8286250941170237
R6018 n_15_5_4 n_16_5_4 11.961177488951195
R6019 n_15_5_4 n_15_6_4 6641.864204545356
R6020 n_15_5_15 n_16_5_15 526.2918095138479
R6021 n_15_5_15 n_15_6_15 292242.02499999304
R6022 n_15_6_0 n_16_6_0 431.92321458763206
R6023 n_15_6_0 n_15_7_0 142.85714285714286
R6024 n_15_6_0 n_15_6_1 4124.999999999883
R6025 n_15_6_1 n_16_6_1 604.6925004226849
R6026 n_15_6_1 n_15_7_1 200.00000000000003
R6027 n_15_6_1 n_15_6_2 18124.999999999483
R6028 n_15_6_2 n_16_6_2 2159.616072938161
R6029 n_15_6_2 n_15_7_2 714.2857142857144
R6030 n_15_6_2 n_15_6_3 17524.9999999995
R6031 n_15_6_3 n_16_6_3 15117.31251056711
R6032 n_15_6_3 n_15_7_3 4999.999999999996
R6033 n_15_6_3 n_15_6_4 162.49999999999554
R6034 n_15_6_4 n_16_6_4 687.1505686621414
R6035 n_15_6_4 n_15_7_4 227.2727272727271
R6036 n_15_6_15 n_16_6_15 30234.625021133954
R6037 n_15_6_15 n_15_7_15 9999.999999999904
R6038 n_15_7_0 n_16_7_0 431.92321458763206
R6039 n_15_7_0 n_15_8_0 4174.886071428513
R6040 n_15_7_0 n_15_7_1 4124.999999999883
R6041 n_15_7_1 n_16_7_1 604.6925004226849
R6042 n_15_7_1 n_15_8_1 5844.8404999999175
R6043 n_15_7_1 n_15_7_2 18124.999999999483
R6044 n_15_7_2 n_16_7_2 2159.616072938161
R6045 n_15_7_2 n_15_8_2 20874.430357142566
R6046 n_15_7_2 n_15_7_3 17524.9999999995
R6047 n_15_7_3 n_16_7_3 15117.31251056711
R6048 n_15_7_3 n_15_8_3 146121.0124999978
R6049 n_15_7_3 n_15_7_4 162.49999999999554
R6050 n_15_7_4 n_16_7_4 687.1505686621414
R6051 n_15_7_4 n_15_8_4 6641.864204545356
R6052 n_15_7_15 n_16_7_15 30234.625021133954
R6053 n_15_7_15 n_15_8_15 292242.02499999304
R6054 n_15_8_0 n_16_8_0 7.518454421626473
R6055 n_15_8_0 n_15_9_0 8206.914999999883
R6056 n_15_8_0 n_15_8_1 71.80356008143207
R6057 n_15_8_1 n_16_8_1 10.525836190277062
R6058 n_15_8_1 n_15_9_1 11489.680999999835
R6059 n_15_8_1 n_15_8_2 315.5004912668985
R6060 n_15_8_2 n_16_8_2 37.59227210813236
R6061 n_15_8_2 n_15_9_2 41034.574999999415
R6062 n_15_8_2 n_15_8_3 305.0563370732357
R6063 n_15_8_3 n_16_8_3 263.1459047569263
R6064 n_15_8_3 n_15_9_3 287242.0249999956
R6065 n_15_8_3 n_15_8_4 2.8286250941170237
R6066 n_15_8_4 n_16_8_4 11.961177488951195
R6067 n_15_8_4 n_15_9_4 13056.455681817984
R6068 n_15_8_15 n_16_8_15 526.2918095138479
R6069 n_15_8_15 n_15_9_15 574484.0499999862
R6070 n_15_9_0 n_16_9_0 7.518454421626473
R6071 n_15_9_0 n_15_10_0 4174.886084484132
R6072 n_15_9_0 n_15_9_1 71.80356008143207
R6073 n_15_9_1 n_16_9_1 10.525836190277062
R6074 n_15_9_1 n_15_10_1 5844.840518277784
R6075 n_15_9_1 n_15_9_2 315.5004912668985
R6076 n_15_9_2 n_16_9_2 37.59227210813236
R6077 n_15_9_2 n_15_10_2 20874.430422420657
R6078 n_15_9_2 n_15_9_3 305.0563370732357
R6079 n_15_9_3 n_16_9_3 263.1459047569263
R6080 n_15_9_3 n_15_10_3 146121.01295694447
R6081 n_15_9_3 n_15_9_4 2.8286250941170237
R6082 n_15_9_4 n_16_9_4 11.961177488951195
R6083 n_15_9_4 n_15_10_4 6641.864225315659
R6084 n_15_9_15 n_16_9_15 526.2918095138479
R6085 n_15_9_15 n_15_10_15 292242.0259138864
R6086 n_15_10_0 n_16_10_0 431.92313564129876
R6087 n_15_10_0 n_15_11_0 142.85716896837795
R6088 n_15_10_0 n_15_10_1 4124.9992460380345
R6089 n_15_10_1 n_16_10_1 604.6923898978181
R6090 n_15_10_1 n_15_11_1 200.0000365557291
R6091 n_15_10_1 n_15_10_2 18124.99668713682
R6092 n_15_10_2 n_16_10_2 2159.615678206494
R6093 n_15_10_2 n_15_11_2 714.2858448418897
R6094 n_15_10_2 n_15_10_3 17524.996796804015
R6095 n_15_10_3 n_16_10_3 15117.30974744544
R6096 n_15_10_3 n_15_11_3 5000.000913893224
R6097 n_15_10_3 n_15_10_4 162.49997029846818
R6098 n_15_10_4 n_16_10_4 687.150443065702
R6099 n_15_10_4 n_15_11_4 227.27276881332836
R6100 n_15_10_15 n_16_10_15 30234.619494890612
R6101 n_15_10_15 n_15_11_15 10000.00182778636
R6102 n_15_11_0 n_16_11_0 431.92313564131405
R6103 n_15_11_0 n_15_12_0 1646.678571428546
R6104 n_15_11_0 n_15_11_1 4124.999246038181
R6105 n_15_11_1 n_16_11_1 604.6923898978396
R6106 n_15_11_1 n_15_12_1 2305.3499999999644
R6107 n_15_11_1 n_15_11_2 18124.99668713746
R6108 n_15_11_2 n_16_11_2 2159.61567820657
R6109 n_15_11_2 n_15_12_2 8233.392857142731
R6110 n_15_11_2 n_15_11_3 17524.996796804633
R6111 n_15_11_3 n_16_11_3 15117.30974744598
R6112 n_15_11_3 n_15_12_3 57633.74999999906
R6113 n_15_11_3 n_15_11_4 162.49997029847395
R6114 n_15_11_4 n_16_11_4 687.1504430657263
R6115 n_15_11_4 n_15_12_4 2619.7159090908667
R6116 n_15_11_15 n_16_11_15 30234.619494891685
R6117 n_15_11_15 n_15_12_15 115267.4999999971
R6118 n_15_12_0 n_16_12_0 19.585245796241118
R6119 n_15_12_0 n_15_13_0 3150.499973888719
R6120 n_15_12_0 n_15_12_1 187.04514177739605
R6121 n_15_12_1 n_16_12_1 27.419344114737562
R6122 n_15_12_1 n_15_13_1 4410.699963444207
R6123 n_15_12_1 n_15_12_2 821.8650169006796
R6124 n_15_12_2 n_16_12_2 97.92622898120557
R6125 n_15_12_2 n_15_13_2 15752.499869443598
R6126 n_15_12_2 n_15_12_3 794.6584508239675
R6127 n_15_12_3 n_16_12_3 685.4836028684383
R6128 n_15_12_3 n_15_13_3 110267.49908610508
R6129 n_15_12_3 n_15_12_4 7.368444979109548
R6130 n_15_12_4 n_16_12_4 31.158345584929023
R6131 n_15_12_4 n_15_13_4 5012.1590493684125
R6132 n_15_12_4 n_15_12_5 6.450763186839494
R6133 n_15_12_5 n_16_12_5 130.56830530827398
R6134 n_15_12_5 n_15_13_5 21003.33315925811
R6135 n_15_12_5 n_15_12_6 1.5114758931506769
R6136 n_15_12_6 n_16_12_6 21.761384218045663
R6137 n_15_12_6 n_15_13_6 3500.5555265430185
R6138 n_15_12_6 n_15_12_7 2.0512887121330587
R6139 n_15_12_7 n_16_12_7 37.305230088078396
R6140 n_15_12_7 n_15_13_7 6000.952331216622
R6141 n_15_12_7 n_15_12_8 1.511475893150672
R6142 n_15_12_8 n_16_12_8 37.305230088078396
R6143 n_15_12_8 n_15_13_8 6000.952331216622
R6144 n_15_12_8 n_15_12_9 1.511475893150672
R6145 n_15_12_9 n_16_12_9 37.305230088078396
R6146 n_15_12_9 n_15_13_9 6000.952331216622
R6147 n_15_12_9 n_15_12_10 1.511475893150672
R6148 n_15_12_10 n_16_12_10 37.305230088078396
R6149 n_15_12_10 n_15_13_10 6000.952331216622
R6150 n_15_12_10 n_15_12_11 1.5114758931506622
R6151 n_15_12_11 n_16_12_11 37.30523008807888
R6152 n_15_12_11 n_15_13_11 6000.9523312166975
R6153 n_15_12_11 n_15_12_12 1.5114758931506573
R6154 n_15_12_12 n_16_12_12 37.30523008807863
R6155 n_15_12_12 n_15_13_12 6000.95233121666
R6156 n_15_12_12 n_15_12_13 1.511475893150672
R6157 n_15_12_13 n_16_12_13 37.30523008807816
R6158 n_15_12_13 n_15_13_13 6000.952331216584
R6159 n_15_12_13 n_15_12_14 7.557379465753378
R6160 n_15_12_14 n_16_12_14 4.145025565342035
R6161 n_15_12_14 n_15_13_14 666.7724812462898
R6162 n_15_12_14 n_15_12_15 233.52302549178157
R6163 n_15_12_15 n_16_12_15 1370.9672057368646
R6164 n_15_12_15 n_15_13_15 220534.9981722082
R6165 n_15_13_0 n_16_13_0 19.585245796241082
R6166 n_15_13_0 n_15_13_1 187.04514177739577
R6167 n_15_13_1 n_16_13_1 27.419344114737516
R6168 n_15_13_1 n_15_13_2 821.8650169006784
R6169 n_15_13_2 n_16_13_2 97.92622898120544
R6170 n_15_13_2 n_15_13_3 794.6584508239663
R6171 n_15_13_3 n_16_13_3 685.4836028684373
R6172 n_15_13_3 n_15_13_4 7.368444979109538
R6173 n_15_13_4 n_16_13_4 31.158345584928966
R6174 n_15_13_4 n_15_13_5 6.4507631868394855
R6175 n_15_13_5 n_16_13_5 130.56830530827378
R6176 n_15_13_5 n_15_13_6 1.511475893150674
R6177 n_15_13_6 n_16_13_6 21.76138421804563
R6178 n_15_13_6 n_15_13_7 2.051288712133055
R6179 n_15_13_7 n_16_13_7 37.30523008807834
R6180 n_15_13_7 n_15_13_8 1.5114758931506693
R6181 n_15_13_8 n_16_13_8 37.30523008807834
R6182 n_15_13_8 n_15_13_9 1.5114758931506693
R6183 n_15_13_9 n_16_13_9 37.30523008807834
R6184 n_15_13_9 n_15_13_10 1.5114758931506693
R6185 n_15_13_10 n_16_13_10 37.30523008807834
R6186 n_15_13_10 n_15_13_11 1.5114758931506596
R6187 n_15_13_11 n_16_13_11 37.30523008807881
R6188 n_15_13_11 n_15_13_12 1.5114758931506547
R6189 n_15_13_12 n_16_13_12 37.305230088078574
R6190 n_15_13_12 n_15_13_13 1.5114758931506693
R6191 n_15_13_13 n_16_13_13 37.305230088078105
R6192 n_15_13_13 n_15_13_14 7.557379465753366
R6193 n_15_13_14 n_16_13_14 4.145025565342028
R6194 n_15_13_14 n_15_13_15 233.52302549178117
R6195 n_15_13_15 n_16_13_15 1370.9672057368623
R6196 n_16_0_0 n_17_0_0 32.692734949199966
R6197 n_16_0_0 n_16_1_0 624.2415416457984
R6198 n_16_0_0 n_16_0_1 37.06120568711565
R6199 n_16_0_1 n_17_0_1 45.769828928879946
R6200 n_16_0_1 n_16_1_1 873.9381583041177
R6201 n_16_0_1 n_16_0_2 162.84469165550814
R6202 n_16_0_2 n_17_0_2 163.4636747459998
R6203 n_16_0_2 n_16_1_2 3121.2077082289916
R6204 n_16_0_2 n_16_0_3 157.45397082829135
R6205 n_16_0_3 n_17_0_3 1144.2457232219977
R6206 n_16_0_3 n_16_1_3 21848.453957602924
R6207 n_16_0_3 n_16_0_4 1.4599868907045574
R6208 n_16_0_4 n_17_0_4 52.01116923736353
R6209 n_16_0_4 n_16_1_4 993.1115435274054
R6210 n_16_0_4 n_16_0_5 1.2781570215325613
R6211 n_16_0_5 n_17_0_5 217.9515663279995
R6212 n_16_0_5 n_16_1_5 4161.610277638652
R6213 n_16_0_5 n_16_0_6 0.2994844904009348
R6214 n_16_0_6 n_17_0_6 36.3252610546666
R6215 n_16_0_6 n_16_1_6 693.6017129397753
R6216 n_16_0_6 n_16_0_7 0.4064432369726968
R6217 n_16_0_7 n_17_0_7 62.27187609371435
R6218 n_16_0_7 n_16_1_7 1189.0315078967615
R6219 n_16_0_7 n_16_0_8 0.2994844904009339
R6220 n_16_0_8 n_17_0_8 62.27187609371435
R6221 n_16_0_8 n_16_1_8 1189.0315078967615
R6222 n_16_0_8 n_16_0_9 0.2994844904009339
R6223 n_16_0_9 n_17_0_9 62.27187609371435
R6224 n_16_0_9 n_16_1_9 1189.0315078967615
R6225 n_16_0_9 n_16_0_10 0.2994844904009339
R6226 n_16_0_10 n_17_0_10 62.27187609371435
R6227 n_16_0_10 n_16_1_10 1189.0315078967615
R6228 n_16_0_10 n_16_0_11 0.29948449040093195
R6229 n_16_0_11 n_17_0_11 62.27187609371514
R6230 n_16_0_11 n_16_1_11 1189.0315078967762
R6231 n_16_0_11 n_16_0_12 0.299484490400931
R6232 n_16_0_12 n_17_0_12 62.271876093714766
R6233 n_16_0_12 n_16_1_12 1189.031507896769
R6234 n_16_0_12 n_16_0_13 0.29948449040093383
R6235 n_16_0_13 n_17_0_13 62.271876093713956
R6236 n_16_0_13 n_16_1_13 1189.031507896754
R6237 n_16_0_13 n_16_0_14 1.4974224520046733
R6238 n_16_0_14 n_17_0_14 6.919097343746024
R6239 n_16_0_14 n_16_1_14 132.1146119885288
R6240 n_16_0_14 n_16_0_15 46.27035376694482
R6241 n_16_0_15 n_17_0_15 2288.491446443975
R6242 n_16_0_15 n_16_1_15 43696.907915205455
R6243 n_16_1_0 n_17_1_0 32.692734949199966
R6244 n_16_1_0 n_16_2_0 326.27363593662255
R6245 n_16_1_0 n_16_1_1 37.06120568711565
R6246 n_16_1_1 n_17_1_1 45.769828928879946
R6247 n_16_1_1 n_16_2_1 456.7830903112715
R6248 n_16_1_1 n_16_1_2 162.84469165550814
R6249 n_16_1_2 n_17_1_2 163.4636747459998
R6250 n_16_1_2 n_16_2_2 1631.3681796831127
R6251 n_16_1_2 n_16_1_3 157.45397082829135
R6252 n_16_1_3 n_17_1_3 1144.2457232219977
R6253 n_16_1_3 n_16_2_3 11419.577257781779
R6254 n_16_1_3 n_16_1_4 1.4599868907045574
R6255 n_16_1_4 n_17_1_4 52.01116923736353
R6256 n_16_1_4 n_16_2_4 519.0716935355352
R6257 n_16_1_4 n_16_1_5 1.2781570215325613
R6258 n_16_1_5 n_17_1_5 217.9515663279995
R6259 n_16_1_5 n_16_2_5 2175.1575729108154
R6260 n_16_1_5 n_16_1_6 0.2994844904009348
R6261 n_16_1_6 n_17_1_6 36.3252610546666
R6262 n_16_1_6 n_16_2_6 362.5262621518025
R6263 n_16_1_6 n_16_1_7 0.4064432369726968
R6264 n_16_1_7 n_17_1_7 62.27187609371435
R6265 n_16_1_7 n_16_2_7 621.4735922602348
R6266 n_16_1_7 n_16_1_8 0.2994844904009339
R6267 n_16_1_8 n_17_1_8 62.27187609371435
R6268 n_16_1_8 n_16_2_8 621.4735922602348
R6269 n_16_1_8 n_16_1_9 0.2994844904009339
R6270 n_16_1_9 n_17_1_9 62.27187609371435
R6271 n_16_1_9 n_16_2_9 621.4735922602348
R6272 n_16_1_9 n_16_1_10 0.2994844904009339
R6273 n_16_1_10 n_17_1_10 62.27187609371435
R6274 n_16_1_10 n_16_2_10 621.4735922602348
R6275 n_16_1_10 n_16_1_11 0.29948449040093195
R6276 n_16_1_11 n_17_1_11 62.27187609371514
R6277 n_16_1_11 n_16_2_11 621.4735922602425
R6278 n_16_1_11 n_16_1_12 0.299484490400931
R6279 n_16_1_12 n_17_1_12 62.271876093714766
R6280 n_16_1_12 n_16_2_12 621.4735922602388
R6281 n_16_1_12 n_16_1_13 0.29948449040093383
R6282 n_16_1_13 n_17_1_13 62.271876093713956
R6283 n_16_1_13 n_16_2_13 621.4735922602309
R6284 n_16_1_13 n_16_1_14 1.4974224520046733
R6285 n_16_1_14 n_17_1_14 6.919097343746024
R6286 n_16_1_14 n_16_2_14 69.05262136224817
R6287 n_16_1_14 n_16_1_15 46.27035376694482
R6288 n_16_1_15 n_17_1_15 2288.491446443975
R6289 n_16_1_15 n_16_2_15 22839.154515563354
R6290 n_16_2_0 n_17_2_0 720.9905238734043
R6291 n_16_2_0 n_16_3_0 28.30573022744671
R6292 n_16_2_0 n_16_2_1 817.3307661550474
R6293 n_16_2_1 n_17_2_1 1009.3867334227659
R6294 n_16_2_1 n_16_3_1 39.62802231842539
R6295 n_16_2_1 n_16_2_2 3591.3018512873296
R6296 n_16_2_2 n_17_2_2 3604.952619367022
R6297 n_16_2_2 n_16_3_2 141.52865113723354
R6298 n_16_2_2 n_16_2_3 3472.417376210232
R6299 n_16_2_3 n_17_2_3 25234.668335569128
R6300 n_16_2_3 n_16_3_3 990.7005579606339
R6301 n_16_2_3 n_16_2_4 32.19787866671402
R6302 n_16_2_4 n_17_2_4 1147.0303788895058
R6303 n_16_2_4 n_16_3_4 45.03184354366517
R6304 n_16_2_4 n_16_2_5 28.187886451811906
R6305 n_16_2_5 n_17_2_5 4806.603492489357
R6306 n_16_2_5 n_16_3_5 188.7048681829779
R6307 n_16_2_5 n_16_2_6 6.604693059838772
R6308 n_16_2_6 n_17_2_6 801.1005820815597
R6309 n_16_2_6 n_16_3_6 31.450811363829644
R6310 n_16_2_6 n_16_2_7 8.96351200978118
R6311 n_16_2_7 n_17_2_7 1373.3152835683923
R6312 n_16_2_7 n_16_3_7 53.91567662370813
R6313 n_16_2_7 n_16_2_8 6.604693059838752
R6314 n_16_2_8 n_17_2_8 1373.3152835683923
R6315 n_16_2_8 n_16_3_8 53.91567662370813
R6316 n_16_2_8 n_16_2_9 6.604693059838752
R6317 n_16_2_9 n_17_2_9 1373.3152835683923
R6318 n_16_2_9 n_16_3_9 53.91567662370813
R6319 n_16_2_9 n_16_2_10 6.604693059838752
R6320 n_16_2_10 n_17_2_10 1373.3152835683923
R6321 n_16_2_10 n_16_3_10 53.91567662370813
R6322 n_16_2_10 n_16_2_11 6.604693059838709
R6323 n_16_2_11 n_17_2_11 1373.3152835684095
R6324 n_16_2_11 n_16_3_11 53.91567662370881
R6325 n_16_2_11 n_16_2_12 6.604693059838688
R6326 n_16_2_12 n_17_2_12 1373.315283568401
R6327 n_16_2_12 n_16_3_12 53.91567662370848
R6328 n_16_2_12 n_16_2_13 6.604693059838752
R6329 n_16_2_13 n_17_2_13 1373.3152835683834
R6330 n_16_2_13 n_16_3_13 53.9156766237078
R6331 n_16_2_13 n_16_2_14 33.02346529919384
R6332 n_16_2_14 n_17_2_14 152.59058706315437
R6333 n_16_2_14 n_16_3_14 5.990630735967558
R6334 n_16_2_14 n_16_2_15 1020.4250777450993
R6335 n_16_2_15 n_17_2_15 50469.3366711378
R6336 n_16_2_15 n_16_3_15 1981.4011159212503
R6337 n_16_3_0 n_17_3_0 720.9905238734043
R6338 n_16_3_0 n_16_4_0 827.2137876682009
R6339 n_16_3_0 n_16_3_1 817.3307661550474
R6340 n_16_3_1 n_17_3_1 1009.3867334227659
R6341 n_16_3_1 n_16_4_1 1158.0993027354812
R6342 n_16_3_1 n_16_3_2 3591.3018512873296
R6343 n_16_3_2 n_17_3_2 3604.952619367022
R6344 n_16_3_2 n_16_4_2 4136.0689383410045
R6345 n_16_3_2 n_16_3_3 3472.417376210232
R6346 n_16_3_3 n_17_3_3 25234.668335569128
R6347 n_16_3_3 n_16_4_3 28952.482568387008
R6348 n_16_3_3 n_16_3_4 32.19787866671402
R6349 n_16_3_4 n_17_3_4 1147.0303788895058
R6350 n_16_3_4 n_16_4_4 1316.021934926682
R6351 n_16_3_4 n_16_3_5 28.187886451811906
R6352 n_16_3_5 n_17_3_5 4806.603492489357
R6353 n_16_3_5 n_16_4_5 5514.758584454668
R6354 n_16_3_5 n_16_3_6 6.604693059838772
R6355 n_16_3_6 n_17_3_6 801.1005820815597
R6356 n_16_3_6 n_16_4_6 919.1264307424445
R6357 n_16_3_6 n_16_3_7 8.96351200978118
R6358 n_16_3_7 n_17_3_7 1373.3152835683923
R6359 n_16_3_7 n_16_4_7 1575.6453098441957
R6360 n_16_3_7 n_16_3_8 6.604693059838752
R6361 n_16_3_8 n_17_3_8 1373.3152835683923
R6362 n_16_3_8 n_16_4_8 1575.6453098441957
R6363 n_16_3_8 n_16_3_9 6.604693059838752
R6364 n_16_3_9 n_17_3_9 1373.3152835683923
R6365 n_16_3_9 n_16_4_9 1575.6453098441957
R6366 n_16_3_9 n_16_3_10 6.604693059838752
R6367 n_16_3_10 n_17_3_10 1373.3152835683923
R6368 n_16_3_10 n_16_4_10 1575.6453098441957
R6369 n_16_3_10 n_16_3_11 6.604693059838709
R6370 n_16_3_11 n_17_3_11 1373.3152835684095
R6371 n_16_3_11 n_16_4_11 1575.6453098442155
R6372 n_16_3_11 n_16_3_12 6.604693059838688
R6373 n_16_3_12 n_17_3_12 1373.315283568401
R6374 n_16_3_12 n_16_4_12 1575.6453098442057
R6375 n_16_3_12 n_16_3_13 6.604693059838752
R6376 n_16_3_13 n_17_3_13 1373.3152835683834
R6377 n_16_3_13 n_16_4_13 1575.645309844186
R6378 n_16_3_13 n_16_3_14 33.02346529919384
R6379 n_16_3_14 n_17_3_14 152.59058706315437
R6380 n_16_3_14 n_16_4_14 175.07170109379916
R6381 n_16_3_14 n_16_3_15 1020.4250777450993
R6382 n_16_3_15 n_17_3_15 50469.3366711378
R6383 n_16_3_15 n_16_4_15 57904.9651367735
R6384 n_16_4_0 n_17_4_0 12.550205463809288
R6385 n_16_4_0 n_16_5_0 1626.1218451089549
R6386 n_16_4_0 n_16_4_1 14.227189827725965
R6387 n_16_4_1 n_17_4_1 17.570287649333007
R6388 n_16_4_1 n_16_5_1 2276.5705831525365
R6389 n_16_4_1 n_16_4_2 62.51340984909893
R6390 n_16_4_2 n_17_4_2 62.75102731904645
R6391 n_16_4_2 n_16_5_2 8130.609225544774
R6392 n_16_4_2 n_16_4_3 60.44400041961151
R6393 n_16_4_3 n_17_4_3 439.25719123332476
R6394 n_16_4_3 n_16_5_3 56914.264578813374
R6395 n_16_4_3 n_16_4_4 0.5604650538195082
R6396 n_16_4_4 n_17_4_4 19.966235965151128
R6397 n_16_4_4 n_16_5_4 2587.0120263096983
R6398 n_16_4_4 n_16_4_5 0.49066354528521045
R6399 n_16_4_5 n_17_4_5 83.6680364253952
R6400 n_16_4_5 n_16_5_5 10840.812300726357
R6401 n_16_4_5 n_16_4_6 0.1149671905270786
R6402 n_16_4_6 n_17_4_6 13.944672737565869
R6403 n_16_4_6 n_16_5_6 1806.8020501210592
R6404 n_16_4_6 n_16_4_7 0.15602690142960648
R6405 n_16_4_7 n_17_4_7 23.905153264398706
R6406 n_16_4_7 n_16_5_7 3097.3749430646826
R6407 n_16_4_7 n_16_4_8 0.11496719052707823
R6408 n_16_4_8 n_17_4_8 23.905153264398706
R6409 n_16_4_8 n_16_5_8 3097.3749430646826
R6410 n_16_4_8 n_16_4_9 0.11496719052707823
R6411 n_16_4_9 n_17_4_9 23.905153264398706
R6412 n_16_4_9 n_16_5_9 3097.3749430646826
R6413 n_16_4_9 n_16_4_10 0.11496719052707823
R6414 n_16_4_10 n_17_4_10 23.905153264398706
R6415 n_16_4_10 n_16_5_10 3097.3749430646826
R6416 n_16_4_10 n_16_4_11 0.11496719052707749
R6417 n_16_4_11 n_17_4_11 23.905153264399008
R6418 n_16_4_11 n_16_5_11 3097.3749430647217
R6419 n_16_4_11 n_16_4_12 0.11496719052707713
R6420 n_16_4_12 n_17_4_12 23.905153264398855
R6421 n_16_4_12 n_16_5_12 3097.3749430647026
R6422 n_16_4_12 n_16_4_13 0.11496719052707823
R6423 n_16_4_13 n_17_4_13 23.905153264398557
R6424 n_16_4_13 n_16_5_13 3097.3749430646635
R6425 n_16_4_13 n_16_4_14 0.5748359526353927
R6426 n_16_4_14 n_17_4_14 2.6561281404887396
R6427 n_16_4_14 n_16_5_14 344.15277145163077
R6428 n_16_4_14 n_16_4_15 17.762430936433795
R6429 n_16_4_15 n_17_4_15 878.5143824666418
R6430 n_16_4_15 n_16_5_15 113828.52915762573
R6431 n_16_5_0 n_17_5_0 12.550205463809297
R6432 n_16_5_0 n_16_6_0 827.2138119611456
R6433 n_16_5_0 n_16_5_1 14.227189827725967
R6434 n_16_5_1 n_17_5_1 17.570287649333014
R6435 n_16_5_1 n_16_6_1 1158.0993367456038
R6436 n_16_5_1 n_16_5_2 62.51340984909895
R6437 n_16_5_2 n_17_5_2 62.75102731904647
R6438 n_16_5_2 n_16_6_2 4136.069059805728
R6439 n_16_5_2 n_16_5_3 60.444000419611534
R6440 n_16_5_3 n_17_5_3 439.257191233325
R6441 n_16_5_3 n_16_6_3 28952.483418640073
R6442 n_16_5_3 n_16_5_4 0.5604650538195083
R6443 n_16_5_4 n_17_5_4 19.966235965151135
R6444 n_16_5_4 n_16_6_4 1316.0219735745484
R6445 n_16_5_4 n_16_5_5 0.49066354528521056
R6446 n_16_5_5 n_17_5_5 83.66803642539523
R6447 n_16_5_5 n_16_6_5 5514.758746407632
R6448 n_16_5_5 n_16_5_6 0.11496719052707863
R6449 n_16_5_6 n_17_5_6 13.944672737565874
R6450 n_16_5_6 n_16_6_6 919.1264577346053
R6451 n_16_5_6 n_16_5_7 0.1560269014296065
R6452 n_16_5_7 n_17_5_7 23.905153264398713
R6453 n_16_5_7 n_16_6_7 1575.6453561164712
R6454 n_16_5_7 n_16_5_8 0.11496719052707827
R6455 n_16_5_8 n_17_5_8 23.905153264398713
R6456 n_16_5_8 n_16_6_8 1575.6453561164712
R6457 n_16_5_8 n_16_5_9 0.11496719052707827
R6458 n_16_5_9 n_17_5_9 23.905153264398713
R6459 n_16_5_9 n_16_6_9 1575.6453561164712
R6460 n_16_5_9 n_16_5_10 0.11496719052707827
R6461 n_16_5_10 n_17_5_10 23.905153264398713
R6462 n_16_5_10 n_16_6_10 1575.6453561164712
R6463 n_16_5_10 n_16_5_11 0.11496719052707753
R6464 n_16_5_11 n_17_5_11 23.90515326439902
R6465 n_16_5_11 n_16_6_11 1575.645356116491
R6466 n_16_5_11 n_16_5_12 0.11496719052707716
R6467 n_16_5_12 n_17_5_12 23.905153264398866
R6468 n_16_5_12 n_16_6_12 1575.6453561164815
R6469 n_16_5_12 n_16_5_13 0.11496719052707827
R6470 n_16_5_13 n_17_5_13 23.90515326439856
R6471 n_16_5_13 n_16_6_13 1575.6453561164615
R6472 n_16_5_13 n_16_5_14 0.5748359526353928
R6473 n_16_5_14 n_17_5_14 2.6561281404887405
R6474 n_16_5_14 n_16_6_14 175.07170623516313
R6475 n_16_5_14 n_16_5_15 17.762430936433798
R6476 n_16_5_15 n_17_5_15 878.514382466642
R6477 n_16_5_15 n_16_6_15 57904.96683727963
R6478 n_16_6_0 n_17_6_0 720.9892863181187
R6479 n_16_6_0 n_16_7_0 28.305778813336563
R6480 n_16_6_0 n_16_6_1 817.3293632350699
R6481 n_16_6_1 n_17_6_1 1009.3850008453664
R6482 n_16_6_1 n_16_7_1 39.628090338671186
R6483 n_16_6_1 n_16_6_2 3591.2956869419736
R6484 n_16_6_2 n_17_6_2 3604.9464315905943
R6485 n_16_6_2 n_16_7_2 141.5288940666828
R6486 n_16_6_2 n_16_6_3 3472.4114159259634
R6487 n_16_6_3 n_17_6_3 25234.625021134136
R6488 n_16_6_3 n_16_7_3 990.7022584667787
R6489 n_16_6_3 n_16_6_4 32.197823400169455
R6490 n_16_6_4 n_17_6_4 1147.0284100515519
R6491 n_16_6_4 n_16_7_4 45.03192083939903
R6492 n_16_6_4 n_16_6_5 28.187838068280215
R6493 n_16_6_5 n_17_6_5 4806.595242120788
R6494 n_16_6_5 n_16_7_5 188.70519208891025
R6495 n_16_6_5 n_16_6_6 6.604681723111682
R6496 n_16_6_6 n_17_6_6 801.0992070201314
R6497 n_16_6_6 n_16_7_6 31.450865348151705
R6498 n_16_6_6 n_16_6_7 8.963496624222987
R6499 n_16_6_7 n_17_6_7 1373.3129263202295
R6500 n_16_6_7 n_16_7_7 53.91576916826023
R6501 n_16_6_7 n_16_6_8 6.6046817231116615
R6502 n_16_6_8 n_17_6_8 1373.3129263202295
R6503 n_16_6_8 n_16_7_8 53.91576916826023
R6504 n_16_6_8 n_16_6_9 6.6046817231116615
R6505 n_16_6_9 n_17_6_9 1373.3129263202295
R6506 n_16_6_9 n_16_7_9 53.91576916826023
R6507 n_16_6_9 n_16_6_10 6.6046817231116615
R6508 n_16_6_10 n_17_6_10 1373.3129263202295
R6509 n_16_6_10 n_16_7_10 53.91576916826023
R6510 n_16_6_10 n_16_6_11 6.60468172311162
R6511 n_16_6_11 n_17_6_11 1373.3129263202468
R6512 n_16_6_11 n_16_7_11 53.91576916826091
R6513 n_16_6_11 n_16_6_12 6.604681723111598
R6514 n_16_6_12 n_17_6_12 1373.3129263202381
R6515 n_16_6_12 n_16_7_12 53.91576916826058
R6516 n_16_6_12 n_16_6_13 6.604681723111662
R6517 n_16_6_13 n_17_6_13 1373.3129263202209
R6518 n_16_6_13 n_16_7_13 53.9157691682599
R6519 n_16_6_13 n_16_6_14 33.023408615558395
R6520 n_16_6_14 n_17_6_14 152.59032514669184
R6521 n_16_6_14 n_16_7_14 5.99064101869557
R6522 n_16_6_14 n_16_6_15 1020.4233262207637
R6523 n_16_6_15 n_17_6_15 50469.25004226783
R6524 n_16_6_15 n_16_7_15 1981.40451693354
R6525 n_16_7_0 n_17_7_0 720.9892863181187
R6526 n_16_7_0 n_16_8_0 827.2138119611456
R6527 n_16_7_0 n_16_7_1 817.3293632350699
R6528 n_16_7_1 n_17_7_1 1009.3850008453664
R6529 n_16_7_1 n_16_8_1 1158.0993367456038
R6530 n_16_7_1 n_16_7_2 3591.2956869419736
R6531 n_16_7_2 n_17_7_2 3604.9464315905943
R6532 n_16_7_2 n_16_8_2 4136.069059805728
R6533 n_16_7_2 n_16_7_3 3472.4114159259634
R6534 n_16_7_3 n_17_7_3 25234.625021134136
R6535 n_16_7_3 n_16_8_3 28952.483418640073
R6536 n_16_7_3 n_16_7_4 32.197823400169455
R6537 n_16_7_4 n_17_7_4 1147.0284100515519
R6538 n_16_7_4 n_16_8_4 1316.0219735745484
R6539 n_16_7_4 n_16_7_5 28.187838068280215
R6540 n_16_7_5 n_17_7_5 4806.595242120788
R6541 n_16_7_5 n_16_8_5 5514.758746407632
R6542 n_16_7_5 n_16_7_6 6.604681723111682
R6543 n_16_7_6 n_17_7_6 801.0992070201314
R6544 n_16_7_6 n_16_8_6 919.1264577346053
R6545 n_16_7_6 n_16_7_7 8.963496624222987
R6546 n_16_7_7 n_17_7_7 1373.3129263202295
R6547 n_16_7_7 n_16_8_7 1575.6453561164712
R6548 n_16_7_7 n_16_7_8 6.6046817231116615
R6549 n_16_7_8 n_17_7_8 1373.3129263202295
R6550 n_16_7_8 n_16_8_8 1575.6453561164712
R6551 n_16_7_8 n_16_7_9 6.6046817231116615
R6552 n_16_7_9 n_17_7_9 1373.3129263202295
R6553 n_16_7_9 n_16_8_9 1575.6453561164712
R6554 n_16_7_9 n_16_7_10 6.6046817231116615
R6555 n_16_7_10 n_17_7_10 1373.3129263202295
R6556 n_16_7_10 n_16_8_10 1575.6453561164712
R6557 n_16_7_10 n_16_7_11 6.60468172311162
R6558 n_16_7_11 n_17_7_11 1373.3129263202468
R6559 n_16_7_11 n_16_8_11 1575.645356116491
R6560 n_16_7_11 n_16_7_12 6.604681723111598
R6561 n_16_7_12 n_17_7_12 1373.3129263202381
R6562 n_16_7_12 n_16_8_12 1575.6453561164815
R6563 n_16_7_12 n_16_7_13 6.604681723111662
R6564 n_16_7_13 n_17_7_13 1373.3129263202209
R6565 n_16_7_13 n_16_8_13 1575.6453561164615
R6566 n_16_7_13 n_16_7_14 33.023408615558395
R6567 n_16_7_14 n_17_7_14 152.59032514669184
R6568 n_16_7_14 n_16_8_14 175.07170623516313
R6569 n_16_7_14 n_16_7_15 1020.4233262207637
R6570 n_16_7_15 n_17_7_15 50469.25004226783
R6571 n_16_7_15 n_16_8_15 57904.96683727963
R6572 n_16_8_0 n_17_8_0 12.550205463809297
R6573 n_16_8_0 n_16_9_0 1626.1218451089546
R6574 n_16_8_0 n_16_8_1 14.227189827725967
R6575 n_16_8_1 n_17_8_1 17.570287649333014
R6576 n_16_8_1 n_16_9_1 2276.5705831525365
R6577 n_16_8_1 n_16_8_2 62.51340984909895
R6578 n_16_8_2 n_17_8_2 62.75102731904647
R6579 n_16_8_2 n_16_9_2 8130.609225544773
R6580 n_16_8_2 n_16_8_3 60.444000419611534
R6581 n_16_8_3 n_17_8_3 439.257191233325
R6582 n_16_8_3 n_16_9_3 56914.26457881337
R6583 n_16_8_3 n_16_8_4 0.5604650538195083
R6584 n_16_8_4 n_17_8_4 19.966235965151135
R6585 n_16_8_4 n_16_9_4 2587.012026309698
R6586 n_16_8_4 n_16_8_5 0.49066354528521056
R6587 n_16_8_5 n_17_8_5 83.66803642539523
R6588 n_16_8_5 n_16_9_5 10840.812300726355
R6589 n_16_8_5 n_16_8_6 0.11496719052707863
R6590 n_16_8_6 n_17_8_6 13.944672737565874
R6591 n_16_8_6 n_16_9_6 1806.802050121059
R6592 n_16_8_6 n_16_8_7 0.1560269014296065
R6593 n_16_8_7 n_17_8_7 23.905153264398713
R6594 n_16_8_7 n_16_9_7 3097.374943064682
R6595 n_16_8_7 n_16_8_8 0.11496719052707827
R6596 n_16_8_8 n_17_8_8 23.905153264398713
R6597 n_16_8_8 n_16_9_8 3097.374943064682
R6598 n_16_8_8 n_16_8_9 0.11496719052707827
R6599 n_16_8_9 n_17_8_9 23.905153264398713
R6600 n_16_8_9 n_16_9_9 3097.374943064682
R6601 n_16_8_9 n_16_8_10 0.11496719052707827
R6602 n_16_8_10 n_17_8_10 23.905153264398713
R6603 n_16_8_10 n_16_9_10 3097.374943064682
R6604 n_16_8_10 n_16_8_11 0.11496719052707753
R6605 n_16_8_11 n_17_8_11 23.90515326439902
R6606 n_16_8_11 n_16_9_11 3097.3749430647213
R6607 n_16_8_11 n_16_8_12 0.11496719052707716
R6608 n_16_8_12 n_17_8_12 23.905153264398866
R6609 n_16_8_12 n_16_9_12 3097.374943064702
R6610 n_16_8_12 n_16_8_13 0.11496719052707827
R6611 n_16_8_13 n_17_8_13 23.90515326439856
R6612 n_16_8_13 n_16_9_13 3097.374943064663
R6613 n_16_8_13 n_16_8_14 0.5748359526353928
R6614 n_16_8_14 n_17_8_14 2.6561281404887405
R6615 n_16_8_14 n_16_9_14 344.1527714516307
R6616 n_16_8_14 n_16_8_15 17.762430936433798
R6617 n_16_8_15 n_17_8_15 878.514382466642
R6618 n_16_8_15 n_16_9_15 113828.52915762572
R6619 n_16_9_0 n_17_9_0 12.550205463809297
R6620 n_16_9_0 n_16_10_0 827.2138145479918
R6621 n_16_9_0 n_16_9_1 14.227189827725967
R6622 n_16_9_1 n_17_9_1 17.570287649333014
R6623 n_16_9_1 n_16_10_1 1158.0993403671885
R6624 n_16_9_1 n_16_9_2 62.51340984909895
R6625 n_16_9_2 n_17_9_2 62.75102731904647
R6626 n_16_9_2 n_16_10_2 4136.069072739959
R6627 n_16_9_2 n_16_9_3 60.444000419611534
R6628 n_16_9_3 n_17_9_3 439.257191233325
R6629 n_16_9_3 n_16_10_3 28952.48350917969
R6630 n_16_9_3 n_16_9_4 0.5604650538195083
R6631 n_16_9_4 n_17_9_4 19.966235965151135
R6632 n_16_9_4 n_16_10_4 1316.0219776899855
R6633 n_16_9_4 n_16_9_5 0.49066354528521056
R6634 n_16_9_5 n_17_9_5 83.66803642539523
R6635 n_16_9_5 n_16_10_5 5514.7587636532735
R6636 n_16_9_5 n_16_9_6 0.11496719052707863
R6637 n_16_9_6 n_17_9_6 13.944672737565874
R6638 n_16_9_6 n_16_10_6 919.1264606088789
R6639 n_16_9_6 n_16_9_7 0.1560269014296065
R6640 n_16_9_7 n_17_9_7 23.905153264398713
R6641 n_16_9_7 n_16_10_7 1575.6453610437973
R6642 n_16_9_7 n_16_9_8 0.11496719052707827
R6643 n_16_9_8 n_17_9_8 23.905153264398713
R6644 n_16_9_8 n_16_10_8 1575.6453610437973
R6645 n_16_9_8 n_16_9_9 0.11496719052707827
R6646 n_16_9_9 n_17_9_9 23.905153264398713
R6647 n_16_9_9 n_16_10_9 1575.6453610437973
R6648 n_16_9_9 n_16_9_10 0.11496719052707827
R6649 n_16_9_10 n_17_9_10 23.905153264398713
R6650 n_16_9_10 n_16_10_10 1575.6453610437973
R6651 n_16_9_10 n_16_9_11 0.11496719052707753
R6652 n_16_9_11 n_17_9_11 23.90515326439902
R6653 n_16_9_11 n_16_10_11 1575.6453610438173
R6654 n_16_9_11 n_16_9_12 0.11496719052707716
R6655 n_16_9_12 n_17_9_12 23.905153264398866
R6656 n_16_9_12 n_16_10_12 1575.6453610438075
R6657 n_16_9_12 n_16_9_13 0.11496719052707827
R6658 n_16_9_13 n_17_9_13 23.90515326439856
R6659 n_16_9_13 n_16_10_13 1575.6453610437875
R6660 n_16_9_13 n_16_9_14 0.5748359526353928
R6661 n_16_9_14 n_17_9_14 2.6561281404887405
R6662 n_16_9_14 n_16_10_14 175.07170678264382
R6663 n_16_9_14 n_16_9_15 17.762430936433798
R6664 n_16_9_15 n_17_9_15 878.514382466642
R6665 n_16_9_15 n_16_10_15 57904.96701835886
R6666 n_16_10_0 n_17_10_0 720.989154536685
R6667 n_16_10_0 n_16_11_0 28.30578398702847
R6668 n_16_10_0 n_16_10_1 817.3292138447287
R6669 n_16_10_1 n_17_10_1 1009.3848163513587
R6670 n_16_10_1 n_16_11_1 39.62809758183986
R6671 n_16_10_1 n_16_10_2 3591.295030529868
R6672 n_16_10_2 n_17_10_2 3604.9457726834253
R6673 n_16_10_2 n_16_11_2 141.52891993514237
R6674 n_16_10_2 n_16_10_3 3472.4107812433626
R6675 n_16_10_3 n_17_10_3 25234.620408783947
R6676 n_16_10_3 n_16_11_3 990.7024395459957
R6677 n_16_10_3 n_16_10_4 32.1978175150954
R6678 n_16_10_4 n_17_10_4 1147.0282003992706
R6679 n_16_10_4 n_16_11_4 45.031929070272525
R6680 n_16_10_4 n_16_10_5 28.18783291614579
R6681 n_16_10_5 n_17_10_5 4806.594363577895
R6682 n_16_10_5 n_16_11_5 188.70522658018965
R6683 n_16_10_5 n_16_10_6 6.604680515917005
R6684 n_16_10_6 n_17_10_6 801.0990605963159
R6685 n_16_10_6 n_16_11_6 31.450871096698272
R6686 n_16_10_6 n_16_10_7 8.963494985887355
R6687 n_16_10_7 n_17_10_7 1373.3126753079741
R6688 n_16_10_7 n_16_11_7 53.915779022911494
R6689 n_16_10_7 n_16_10_8 6.604680515916985
R6690 n_16_10_8 n_17_10_8 1373.3126753079741
R6691 n_16_10_8 n_16_11_8 53.915779022911494
R6692 n_16_10_8 n_16_10_9 6.604680515916985
R6693 n_16_10_9 n_17_10_9 1373.3126753079741
R6694 n_16_10_9 n_16_11_9 53.915779022911494
R6695 n_16_10_9 n_16_10_10 6.604680515916985
R6696 n_16_10_10 n_17_10_10 1373.3126753079741
R6697 n_16_10_10 n_16_11_10 53.915779022911494
R6698 n_16_10_10 n_16_10_11 6.604680515916943
R6699 n_16_10_11 n_17_10_11 1373.3126753079919
R6700 n_16_10_11 n_16_11_11 53.91577902291217
R6701 n_16_10_11 n_16_10_12 6.604680515916922
R6702 n_16_10_12 n_17_10_12 1373.3126753079828
R6703 n_16_10_12 n_16_11_12 53.915779022911835
R6704 n_16_10_12 n_16_10_13 6.604680515916984
R6705 n_16_10_13 n_17_10_13 1373.3126753079655
R6706 n_16_10_13 n_16_11_13 53.91577902291116
R6707 n_16_10_13 n_16_10_14 33.02340257958501
R6708 n_16_10_14 n_17_10_14 152.59029725644126
R6709 n_16_10_14 n_16_11_14 5.99064211365682
R6710 n_16_10_14 n_16_10_15 1020.4231397091861
R6711 n_16_10_15 n_17_10_15 50469.24081756744
R6712 n_16_10_15 n_16_11_15 1981.4048790919737
R6713 n_16_11_0 n_17_11_0 720.9891545367104
R6714 n_16_11_0 n_16_12_0 326.27363593662216
R6715 n_16_11_0 n_16_11_1 817.3292138447578
R6716 n_16_11_1 n_17_11_1 1009.3848163513946
R6717 n_16_11_1 n_16_12_1 456.783090311271
R6718 n_16_11_1 n_16_11_2 3591.2950305299964
R6719 n_16_11_2 n_17_11_2 3604.9457726835526
R6720 n_16_11_2 n_16_12_2 1631.3681796831106
R6721 n_16_11_2 n_16_11_3 3472.4107812434863
R6722 n_16_11_3 n_17_11_3 25234.620408784845
R6723 n_16_11_3 n_16_12_3 11419.577257781764
R6724 n_16_11_3 n_16_11_4 32.197817515096546
R6725 n_16_11_4 n_17_11_4 1147.0282003993111
R6726 n_16_11_4 n_16_12_4 519.0716935355347
R6727 n_16_11_4 n_16_11_5 28.187832916146796
R6728 n_16_11_5 n_17_11_5 4806.594363578066
R6729 n_16_11_5 n_16_12_5 2175.1575729108126
R6730 n_16_11_5 n_16_11_6 6.60468051591724
R6731 n_16_11_6 n_17_11_6 801.0990605963442
R6732 n_16_11_6 n_16_12_6 362.52626215180203
R6733 n_16_11_6 n_16_11_7 8.963494985887673
R6734 n_16_11_7 n_17_11_7 1373.3126753080232
R6735 n_16_11_7 n_16_12_7 621.473592260234
R6736 n_16_11_7 n_16_11_8 6.604680515917219
R6737 n_16_11_8 n_17_11_8 1373.3126753080232
R6738 n_16_11_8 n_16_12_8 621.473592260234
R6739 n_16_11_8 n_16_11_9 6.604680515917219
R6740 n_16_11_9 n_17_11_9 1373.3126753080232
R6741 n_16_11_9 n_16_12_9 621.473592260234
R6742 n_16_11_9 n_16_11_10 6.604680515917219
R6743 n_16_11_10 n_17_11_10 1373.3126753080232
R6744 n_16_11_10 n_16_12_10 621.473592260234
R6745 n_16_11_10 n_16_11_11 6.6046805159171775
R6746 n_16_11_11 n_17_11_11 1373.3126753080405
R6747 n_16_11_11 n_16_12_11 621.4735922602418
R6748 n_16_11_11 n_16_11_12 6.604680515917156
R6749 n_16_11_12 n_17_11_12 1373.3126753080319
R6750 n_16_11_12 n_16_12_12 621.473592260238
R6751 n_16_11_12 n_16_11_13 6.604680515917218
R6752 n_16_11_13 n_17_11_13 1373.3126753080146
R6753 n_16_11_13 n_16_12_13 621.4735922602301
R6754 n_16_11_13 n_16_11_14 33.02340257958618
R6755 n_16_11_14 n_17_11_14 152.59029725644672
R6756 n_16_11_14 n_16_12_14 69.05262136224809
R6757 n_16_11_14 n_16_11_15 1020.4231397092225
R6758 n_16_11_15 n_17_11_15 50469.24081756924
R6759 n_16_11_15 n_16_12_15 22839.15451556333
R6760 n_16_12_0 n_17_12_0 32.692737764693334
R6761 n_16_12_0 n_16_13_0 624.2414878862169
R6762 n_16_12_0 n_16_12_1 37.06120887882105
R6763 n_16_12_1 n_17_12_1 45.76983287057065
R6764 n_16_12_1 n_16_13_1 873.9380830407035
R6765 n_16_12_1 n_16_12_2 162.84470567966824
R6766 n_16_12_2 n_17_12_2 163.4636888234666
R6767 n_16_12_2 n_16_13_2 3121.207439431084
R6768 n_16_12_2 n_16_12_3 157.45398438820334
R6769 n_16_12_3 n_17_12_3 1144.2458217642652
R6770 n_16_12_3 n_16_13_3 21848.45207601757
R6771 n_16_12_3 n_16_12_4 1.4599870164384063
R6772 n_16_12_4 n_17_12_4 52.01117371655752
R6773 n_16_12_4 n_16_13_4 993.1114580007984
R6774 n_16_12_4 n_16_12_5 1.2781571316072493
R6775 n_16_12_5 n_17_12_5 217.95158509795527
R6776 n_16_12_5 n_16_13_5 4161.609919241442
R6777 n_16_12_5 n_16_12_6 0.2994845161924936
R6778 n_16_12_6 n_17_12_6 36.32526418299255
R6779 n_16_12_6 n_16_13_6 693.6016532069069
R6780 n_16_12_6 n_16_12_7 0.40644327197552654
R6781 n_16_12_7 n_17_12_7 62.27188145655885
R6782 n_16_12_7 n_16_13_7 1189.0314054975584
R6783 n_16_12_7 n_16_12_8 0.29948451619249267
R6784 n_16_12_8 n_17_12_8 62.27188145655885
R6785 n_16_12_8 n_16_13_8 1189.0314054975584
R6786 n_16_12_8 n_16_12_9 0.29948451619249267
R6787 n_16_12_9 n_17_12_9 62.27188145655885
R6788 n_16_12_9 n_16_13_9 1189.0314054975584
R6789 n_16_12_9 n_16_12_10 0.29948451619249267
R6790 n_16_12_10 n_17_12_10 62.27188145655885
R6791 n_16_12_10 n_16_13_10 1189.0314054975584
R6792 n_16_12_10 n_16_12_11 0.2994845161924907
R6793 n_16_12_11 n_17_12_11 62.27188145655966
R6794 n_16_12_11 n_16_13_11 1189.0314054975734
R6795 n_16_12_11 n_16_12_12 0.2994845161924898
R6796 n_16_12_12 n_17_12_12 62.27188145655924
R6797 n_16_12_12 n_16_13_12 1189.031405497566
R6798 n_16_12_12 n_16_12_13 0.2994845161924926
R6799 n_16_12_13 n_17_12_13 62.27188145655846
R6800 n_16_12_13 n_16_13_13 1189.031405497551
R6801 n_16_12_13 n_16_12_14 1.497422580962467
R6802 n_16_12_14 n_17_12_14 6.919097939617636
R6803 n_16_12_14 n_16_13_14 132.11460061083955
R6804 n_16_12_14 n_16_12_15 46.270357751740654
R6805 n_16_12_15 n_17_12_15 2288.4916435285104
R6806 n_16_12_15 n_16_13_15 43696.90415203475
R6807 n_16_13_0 n_17_13_0 32.69273776469328
R6808 n_16_13_0 n_16_13_1 37.06120887882099
R6809 n_16_13_1 n_17_13_1 45.76983287057058
R6810 n_16_13_1 n_16_13_2 162.84470567966798
R6811 n_16_13_2 n_17_13_2 163.46368882346638
R6812 n_16_13_2 n_16_13_3 157.4539843882031
R6813 n_16_13_3 n_17_13_3 1144.2458217642634
R6814 n_16_13_3 n_16_13_4 1.4599870164384041
R6815 n_16_13_4 n_17_13_4 52.01117371655743
R6816 n_16_13_4 n_16_13_5 1.2781571316072475
R6817 n_16_13_5 n_17_13_5 217.951585097955
R6818 n_16_13_5 n_16_13_6 0.2994845161924931
R6819 n_16_13_6 n_17_13_6 36.32526418299249
R6820 n_16_13_6 n_16_13_7 0.4064432719755259
R6821 n_16_13_7 n_17_13_7 62.271881456558745
R6822 n_16_13_7 n_16_13_8 0.29948451619249217
R6823 n_16_13_8 n_17_13_8 62.271881456558745
R6824 n_16_13_8 n_16_13_9 0.29948451619249217
R6825 n_16_13_9 n_17_13_9 62.271881456558745
R6826 n_16_13_9 n_16_13_10 0.29948451619249217
R6827 n_16_13_10 n_17_13_10 62.271881456558745
R6828 n_16_13_10 n_16_13_11 0.2994845161924903
R6829 n_16_13_11 n_17_13_11 62.27188145655954
R6830 n_16_13_11 n_16_13_12 0.2994845161924893
R6831 n_16_13_12 n_17_13_12 62.27188145655915
R6832 n_16_13_12 n_16_13_13 0.29948451619249217
R6833 n_16_13_13 n_17_13_13 62.27188145655836
R6834 n_16_13_13 n_16_13_14 1.4974225809624646
R6835 n_16_13_14 n_17_13_14 6.9190979396176235
R6836 n_16_13_14 n_16_13_15 46.27035775174059
R6837 n_16_13_15 n_17_13_15 2288.4916435285068
R6838 n_17_0_0 n_17_1_0 624.2415416458027
R6839 n_17_0_0 n_17_0_1 37.06120568711591
R6840 n_17_0_1 n_17_1_1 873.9381583041238
R6841 n_17_0_1 n_17_0_2 162.8446916555093
R6842 n_17_0_2 n_17_1_2 3121.2077082290134
R6843 n_17_0_2 n_17_0_3 157.45397082829246
R6844 n_17_0_3 n_17_1_3 21848.453957603077
R6845 n_17_0_3 n_17_0_4 1.4599868907045674
R6846 n_17_0_4 n_17_1_4 993.1115435274126
R6847 n_17_0_4 n_17_0_5 1.27815702153257
R6848 n_17_0_5 n_17_1_5 4161.6102776386815
R6849 n_17_0_5 n_17_0_6 0.29948449040093694
R6850 n_17_0_6 n_17_1_6 693.6017129397802
R6851 n_17_0_6 n_17_0_7 0.4064432369726997
R6852 n_17_0_7 n_17_1_7 1189.0315078967699
R6853 n_17_0_7 n_17_0_8 0.299484490400936
R6854 n_17_0_8 n_17_1_8 1189.0315078967699
R6855 n_17_0_8 n_17_0_9 0.299484490400936
R6856 n_17_0_9 n_17_1_9 1189.0315078967699
R6857 n_17_0_9 n_17_0_10 0.299484490400936
R6858 n_17_0_10 n_17_1_10 1189.0315078967699
R6859 n_17_0_10 n_17_0_11 0.29948449040093406
R6860 n_17_0_11 n_17_1_11 1189.0315078967847
R6861 n_17_0_11 n_17_0_12 0.2994844904009331
R6862 n_17_0_12 n_17_1_12 1189.0315078967774
R6863 n_17_0_12 n_17_0_13 0.29948449040093594
R6864 n_17_0_13 n_17_1_13 1189.0315078967622
R6865 n_17_0_13 n_17_0_14 1.4974224520046837
R6866 n_17_0_14 n_17_1_14 132.1146119885297
R6867 n_17_0_14 n_17_0_15 46.27035376694515
R6868 n_17_0_15 n_17_1_15 43696.90791520576
R6869 n_17_1_0 n_17_2_0 326.2736359366248
R6870 n_17_1_0 n_17_1_1 37.06120568711591
R6871 n_17_1_1 n_17_2_1 456.78309031127475
R6872 n_17_1_1 n_17_1_2 162.8446916555093
R6873 n_17_1_2 n_17_2_2 1631.368179683124
R6874 n_17_1_2 n_17_1_3 157.45397082829246
R6875 n_17_1_3 n_17_2_3 11419.577257781859
R6876 n_17_1_3 n_17_1_4 1.4599868907045674
R6877 n_17_1_4 n_17_2_4 519.071693535539
R6878 n_17_1_4 n_17_1_5 1.27815702153257
R6879 n_17_1_5 n_17_2_5 2175.1575729108304
R6880 n_17_1_5 n_17_1_6 0.29948449040093694
R6881 n_17_1_6 n_17_2_6 362.52626215180504
R6882 n_17_1_6 n_17_1_7 0.4064432369726997
R6883 n_17_1_7 n_17_2_7 621.4735922602392
R6884 n_17_1_7 n_17_1_8 0.299484490400936
R6885 n_17_1_8 n_17_2_8 621.4735922602392
R6886 n_17_1_8 n_17_1_9 0.299484490400936
R6887 n_17_1_9 n_17_2_9 621.4735922602392
R6888 n_17_1_9 n_17_1_10 0.299484490400936
R6889 n_17_1_10 n_17_2_10 621.4735922602392
R6890 n_17_1_10 n_17_1_11 0.29948449040093406
R6891 n_17_1_11 n_17_2_11 621.473592260247
R6892 n_17_1_11 n_17_1_12 0.2994844904009331
R6893 n_17_1_12 n_17_2_12 621.4735922602431
R6894 n_17_1_12 n_17_1_13 0.29948449040093594
R6895 n_17_1_13 n_17_2_13 621.4735922602351
R6896 n_17_1_13 n_17_1_14 1.4974224520046837
R6897 n_17_1_14 n_17_2_14 69.05262136224866
R6898 n_17_1_14 n_17_1_15 46.27035376694515
R6899 n_17_1_15 n_17_2_15 22839.15451556351
R6900 n_17_2_0 n_17_3_0 28.305730227446904
R6901 n_17_2_0 n_17_2_1 817.3307661550532
R6902 n_17_2_1 n_17_3_1 39.62802231842567
R6903 n_17_2_1 n_17_2_2 3591.3018512873546
R6904 n_17_2_2 n_17_3_2 141.52865113723453
R6905 n_17_2_2 n_17_2_3 3472.417376210256
R6906 n_17_2_3 n_17_3_3 990.7005579606408
R6907 n_17_2_3 n_17_2_4 32.197878666714246
R6908 n_17_2_4 n_17_3_4 45.031843543665495
R6909 n_17_2_4 n_17_2_5 28.1878864518121
R6910 n_17_2_5 n_17_3_5 188.70486818297923
R6911 n_17_2_5 n_17_2_6 6.604693059838819
R6912 n_17_2_6 n_17_3_6 31.450811363829867
R6913 n_17_2_6 n_17_2_7 8.963512009781244
R6914 n_17_2_7 n_17_3_7 53.915676623708514
R6915 n_17_2_7 n_17_2_8 6.604693059838798
R6916 n_17_2_8 n_17_3_8 53.915676623708514
R6917 n_17_2_8 n_17_2_9 6.604693059838798
R6918 n_17_2_9 n_17_3_9 53.915676623708514
R6919 n_17_2_9 n_17_2_10 6.604693059838798
R6920 n_17_2_10 n_17_3_10 53.915676623708514
R6921 n_17_2_10 n_17_2_11 6.604693059838755
R6922 n_17_2_11 n_17_3_11 53.91567662370919
R6923 n_17_2_11 n_17_2_12 6.604693059838735
R6924 n_17_2_12 n_17_3_12 53.91567662370886
R6925 n_17_2_12 n_17_2_13 6.604693059838798
R6926 n_17_2_13 n_17_3_13 53.91567662370817
R6927 n_17_2_13 n_17_2_14 33.02346529919407
R6928 n_17_2_14 n_17_3_14 5.9906307359676
R6929 n_17_2_14 n_17_2_15 1020.4250777451064
R6930 n_17_2_15 n_17_3_15 1981.401115921264
R6931 n_17_3_0 n_17_4_0 827.2137876682067
R6932 n_17_3_0 n_17_3_1 817.3307661550532
R6933 n_17_3_1 n_17_4_1 1158.0993027354896
R6934 n_17_3_1 n_17_3_2 3591.3018512873546
R6935 n_17_3_2 n_17_4_2 4136.068938341034
R6936 n_17_3_2 n_17_3_3 3472.417376210256
R6937 n_17_3_3 n_17_4_3 28952.482568387208
R6938 n_17_3_3 n_17_3_4 32.197878666714246
R6939 n_17_3_4 n_17_4_4 1316.0219349266915
R6940 n_17_3_4 n_17_3_5 28.1878864518121
R6941 n_17_3_5 n_17_4_5 5514.758584454707
R6942 n_17_3_5 n_17_3_6 6.604693059838819
R6943 n_17_3_6 n_17_4_6 919.1264307424511
R6944 n_17_3_6 n_17_3_7 8.963512009781244
R6945 n_17_3_7 n_17_4_7 1575.6453098442068
R6946 n_17_3_7 n_17_3_8 6.604693059838798
R6947 n_17_3_8 n_17_4_8 1575.6453098442068
R6948 n_17_3_8 n_17_3_9 6.604693059838798
R6949 n_17_3_9 n_17_4_9 1575.6453098442068
R6950 n_17_3_9 n_17_3_10 6.604693059838798
R6951 n_17_3_10 n_17_4_10 1575.6453098442068
R6952 n_17_3_10 n_17_3_11 6.604693059838755
R6953 n_17_3_11 n_17_4_11 1575.6453098442266
R6954 n_17_3_11 n_17_3_12 6.604693059838735
R6955 n_17_3_12 n_17_4_12 1575.6453098442169
R6956 n_17_3_12 n_17_3_13 6.604693059838798
R6957 n_17_3_13 n_17_4_13 1575.6453098441968
R6958 n_17_3_13 n_17_3_14 33.02346529919407
R6959 n_17_3_14 n_17_4_14 175.07170109380039
R6960 n_17_3_14 n_17_3_15 1020.4250777451064
R6961 n_17_3_15 n_17_4_15 57904.965136773906
R6962 n_17_4_0 n_17_5_0 1626.1218451089662
R6963 n_17_4_0 n_17_4_1 14.227189827726065
R6964 n_17_4_1 n_17_5_1 2276.570583152553
R6965 n_17_4_1 n_17_4_2 62.513409849099375
R6966 n_17_4_2 n_17_5_2 8130.609225544831
R6967 n_17_4_2 n_17_4_3 60.444000419611946
R6968 n_17_4_3 n_17_5_3 56914.26457881377
R6969 n_17_4_3 n_17_4_4 0.5604650538195122
R6970 n_17_4_4 n_17_5_4 2587.012026309717
R6971 n_17_4_4 n_17_4_5 0.49066354528521394
R6972 n_17_4_5 n_17_5_5 10840.812300726433
R6973 n_17_4_5 n_17_4_6 0.1149671905270794
R6974 n_17_4_6 n_17_5_6 1806.8020501210722
R6975 n_17_4_6 n_17_4_7 0.15602690142960757
R6976 n_17_4_7 n_17_5_7 3097.374943064705
R6977 n_17_4_7 n_17_4_8 0.11496719052707904
R6978 n_17_4_8 n_17_5_8 3097.374943064705
R6979 n_17_4_8 n_17_4_9 0.11496719052707904
R6980 n_17_4_9 n_17_5_9 3097.374943064705
R6981 n_17_4_9 n_17_4_10 0.11496719052707904
R6982 n_17_4_10 n_17_5_10 3097.374943064705
R6983 n_17_4_10 n_17_4_11 0.11496719052707831
R6984 n_17_4_11 n_17_5_11 3097.3749430647435
R6985 n_17_4_11 n_17_4_12 0.11496719052707793
R6986 n_17_4_12 n_17_5_12 3097.3749430647244
R6987 n_17_4_12 n_17_4_13 0.11496719052707904
R6988 n_17_4_13 n_17_5_13 3097.374943064685
R6989 n_17_4_13 n_17_4_14 0.5748359526353967
R6990 n_17_4_14 n_17_5_14 344.1527714516331
R6991 n_17_4_14 n_17_4_15 17.762430936433923
R6992 n_17_4_15 n_17_5_15 113828.52915762653
R6993 n_17_5_0 n_17_6_0 827.2138119611514
R6994 n_17_5_0 n_17_5_1 14.227189827726068
R6995 n_17_5_1 n_17_6_1 1158.099336745612
R6996 n_17_5_1 n_17_5_2 62.51340984909939
R6997 n_17_5_2 n_17_6_2 4136.069059805757
R6998 n_17_5_2 n_17_5_3 60.44400041961196
R6999 n_17_5_3 n_17_6_3 28952.483418640273
R7000 n_17_5_3 n_17_5_4 0.5604650538195123
R7001 n_17_5_4 n_17_6_4 1316.021973574558
R7002 n_17_5_4 n_17_5_5 0.49066354528521405
R7003 n_17_5_5 n_17_6_5 5514.758746407671
R7004 n_17_5_5 n_17_5_6 0.11496719052707945
R7005 n_17_5_6 n_17_6_6 919.1264577346118
R7006 n_17_5_6 n_17_5_7 0.15602690142960765
R7007 n_17_5_7 n_17_6_7 1575.6453561164826
R7008 n_17_5_7 n_17_5_8 0.11496719052707909
R7009 n_17_5_8 n_17_6_8 1575.6453561164826
R7010 n_17_5_8 n_17_5_9 0.11496719052707909
R7011 n_17_5_9 n_17_6_9 1575.6453561164826
R7012 n_17_5_9 n_17_5_10 0.11496719052707909
R7013 n_17_5_10 n_17_6_10 1575.6453561164826
R7014 n_17_5_10 n_17_5_11 0.11496719052707835
R7015 n_17_5_11 n_17_6_11 1575.6453561165022
R7016 n_17_5_11 n_17_5_12 0.11496719052707799
R7017 n_17_5_12 n_17_6_12 1575.6453561164924
R7018 n_17_5_12 n_17_5_13 0.11496719052707909
R7019 n_17_5_13 n_17_6_13 1575.6453561164724
R7020 n_17_5_13 n_17_5_14 0.5748359526353968
R7021 n_17_5_14 n_17_6_14 175.07170623516433
R7022 n_17_5_14 n_17_5_15 17.762430936433926
R7023 n_17_5_15 n_17_6_15 57904.96683728003
R7024 n_17_6_0 n_17_7_0 28.305778813336758
R7025 n_17_6_0 n_17_6_1 817.3293632350757
R7026 n_17_6_1 n_17_7_1 39.62809033867146
R7027 n_17_6_1 n_17_6_2 3591.295686941999
R7028 n_17_6_2 n_17_7_2 141.5288940666838
R7029 n_17_6_2 n_17_6_3 3472.411415925988
R7030 n_17_6_3 n_17_7_3 990.7022584667857
R7031 n_17_6_3 n_17_6_4 32.19782340016968
R7032 n_17_6_4 n_17_7_4 45.031920839399355
R7033 n_17_6_4 n_17_6_5 28.187838068280413
R7034 n_17_6_5 n_17_7_5 188.70519208891156
R7035 n_17_6_5 n_17_6_6 6.604681723111728
R7036 n_17_6_6 n_17_7_6 31.450865348151925
R7037 n_17_6_6 n_17_6_7 8.963496624223048
R7038 n_17_6_7 n_17_7_7 53.91576916826062
R7039 n_17_6_7 n_17_6_8 6.604681723111707
R7040 n_17_6_8 n_17_7_8 53.91576916826062
R7041 n_17_6_8 n_17_6_9 6.604681723111707
R7042 n_17_6_9 n_17_7_9 53.91576916826062
R7043 n_17_6_9 n_17_6_10 6.604681723111707
R7044 n_17_6_10 n_17_7_10 53.91576916826062
R7045 n_17_6_10 n_17_6_11 6.604681723111664
R7046 n_17_6_11 n_17_7_11 53.91576916826129
R7047 n_17_6_11 n_17_6_12 6.604681723111644
R7048 n_17_6_12 n_17_7_12 53.91576916826096
R7049 n_17_6_12 n_17_6_13 6.604681723111707
R7050 n_17_6_13 n_17_7_13 53.91576916826027
R7051 n_17_6_13 n_17_6_14 33.023408615558616
R7052 n_17_6_14 n_17_7_14 5.990641018695611
R7053 n_17_6_14 n_17_6_15 1020.423326220771
R7054 n_17_6_15 n_17_7_15 1981.4045169335536
R7055 n_17_7_0 n_17_8_0 827.2138119611514
R7056 n_17_7_0 n_17_7_1 817.3293632350757
R7057 n_17_7_1 n_17_8_1 1158.099336745612
R7058 n_17_7_1 n_17_7_2 3591.295686941999
R7059 n_17_7_2 n_17_8_2 4136.069059805757
R7060 n_17_7_2 n_17_7_3 3472.411415925988
R7061 n_17_7_3 n_17_8_3 28952.483418640273
R7062 n_17_7_3 n_17_7_4 32.19782340016968
R7063 n_17_7_4 n_17_8_4 1316.021973574558
R7064 n_17_7_4 n_17_7_5 28.187838068280413
R7065 n_17_7_5 n_17_8_5 5514.758746407671
R7066 n_17_7_5 n_17_7_6 6.604681723111728
R7067 n_17_7_6 n_17_8_6 919.1264577346118
R7068 n_17_7_6 n_17_7_7 8.963496624223048
R7069 n_17_7_7 n_17_8_7 1575.6453561164826
R7070 n_17_7_7 n_17_7_8 6.604681723111707
R7071 n_17_7_8 n_17_8_8 1575.6453561164826
R7072 n_17_7_8 n_17_7_9 6.604681723111707
R7073 n_17_7_9 n_17_8_9 1575.6453561164826
R7074 n_17_7_9 n_17_7_10 6.604681723111707
R7075 n_17_7_10 n_17_8_10 1575.6453561164826
R7076 n_17_7_10 n_17_7_11 6.604681723111664
R7077 n_17_7_11 n_17_8_11 1575.6453561165022
R7078 n_17_7_11 n_17_7_12 6.604681723111644
R7079 n_17_7_12 n_17_8_12 1575.6453561164924
R7080 n_17_7_12 n_17_7_13 6.604681723111707
R7081 n_17_7_13 n_17_8_13 1575.6453561164724
R7082 n_17_7_13 n_17_7_14 33.023408615558616
R7083 n_17_7_14 n_17_8_14 175.07170623516433
R7084 n_17_7_14 n_17_7_15 1020.423326220771
R7085 n_17_7_15 n_17_8_15 57904.96683728003
R7086 n_17_8_0 n_17_9_0 1626.121845108966
R7087 n_17_8_0 n_17_8_1 14.227189827726068
R7088 n_17_8_1 n_17_9_1 2276.5705831525524
R7089 n_17_8_1 n_17_8_2 62.51340984909939
R7090 n_17_8_2 n_17_9_2 8130.60922554483
R7091 n_17_8_2 n_17_8_3 60.44400041961196
R7092 n_17_8_3 n_17_9_3 56914.26457881376
R7093 n_17_8_3 n_17_8_4 0.5604650538195123
R7094 n_17_8_4 n_17_9_4 2587.0120263097165
R7095 n_17_8_4 n_17_8_5 0.49066354528521405
R7096 n_17_8_5 n_17_9_5 10840.812300726431
R7097 n_17_8_5 n_17_8_6 0.11496719052707945
R7098 n_17_8_6 n_17_9_6 1806.8020501210717
R7099 n_17_8_6 n_17_8_7 0.15602690142960765
R7100 n_17_8_7 n_17_9_7 3097.3749430647044
R7101 n_17_8_7 n_17_8_8 0.11496719052707909
R7102 n_17_8_8 n_17_9_8 3097.3749430647044
R7103 n_17_8_8 n_17_8_9 0.11496719052707909
R7104 n_17_8_9 n_17_9_9 3097.3749430647044
R7105 n_17_8_9 n_17_8_10 0.11496719052707909
R7106 n_17_8_10 n_17_9_10 3097.3749430647044
R7107 n_17_8_10 n_17_8_11 0.11496719052707835
R7108 n_17_8_11 n_17_9_11 3097.374943064743
R7109 n_17_8_11 n_17_8_12 0.11496719052707799
R7110 n_17_8_12 n_17_9_12 3097.374943064724
R7111 n_17_8_12 n_17_8_13 0.11496719052707909
R7112 n_17_8_13 n_17_9_13 3097.3749430646844
R7113 n_17_8_13 n_17_8_14 0.5748359526353968
R7114 n_17_8_14 n_17_9_14 344.15277145163304
R7115 n_17_8_14 n_17_8_15 17.762430936433926
R7116 n_17_8_15 n_17_9_15 113828.5291576265
R7117 n_17_9_0 n_17_10_0 827.2138145479976
R7118 n_17_9_0 n_17_9_1 14.227189827726068
R7119 n_17_9_1 n_17_10_1 1158.0993403671966
R7120 n_17_9_1 n_17_9_2 62.51340984909939
R7121 n_17_9_2 n_17_10_2 4136.069072739988
R7122 n_17_9_2 n_17_9_3 60.44400041961196
R7123 n_17_9_3 n_17_10_3 28952.48350917989
R7124 n_17_9_3 n_17_9_4 0.5604650538195123
R7125 n_17_9_4 n_17_10_4 1316.021977689995
R7126 n_17_9_4 n_17_9_5 0.49066354528521405
R7127 n_17_9_5 n_17_10_5 5514.758763653313
R7128 n_17_9_5 n_17_9_6 0.11496719052707945
R7129 n_17_9_6 n_17_10_6 919.1264606088854
R7130 n_17_9_6 n_17_9_7 0.15602690142960765
R7131 n_17_9_7 n_17_10_7 1575.6453610438086
R7132 n_17_9_7 n_17_9_8 0.11496719052707909
R7133 n_17_9_8 n_17_10_8 1575.6453610438086
R7134 n_17_9_8 n_17_9_9 0.11496719052707909
R7135 n_17_9_9 n_17_10_9 1575.6453610438086
R7136 n_17_9_9 n_17_9_10 0.11496719052707909
R7137 n_17_9_10 n_17_10_10 1575.6453610438086
R7138 n_17_9_10 n_17_9_11 0.11496719052707835
R7139 n_17_9_11 n_17_10_11 1575.6453610438282
R7140 n_17_9_11 n_17_9_12 0.11496719052707799
R7141 n_17_9_12 n_17_10_12 1575.6453610438186
R7142 n_17_9_12 n_17_9_13 0.11496719052707909
R7143 n_17_9_13 n_17_10_13 1575.6453610437984
R7144 n_17_9_13 n_17_9_14 0.5748359526353968
R7145 n_17_9_14 n_17_10_14 175.071706782645
R7146 n_17_9_14 n_17_9_15 17.762430936433926
R7147 n_17_9_15 n_17_10_15 57904.96701835926
R7148 n_17_10_0 n_17_11_0 28.30578398702867
R7149 n_17_10_0 n_17_10_1 817.3292138447346
R7150 n_17_10_1 n_17_11_1 39.62809758184014
R7151 n_17_10_1 n_17_10_2 3591.2950305298937
R7152 n_17_10_2 n_17_11_2 141.52891993514334
R7153 n_17_10_2 n_17_10_3 3472.410781243387
R7154 n_17_10_3 n_17_11_3 990.7024395460026
R7155 n_17_10_3 n_17_10_4 32.19781751509563
R7156 n_17_10_4 n_17_11_4 45.03192907027285
R7157 n_17_10_4 n_17_10_5 28.18783291614599
R7158 n_17_10_5 n_17_11_5 188.70522658019098
R7159 n_17_10_5 n_17_10_6 6.604680515917052
R7160 n_17_10_6 n_17_11_6 31.450871096698492
R7161 n_17_10_6 n_17_10_7 8.963494985887417
R7162 n_17_10_7 n_17_11_7 53.91577902291188
R7163 n_17_10_7 n_17_10_8 6.604680515917031
R7164 n_17_10_8 n_17_11_8 53.91577902291188
R7165 n_17_10_8 n_17_10_9 6.604680515917031
R7166 n_17_10_9 n_17_11_9 53.91577902291188
R7167 n_17_10_9 n_17_10_10 6.604680515917031
R7168 n_17_10_10 n_17_11_10 53.91577902291188
R7169 n_17_10_10 n_17_10_11 6.604680515916989
R7170 n_17_10_11 n_17_11_11 53.915779022912545
R7171 n_17_10_11 n_17_10_12 6.604680515916968
R7172 n_17_10_12 n_17_11_12 53.91577902291222
R7173 n_17_10_12 n_17_10_13 6.604680515917032
R7174 n_17_10_13 n_17_11_13 53.91577902291153
R7175 n_17_10_13 n_17_10_14 33.02340257958524
R7176 n_17_10_14 n_17_11_14 5.990642113656862
R7177 n_17_10_14 n_17_10_15 1020.4231397091934
R7178 n_17_10_15 n_17_11_15 1981.4048790919874
R7179 n_17_11_0 n_17_12_0 326.2736359366244
R7180 n_17_11_0 n_17_11_1 817.3292138447634
R7181 n_17_11_1 n_17_12_1 456.78309031127424
R7182 n_17_11_1 n_17_11_2 3591.2950305300214
R7183 n_17_11_2 n_17_12_2 1631.3681796831222
R7184 n_17_11_2 n_17_11_3 3472.4107812435104
R7185 n_17_11_3 n_17_12_3 11419.577257781844
R7186 n_17_11_3 n_17_11_4 32.19781751509677
R7187 n_17_11_4 n_17_12_4 519.0716935355384
R7188 n_17_11_4 n_17_11_5 28.187832916146988
R7189 n_17_11_5 n_17_12_5 2175.1575729108276
R7190 n_17_11_5 n_17_11_6 6.604680515917286
R7191 n_17_11_6 n_17_12_6 362.5262621518046
R7192 n_17_11_6 n_17_11_7 8.963494985887735
R7193 n_17_11_7 n_17_12_7 621.4735922602384
R7194 n_17_11_7 n_17_11_8 6.6046805159172655
R7195 n_17_11_8 n_17_12_8 621.4735922602384
R7196 n_17_11_8 n_17_11_9 6.6046805159172655
R7197 n_17_11_9 n_17_12_9 621.4735922602384
R7198 n_17_11_9 n_17_11_10 6.6046805159172655
R7199 n_17_11_10 n_17_12_10 621.4735922602384
R7200 n_17_11_10 n_17_11_11 6.604680515917224
R7201 n_17_11_11 n_17_12_11 621.4735922602463
R7202 n_17_11_11 n_17_11_12 6.604680515917202
R7203 n_17_11_12 n_17_12_12 621.4735922602424
R7204 n_17_11_12 n_17_11_13 6.604680515917266
R7205 n_17_11_13 n_17_12_13 621.4735922602345
R7206 n_17_11_13 n_17_11_14 33.02340257958641
R7207 n_17_11_14 n_17_12_14 69.05262136224856
R7208 n_17_11_14 n_17_11_15 1020.4231397092295
R7209 n_17_11_15 n_17_12_15 22839.15451556349
R7210 n_17_12_0 n_17_13_0 624.2414878862212
R7211 n_17_12_0 n_17_12_1 37.061208878821304
R7212 n_17_12_1 n_17_13_1 873.9380830407097
R7213 n_17_12_1 n_17_12_2 162.84470567966937
R7214 n_17_12_2 n_17_13_2 3121.2074394311057
R7215 n_17_12_2 n_17_12_3 157.45398438820445
R7216 n_17_12_3 n_17_13_3 21848.452076017722
R7217 n_17_12_3 n_17_12_4 1.4599870164384166
R7218 n_17_12_4 n_17_13_4 993.1114580008056
R7219 n_17_12_4 n_17_12_5 1.2781571316072584
R7220 n_17_12_5 n_17_13_5 4161.609919241471
R7221 n_17_12_5 n_17_12_6 0.2994845161924957
R7222 n_17_12_6 n_17_13_6 693.6016532069118
R7223 n_17_12_6 n_17_12_7 0.40644327197552943
R7224 n_17_12_7 n_17_13_7 1189.0314054975668
R7225 n_17_12_7 n_17_12_8 0.2994845161924948
R7226 n_17_12_8 n_17_13_8 1189.0314054975668
R7227 n_17_12_8 n_17_12_9 0.2994845161924948
R7228 n_17_12_9 n_17_13_9 1189.0314054975668
R7229 n_17_12_9 n_17_12_10 0.2994845161924948
R7230 n_17_12_10 n_17_13_10 1189.0314054975668
R7231 n_17_12_10 n_17_12_11 0.29948451619249283
R7232 n_17_12_11 n_17_13_11 1189.0314054975818
R7233 n_17_12_11 n_17_12_12 0.29948451619249195
R7234 n_17_12_12 n_17_13_12 1189.0314054975745
R7235 n_17_12_12 n_17_12_13 0.29948451619249483
R7236 n_17_12_13 n_17_13_13 1189.0314054975593
R7237 n_17_12_13 n_17_12_14 1.4974225809624777
R7238 n_17_12_14 n_17_13_14 132.11460061084045
R7239 n_17_12_14 n_17_12_15 46.27035775174099
R7240 n_17_12_15 n_17_13_15 43696.90415203506
R7241 n_17_13_0 n_17_13_1 37.06120887882125
R7242 n_17_13_1 n_17_13_2 162.84470567966912
R7243 n_17_13_2 n_17_13_3 157.4539843882042
R7244 n_17_13_3 n_17_13_4 1.459987016438414
R7245 n_17_13_4 n_17_13_5 1.2781571316072564
R7246 n_17_13_5 n_17_13_6 0.2994845161924952
R7247 n_17_13_6 n_17_13_7 0.40644327197552876
R7248 n_17_13_7 n_17_13_8 0.2994845161924943
R7249 n_17_13_8 n_17_13_9 0.2994845161924943
R7250 n_17_13_9 n_17_13_10 0.2994845161924943
R7251 n_17_13_10 n_17_13_11 0.2994845161924924
R7252 n_17_13_11 n_17_13_12 0.2994845161924914
R7253 n_17_13_12 n_17_13_13 0.2994845161924943
R7254 n_17_13_13 n_17_13_14 1.4974225809624753
R7255 n_17_13_14 n_17_13_15 46.2703577517409
R7256 n_0_0_15 amb 128.35049588611483
R7257 n_0_1_15 amb 128.35049588611483
R7258 n_0_2_15 amb 2830.582739930901
R7259 n_0_3_15 amb 2830.582739930901
R7260 n_0_4_15 amb 49.271653083033655
R7261 n_0_5_15 amb 49.27165308303368
R7262 n_0_6_15 amb 2830.5778813335755
R7263 n_0_7_15 amb 2830.5778813335755
R7264 n_0_8_15 amb 49.27165308303368
R7265 n_0_9_15 amb 49.27165308303368
R7266 n_0_10_15 amb 2830.577363964429
R7267 n_0_11_15 amb 2830.5773639645295
R7268 n_0_12_15 amb 128.35050693964
R7269 n_0_13_15 amb 128.3505069396398
R7270 n_1_0_15 amb 128.35049588611483
R7271 n_1_1_15 amb 128.35049588611483
R7272 n_1_2_15 amb 2830.582739930901
R7273 n_1_3_15 amb 2830.582739930901
R7274 n_1_4_15 amb 49.271653083033655
R7275 n_1_5_15 amb 49.27165308303368
R7276 n_1_6_15 amb 2830.5778813335755
R7277 n_1_7_15 amb 2830.5778813335755
R7278 n_1_8_15 amb 49.27165308303368
R7279 n_1_9_15 amb 49.27165308303368
R7280 n_1_10_15 amb 2830.577363964429
R7281 n_1_11_15 amb 2830.5773639645295
R7282 n_1_12_15 amb 128.35050693964
R7283 n_1_13_15 amb 128.3505069396398
R7284 n_2_0_15 amb 647.775329730652
R7285 n_2_1_15 amb 647.775329730652
R7286 n_2_2_4 amb 14285.738867075088
R7287 n_2_2_15 amb 14285.738867075088
R7288 n_2_3_4 amb 14285.738867075088
R7289 n_2_3_15 amb 14285.738867075088
R7290 n_2_4_4 amb 248.67033899546664
R7291 n_2_4_15 amb 248.67033899546664
R7292 n_2_5_4 amb 248.6703389954667
R7293 n_2_5_15 amb 248.6703389954667
R7294 n_2_6_4 amb 14285.714346098655
R7295 n_2_6_15 amb 14285.714346098655
R7296 n_2_7_4 amb 14285.714346098655
R7297 n_2_7_15 amb 14285.714346098655
R7298 n_2_8_4 amb 248.6703389954667
R7299 n_2_8_15 amb 248.6703389954667
R7300 n_2_9_4 amb 248.6703389954667
R7301 n_2_9_15 amb 248.6703389954667
R7302 n_2_10_4 amb 14285.711734975363
R7303 n_2_10_15 amb 14285.711734975363
R7304 n_2_11_4 amb 14285.711734975868
R7305 n_2_11_15 amb 14285.711734975868
R7306 n_2_12_15 amb 647.7753855169649
R7307 n_2_13_15 amb 647.7753855169639
R7308 n_3_0_15 amb 647.775329730652
R7309 n_3_1_15 amb 647.775329730652
R7310 n_3_2_4 amb 14285.738867075088
R7311 n_3_2_15 amb 14285.738867075088
R7312 n_3_3_4 amb 14285.738867075088
R7313 n_3_3_15 amb 14285.738867075088
R7314 n_3_4_4 amb 248.67033899546664
R7315 n_3_4_15 amb 248.67033899546664
R7316 n_3_5_4 amb 248.6703389954667
R7317 n_3_5_15 amb 248.6703389954667
R7318 n_3_6_4 amb 14285.714346098655
R7319 n_3_6_15 amb 14285.714346098655
R7320 n_3_7_4 amb 14285.714346098655
R7321 n_3_7_15 amb 14285.714346098655
R7322 n_3_8_4 amb 248.6703389954667
R7323 n_3_8_15 amb 248.6703389954667
R7324 n_3_9_4 amb 248.6703389954667
R7325 n_3_9_15 amb 248.6703389954667
R7326 n_3_10_4 amb 14285.711734975363
R7327 n_3_10_15 amb 14285.711734975363
R7328 n_3_11_4 amb 14285.711734975868
R7329 n_3_11_15 amb 14285.711734975868
R7330 n_3_12_15 amb 647.7753855169649
R7331 n_3_13_15 amb 647.7753855169639
R7332 n_4_0_15 amb 17.13643740504622
R7333 n_4_1_15 amb 17.13643740504622
R7334 n_4_2_4 amb 377.91910041134156
R7335 n_4_2_15 amb 377.91910041134156
R7336 n_4_3_4 amb 377.91910041134156
R7337 n_4_3_15 amb 377.91910041134156
R7338 n_4_4_15 amb 6.578397637432899
R7339 n_4_5_15 amb 6.578397637432902
R7340 n_4_6_4 amb 377.918451726283
R7341 n_4_6_15 amb 377.918451726283
R7342 n_4_7_4 amb 377.918451726283
R7343 n_4_7_15 amb 377.918451726283
R7344 n_4_8_15 amb 6.578397637432902
R7345 n_4_9_15 amb 6.578397637432902
R7346 n_4_10_4 amb 377.9183826508662
R7347 n_4_10_15 amb 377.9183826508662
R7348 n_4_11_4 amb 377.9183826508796
R7349 n_4_11_15 amb 377.9183826508796
R7350 n_4_12_15 amb 17.136438880833605
R7351 n_4_13_15 amb 17.136438880833577
R7352 n_5_0_15 amb 17.136437405046216
R7353 n_5_1_15 amb 17.136437405046216
R7354 n_5_2_4 amb 377.91910041134145
R7355 n_5_2_15 amb 377.91910041134145
R7356 n_5_3_4 amb 377.91910041134145
R7357 n_5_3_15 amb 377.91910041134145
R7358 n_5_4_15 amb 6.578397637432898
R7359 n_5_5_15 amb 6.5783976374329
R7360 n_5_6_4 amb 377.9184517262829
R7361 n_5_6_15 amb 377.9184517262829
R7362 n_5_7_4 amb 377.9184517262829
R7363 n_5_7_15 amb 377.9184517262829
R7364 n_5_8_15 amb 6.5783976374329
R7365 n_5_9_15 amb 6.5783976374329
R7366 n_5_10_4 amb 377.91838265086614
R7367 n_5_10_15 amb 377.91838265086614
R7368 n_5_11_4 amb 377.91838265087955
R7369 n_5_11_15 amb 377.91838265087955
R7370 n_5_12_15 amb 17.1364388808336
R7371 n_5_13_15 amb 17.136438880833573
R7372 n_6_0_15 amb 647.7753269925596
R7373 n_6_1_15 amb 647.7753269925596
R7374 n_6_2_4 amb 14285.738806690459
R7375 n_6_2_15 amb 14285.738806690459
R7376 n_6_3_4 amb 14285.738806690459
R7377 n_6_3_15 amb 14285.738806690459
R7378 n_6_4_4 amb 248.6703379443578
R7379 n_6_4_15 amb 248.6703379443578
R7380 n_6_5_4 amb 248.6703379443579
R7381 n_6_5_15 amb 248.6703379443579
R7382 n_6_6_4 amb 14285.714285714135
R7383 n_6_6_15 amb 14285.714285714135
R7384 n_6_7_4 amb 14285.714285714135
R7385 n_6_7_15 amb 14285.714285714135
R7386 n_6_8_4 amb 248.6703379443579
R7387 n_6_8_15 amb 248.6703379443579
R7388 n_6_9_4 amb 248.6703379443579
R7389 n_6_9_15 amb 248.6703379443579
R7390 n_6_10_4 amb 14285.71167459085
R7391 n_6_10_15 amb 14285.71167459085
R7392 n_6_11_4 amb 14285.711674591355
R7393 n_6_11_15 amb 14285.711674591355
R7394 n_6_12_15 amb 647.7753827788723
R7395 n_6_13_15 amb 647.7753827788713
R7396 n_7_0_15 amb 647.7753269925596
R7397 n_7_1_15 amb 647.7753269925596
R7398 n_7_2_4 amb 14285.738806690459
R7399 n_7_2_15 amb 14285.738806690459
R7400 n_7_3_4 amb 14285.738806690459
R7401 n_7_3_15 amb 14285.738806690459
R7402 n_7_4_4 amb 248.6703379443578
R7403 n_7_4_15 amb 248.6703379443578
R7404 n_7_5_4 amb 248.6703379443579
R7405 n_7_5_15 amb 248.6703379443579
R7406 n_7_6_4 amb 14285.714285714135
R7407 n_7_6_15 amb 14285.714285714135
R7408 n_7_7_4 amb 14285.714285714135
R7409 n_7_7_15 amb 14285.714285714135
R7410 n_7_8_4 amb 248.6703379443579
R7411 n_7_8_15 amb 248.6703379443579
R7412 n_7_9_4 amb 248.6703379443579
R7413 n_7_9_15 amb 248.6703379443579
R7414 n_7_10_4 amb 14285.71167459085
R7415 n_7_10_15 amb 14285.71167459085
R7416 n_7_11_4 amb 14285.711674591355
R7417 n_7_11_15 amb 14285.711674591355
R7418 n_7_12_15 amb 647.7753827788723
R7419 n_7_13_15 amb 647.7753827788713
R7420 n_8_0_15 amb 17.13643740696242
R7421 n_8_1_15 amb 17.13643740696242
R7422 n_8_2_4 amb 377.91910045360044
R7423 n_8_2_15 amb 377.91910045360044
R7424 n_8_3_4 amb 377.91910045360044
R7425 n_8_3_15 amb 377.91910045360044
R7426 n_8_4_15 amb 6.578397638168496
R7427 n_8_5_15 amb 6.578397638168497
R7428 n_8_6_4 amb 377.91845176854184
R7429 n_8_6_15 amb 377.91845176854184
R7430 n_8_7_4 amb 377.91845176854184
R7431 n_8_7_15 amb 377.91845176854184
R7432 n_8_8_15 amb 6.578397638168497
R7433 n_8_9_15 amb 6.578397638168497
R7434 n_8_10_4 amb 377.918382693125
R7435 n_8_10_15 amb 377.918382693125
R7436 n_8_11_4 amb 377.9183826931385
R7437 n_8_11_15 amb 377.9183826931385
R7438 n_8_12_15 amb 17.136438882749804
R7439 n_8_13_15 amb 17.136438882749772
R7440 n_9_0_15 amb 17.13643740696242
R7441 n_9_1_15 amb 17.13643740696242
R7442 n_9_2_4 amb 377.91910045360044
R7443 n_9_2_15 amb 377.91910045360044
R7444 n_9_3_4 amb 377.91910045360044
R7445 n_9_3_15 amb 377.91910045360044
R7446 n_9_4_15 amb 6.578397638168496
R7447 n_9_5_15 amb 6.578397638168497
R7448 n_9_6_4 amb 377.91845176854184
R7449 n_9_6_15 amb 377.91845176854184
R7450 n_9_7_4 amb 377.91845176854184
R7451 n_9_7_15 amb 377.91845176854184
R7452 n_9_8_15 amb 6.578397638168497
R7453 n_9_9_15 amb 6.578397638168497
R7454 n_9_10_4 amb 377.918382693125
R7455 n_9_10_15 amb 377.918382693125
R7456 n_9_11_4 amb 377.9183826931385
R7457 n_9_11_15 amb 377.9183826931385
R7458 n_9_12_15 amb 17.136438882749804
R7459 n_9_13_15 amb 17.136438882749772
R7460 n_10_0_15 amb 647.7753269925482
R7461 n_10_1_15 amb 647.7753269925482
R7462 n_10_2_4 amb 14285.738806690204
R7463 n_10_2_15 amb 14285.738806690204
R7464 n_10_3_4 amb 14285.738806690204
R7465 n_10_3_15 amb 14285.738806690204
R7466 n_10_4_4 amb 248.6703379443534
R7467 n_10_4_15 amb 248.6703379443534
R7468 n_10_5_4 amb 248.67033794435352
R7469 n_10_5_15 amb 248.67033794435352
R7470 n_10_6_4 amb 14285.714285713877
R7471 n_10_6_15 amb 14285.714285713877
R7472 n_10_7_4 amb 14285.714285713877
R7473 n_10_7_15 amb 14285.714285713877
R7474 n_10_8_4 amb 248.67033794435352
R7475 n_10_8_15 amb 248.67033794435352
R7476 n_10_9_4 amb 248.67033794435352
R7477 n_10_9_15 amb 248.67033794435352
R7478 n_10_10_4 amb 14285.711674590595
R7479 n_10_10_15 amb 14285.711674590595
R7480 n_10_11_4 amb 14285.7116745911
R7481 n_10_11_15 amb 14285.7116745911
R7482 n_10_12_15 amb 647.7753827788608
R7483 n_10_13_15 amb 647.7753827788598
R7484 n_11_0_15 amb 647.7753269925482
R7485 n_11_1_15 amb 647.7753269925482
R7486 n_11_2_4 amb 14285.738806690204
R7487 n_11_2_15 amb 14285.738806690204
R7488 n_11_3_4 amb 14285.738806690204
R7489 n_11_3_15 amb 14285.738806690204
R7490 n_11_4_4 amb 248.6703379443534
R7491 n_11_4_15 amb 248.6703379443534
R7492 n_11_5_4 amb 248.67033794435352
R7493 n_11_5_15 amb 248.67033794435352
R7494 n_11_6_4 amb 14285.714285713877
R7495 n_11_6_15 amb 14285.714285713877
R7496 n_11_7_4 amb 14285.714285713877
R7497 n_11_7_15 amb 14285.714285713877
R7498 n_11_8_4 amb 248.67033794435352
R7499 n_11_8_15 amb 248.67033794435352
R7500 n_11_9_4 amb 248.67033794435352
R7501 n_11_9_15 amb 248.67033794435352
R7502 n_11_10_4 amb 14285.711674590595
R7503 n_11_10_15 amb 14285.711674590595
R7504 n_11_11_4 amb 14285.7116745911
R7505 n_11_11_15 amb 14285.7116745911
R7506 n_11_12_15 amb 647.7753827788608
R7507 n_11_13_15 amb 647.7753827788598
R7508 n_12_0_15 amb 17.13643740696241
R7509 n_12_1_15 amb 17.13643740696241
R7510 n_12_2_4 amb 377.9191004536002
R7511 n_12_2_15 amb 377.9191004536002
R7512 n_12_3_4 amb 377.9191004536002
R7513 n_12_3_15 amb 377.9191004536002
R7514 n_12_4_15 amb 6.578397638168492
R7515 n_12_5_15 amb 6.578397638168495
R7516 n_12_6_4 amb 377.9184517685417
R7517 n_12_6_15 amb 377.9184517685417
R7518 n_12_7_4 amb 377.9184517685417
R7519 n_12_7_15 amb 377.9184517685417
R7520 n_12_8_15 amb 6.578397638168495
R7521 n_12_9_15 amb 6.578397638168495
R7522 n_12_10_4 amb 377.91838269312484
R7523 n_12_10_15 amb 377.91838269312484
R7524 n_12_11_4 amb 377.91838269313826
R7525 n_12_11_15 amb 377.91838269313826
R7526 n_12_12_15 amb 17.13643888274979
R7527 n_12_13_15 amb 17.136438882749765
R7528 n_13_0_15 amb 17.136437406962425
R7529 n_13_1_15 amb 17.136437406962425
R7530 n_13_2_4 amb 377.91910045360066
R7531 n_13_2_15 amb 377.91910045360066
R7532 n_13_3_4 amb 377.91910045360066
R7533 n_13_3_15 amb 377.91910045360066
R7534 n_13_4_15 amb 6.578397638168498
R7535 n_13_5_15 amb 6.578397638168501
R7536 n_13_6_4 amb 377.91845176854207
R7537 n_13_6_15 amb 377.91845176854207
R7538 n_13_7_4 amb 377.91845176854207
R7539 n_13_7_15 amb 377.91845176854207
R7540 n_13_8_15 amb 6.578397638168501
R7541 n_13_9_15 amb 6.578397638168501
R7542 n_13_10_4 amb 377.9183826931251
R7543 n_13_10_15 amb 377.9183826931251
R7544 n_13_11_4 amb 377.91838269313865
R7545 n_13_11_15 amb 377.91838269313865
R7546 n_13_12_15 amb 17.13643888274981
R7547 n_13_13_15 amb 17.13643888274978
R7548 n_14_0_15 amb 647.7753269925712
R7549 n_14_1_15 amb 647.7753269925712
R7550 n_14_2_4 amb 14285.738806690713
R7551 n_14_2_15 amb 14285.738806690713
R7552 n_14_3_4 amb 14285.738806690713
R7553 n_14_3_15 amb 14285.738806690713
R7554 n_14_4_4 amb 248.67033794436225
R7555 n_14_4_15 amb 248.67033794436225
R7556 n_14_5_4 amb 248.67033794436236
R7557 n_14_5_15 amb 248.67033794436236
R7558 n_14_6_4 amb 14285.714285714386
R7559 n_14_6_15 amb 14285.714285714386
R7560 n_14_7_4 amb 14285.714285714386
R7561 n_14_7_15 amb 14285.714285714386
R7562 n_14_8_4 amb 248.67033794436236
R7563 n_14_8_15 amb 248.67033794436236
R7564 n_14_9_4 amb 248.67033794436236
R7565 n_14_9_15 amb 248.67033794436236
R7566 n_14_10_4 amb 14285.7116745911
R7567 n_14_10_15 amb 14285.7116745911
R7568 n_14_11_4 amb 14285.71167459161
R7569 n_14_11_15 amb 14285.71167459161
R7570 n_14_12_15 amb 647.7753827788838
R7571 n_14_13_15 amb 647.7753827788828
R7572 n_15_0_15 amb 647.7753269925482
R7573 n_15_1_15 amb 647.7753269925482
R7574 n_15_2_4 amb 14285.738806690204
R7575 n_15_2_15 amb 14285.738806690204
R7576 n_15_3_4 amb 14285.738806690204
R7577 n_15_3_15 amb 14285.738806690204
R7578 n_15_4_4 amb 248.6703379443534
R7579 n_15_4_15 amb 248.6703379443534
R7580 n_15_5_4 amb 248.67033794435352
R7581 n_15_5_15 amb 248.67033794435352
R7582 n_15_6_4 amb 14285.714285713877
R7583 n_15_6_15 amb 14285.714285713877
R7584 n_15_7_4 amb 14285.714285713877
R7585 n_15_7_15 amb 14285.714285713877
R7586 n_15_8_4 amb 248.67033794435352
R7587 n_15_8_15 amb 248.67033794435352
R7588 n_15_9_4 amb 248.67033794435352
R7589 n_15_9_15 amb 248.67033794435352
R7590 n_15_10_4 amb 14285.711674590595
R7591 n_15_10_15 amb 14285.711674590595
R7592 n_15_11_4 amb 14285.7116745911
R7593 n_15_11_15 amb 14285.7116745911
R7594 n_15_12_15 amb 647.7753827788608
R7595 n_15_13_15 amb 647.7753827788598
R7596 n_16_0_15 amb 128.3504958861148
R7597 n_16_1_15 amb 128.3504958861148
R7598 n_16_2_15 amb 2830.5827399309005
R7599 n_16_3_15 amb 2830.5827399309005
R7600 n_16_4_15 amb 49.271653083033634
R7601 n_16_5_15 amb 49.271653083033655
R7602 n_16_6_15 amb 2830.577881333575
R7603 n_16_7_15 amb 2830.577881333575
R7604 n_16_8_15 amb 49.271653083033655
R7605 n_16_9_15 amb 49.271653083033655
R7606 n_16_10_15 amb 2830.577363964428
R7607 n_16_11_15 amb 2830.577363964529
R7608 n_16_12_15 amb 128.35050693963998
R7609 n_16_13_15 amb 128.3505069396398
R7610 n_17_0_15 amb 128.3504958861157
R7611 n_17_1_15 amb 128.3504958861157
R7612 n_17_2_15 amb 2830.58273993092
R7613 n_17_3_15 amb 2830.58273993092
R7614 n_17_4_15 amb 49.27165308303399
R7615 n_17_5_15 amb 49.271653083034
R7616 n_17_6_15 amb 2830.5778813335955
R7617 n_17_7_15 amb 2830.5778813335955
R7618 n_17_8_15 amb 49.271653083034
R7619 n_17_9_15 amb 49.271653083034
R7620 n_17_10_15 amb 2830.5773639644485
R7621 n_17_11_15 amb 2830.5773639645486
R7622 n_17_12_15 amb 128.3505069396409
R7623 n_17_13_15 amb 128.35050693964067
I0 0 n_0_0_4 0.3637332370864001
I1 0 n_0_1_4 0.3637332370864001
I2 0 n_0_2_4 0.01649319085137956
I3 0 n_0_3_4 0.01649319085137956
I4 0 n_0_4_4 0.947509134138976
I5 0 n_0_5_4 0.9475091341389756
I6 0 n_0_6_4 0.01649321916141953
I7 0 n_0_7_4 0.01649321916141953
I8 0 n_0_8_4 0.9475091341389756
I9 0 n_0_9_4 0.9475091341389756
I10 0 n_0_10_4 0.01649322217602808
I11 0 n_0_11_4 0.016493222176027493
I12 0 n_0_12_4 0.36373320576175167
I13 0 n_0_13_4 0.3637332057617523
I14 0 n_1_0_4 0.3637332370864001
I15 0 n_1_1_4 0.3637332370864001
I16 0 n_1_2_4 0.01649319085137956
I17 0 n_1_3_4 0.01649319085137956
I18 0 n_1_4_4 0.947509134138976
I19 0 n_1_5_4 0.9475091341389756
I20 0 n_1_6_4 0.01649321916141953
I21 0 n_1_7_4 0.01649321916141953
I22 0 n_1_8_4 0.9475091341389756
I23 0 n_1_9_4 0.9475091341389756
I24 0 n_1_10_4 0.01649322217602808
I25 0 n_1_11_4 0.016493222176027493
I26 0 n_1_12_4 0.36373320576175167
I27 0 n_1_13_4 0.3637332057617523
I28 0 n_2_0_4 0.07207026758754954
I29 0 n_2_1_4 0.07207026758754954
I30 0 n_2_2_4 0.003267968271343584
I31 0 n_2_3_4 0.003267968271343584
I32 0 n_2_4_4 0.1877398870283131
I33 0 n_2_5_4 0.18773988702831307
I34 0 n_2_6_4 0.0032679738807076674
I35 0 n_2_7_4 0.0032679738807076674
I36 0 n_2_8_4 0.18773988702831307
I37 0 n_2_9_4 0.18773988702831307
I38 0 n_2_10_4 0.0032679744780235646
I39 0 n_2_11_4 0.0032679744780234484
I40 0 n_2_12_4 0.0720702613808696
I41 0 n_2_13_4 0.07207026138086971
I42 0 n_3_0_4 0.07207026758754954
I43 0 n_3_1_4 0.07207026758754954
I44 0 n_3_2_4 0.003267968271343584
I45 0 n_3_3_4 0.003267968271343584
I46 0 n_3_4_4 0.1877398870283131
I47 0 n_3_5_4 0.18773988702831307
I48 0 n_3_6_4 0.0032679738807076674
I49 0 n_3_7_4 0.0032679738807076674
I50 0 n_3_8_4 0.18773988702831307
I51 0 n_3_9_4 0.18773988702831307
I52 0 n_3_10_4 0.0032679744780235646
I53 0 n_3_11_4 0.0032679744780234484
I54 0 n_3_12_4 0.0720702613808696
I55 0 n_3_13_4 0.07207026138086971
I56 0 n_4_0_4 2.724331799359512
I57 0 n_4_1_4 2.724331799359512
I58 0 n_4_2_4 0.12353263251179186
I59 0 n_4_3_4 0.12353263251179186
I60 0 n_4_4_4 7.096764884604837
I61 0 n_4_4_6 0.25000000000000006
I62 0 n_4_4_7 0.125
I63 0 n_4_4_8 0.125
I64 0 n_4_4_9 0.125
I65 0 n_4_4_10 0.125
I66 0 n_4_4_11 0.125
I67 0 n_4_4_12 0.125
I68 0 n_4_4_13 0.12500000000000003
I69 0 n_4_4_14 0.12500000000000003
I70 0 n_4_5_4 7.096764884604834
I71 0 n_4_5_6 0.24999999999999994
I72 0 n_4_5_7 0.12499999999999996
I73 0 n_4_5_8 0.12499999999999996
I74 0 n_4_5_9 0.12499999999999996
I75 0 n_4_5_10 0.12499999999999996
I76 0 n_4_5_11 0.12499999999999996
I77 0 n_4_5_12 0.12499999999999996
I78 0 n_4_5_13 0.12499999999999999
I79 0 n_4_5_14 0.12499999999999999
I80 0 n_4_6_4 0.12353284455164486
I81 0 n_4_7_4 0.12353284455164486
I82 0 n_4_8_4 7.096764884604834
I83 0 n_4_8_6 0.24999999999999994
I84 0 n_4_8_7 0.12499999999999999
I85 0 n_4_8_8 0.12499999999999999
I86 0 n_4_8_9 0.12499999999999999
I87 0 n_4_8_10 0.12499999999999999
I88 0 n_4_8_11 0.125
I89 0 n_4_8_12 0.12499999999999999
I90 0 n_4_8_13 0.12499999999999999
I91 0 n_4_8_14 0.12499999999999999
I92 0 n_4_9_4 7.096764884604834
I93 0 n_4_9_6 0.24999999999999994
I94 0 n_4_9_7 0.12499999999999999
I95 0 n_4_9_8 0.12499999999999999
I96 0 n_4_9_9 0.12499999999999999
I97 0 n_4_9_10 0.12499999999999999
I98 0 n_4_9_11 0.125
I99 0 n_4_9_12 0.12499999999999999
I100 0 n_4_9_13 0.12499999999999999
I101 0 n_4_9_14 0.12499999999999999
I102 0 n_4_10_4 0.12353286713081306
I103 0 n_4_11_4 0.12353286713080866
I104 0 n_4_12_4 2.724331564740492
I105 0 n_4_13_4 2.724331564740497
I106 0 n_5_0_4 2.724331799359513
I107 0 n_5_1_4 2.724331799359513
I108 0 n_5_2_4 0.12353263251179186
I109 0 n_5_3_4 0.12353263251179186
I110 0 n_5_4_4 7.096764884604839
I111 0 n_5_4_6 0.2500000000000001
I112 0 n_5_4_7 0.12500000000000003
I113 0 n_5_4_8 0.12500000000000003
I114 0 n_5_4_9 0.12500000000000003
I115 0 n_5_4_10 0.12500000000000003
I116 0 n_5_4_11 0.12500000000000003
I117 0 n_5_4_12 0.12500000000000003
I118 0 n_5_4_13 0.12500000000000003
I119 0 n_5_4_14 0.12500000000000006
I120 0 n_5_5_4 7.096764884604836
I121 0 n_5_5_6 0.25
I122 0 n_5_5_7 0.12499999999999999
I123 0 n_5_5_8 0.12499999999999999
I124 0 n_5_5_9 0.12499999999999999
I125 0 n_5_5_10 0.12499999999999999
I126 0 n_5_5_11 0.12499999999999999
I127 0 n_5_5_12 0.12499999999999999
I128 0 n_5_5_13 0.125
I129 0 n_5_5_14 0.125
I130 0 n_5_6_4 0.1235328445516449
I131 0 n_5_7_4 0.1235328445516449
I132 0 n_5_8_4 7.096764884604836
I133 0 n_5_8_6 0.25
I134 0 n_5_8_7 0.125
I135 0 n_5_8_8 0.125
I136 0 n_5_8_9 0.125
I137 0 n_5_8_10 0.125
I138 0 n_5_8_11 0.12500000000000003
I139 0 n_5_8_12 0.125
I140 0 n_5_8_13 0.125
I141 0 n_5_8_14 0.125
I142 0 n_5_9_4 7.096764884604836
I143 0 n_5_9_6 0.25
I144 0 n_5_9_7 0.125
I145 0 n_5_9_8 0.125
I146 0 n_5_9_9 0.125
I147 0 n_5_9_10 0.125
I148 0 n_5_9_11 0.12500000000000003
I149 0 n_5_9_12 0.125
I150 0 n_5_9_13 0.125
I151 0 n_5_9_14 0.125
I152 0 n_5_10_4 0.12353286713081309
I153 0 n_5_11_4 0.12353286713080869
I154 0 n_5_12_4 2.7243315647404924
I155 0 n_5_13_4 2.7243315647404973
I156 0 n_6_0_4 0.07207026789218456
I157 0 n_6_1_4 0.07207026789218456
I158 0 n_6_2_4 0.0032679682851570135
I159 0 n_6_3_4 0.0032679682851570135
I160 0 n_6_4_4 0.18773988782187395
I161 0 n_6_5_4 0.18773988782187387
I162 0 n_6_6_4 0.00326797389452112
I163 0 n_6_7_4 0.00326797389452112
I164 0 n_6_8_4 0.18773988782187387
I165 0 n_6_9_4 0.18773988782187387
I166 0 n_6_10_4 0.00326797449183702
I167 0 n_6_11_4 0.003267974491836905
I168 0 n_6_12_4 0.07207026168550457
I169 0 n_6_13_4 0.0720702616855047
I170 0 n_7_0_4 0.07207026789218456
I171 0 n_7_1_4 0.07207026789218456
I172 0 n_7_2_4 0.0032679682851570135
I173 0 n_7_3_4 0.0032679682851570135
I174 0 n_7_4_4 0.18773988782187395
I175 0 n_7_5_4 0.18773988782187387
I176 0 n_7_6_4 0.00326797389452112
I177 0 n_7_7_4 0.00326797389452112
I178 0 n_7_8_4 0.18773988782187387
I179 0 n_7_9_4 0.18773988782187387
I180 0 n_7_10_4 0.00326797449183702
I181 0 n_7_11_4 0.003267974491836905
I182 0 n_7_12_4 0.07207026168550457
I183 0 n_7_13_4 0.0720702616855047
I184 0 n_8_0_4 2.724331799054877
I185 0 n_8_1_4 2.724331799054877
I186 0 n_8_2_4 0.12353263249797844
I187 0 n_8_3_4 0.12353263249797844
I188 0 n_8_4_4 7.096764883811278
I189 0 n_8_4_6 0.25000000000000006
I190 0 n_8_4_7 0.12500000000000003
I191 0 n_8_4_8 0.12500000000000003
I192 0 n_8_4_9 0.12500000000000003
I193 0 n_8_4_10 0.12500000000000003
I194 0 n_8_4_11 0.12500000000000003
I195 0 n_8_4_12 0.12500000000000003
I196 0 n_8_4_13 0.12500000000000003
I197 0 n_8_4_14 0.12500000000000003
I198 0 n_8_5_4 7.096764883811275
I199 0 n_8_5_6 0.24999999999999994
I200 0 n_8_5_7 0.12499999999999999
I201 0 n_8_5_8 0.12499999999999999
I202 0 n_8_5_9 0.12499999999999999
I203 0 n_8_5_10 0.12499999999999999
I204 0 n_8_5_11 0.12499999999999996
I205 0 n_8_5_12 0.125
I206 0 n_8_5_13 0.12499999999999999
I207 0 n_8_5_14 0.12499999999999997
I208 0 n_8_6_4 0.12353284453783142
I209 0 n_8_7_4 0.12353284453783142
I210 0 n_8_8_4 7.096764883811275
I211 0 n_8_8_6 0.25
I212 0 n_8_8_7 0.125
I213 0 n_8_8_8 0.125
I214 0 n_8_8_9 0.125
I215 0 n_8_8_10 0.125
I216 0 n_8_8_11 0.125
I217 0 n_8_8_12 0.125
I218 0 n_8_8_13 0.125
I219 0 n_8_8_14 0.125
I220 0 n_8_9_4 7.096764883811275
I221 0 n_8_9_6 0.25
I222 0 n_8_9_7 0.125
I223 0 n_8_9_8 0.125
I224 0 n_8_9_9 0.125
I225 0 n_8_9_10 0.125
I226 0 n_8_9_11 0.125
I227 0 n_8_9_12 0.125
I228 0 n_8_9_13 0.125
I229 0 n_8_9_14 0.125
I230 0 n_8_10_4 0.12353286711699962
I231 0 n_8_11_4 0.12353286711699524
I232 0 n_8_12_4 2.724331564435857
I233 0 n_8_13_4 2.724331564435862
I234 0 n_9_0_4 2.724331799054877
I235 0 n_9_1_4 2.724331799054877
I236 0 n_9_2_4 0.12353263249797844
I237 0 n_9_3_4 0.12353263249797844
I238 0 n_9_4_4 7.096764883811278
I239 0 n_9_4_6 0.25000000000000006
I240 0 n_9_4_7 0.12500000000000003
I241 0 n_9_4_8 0.12500000000000003
I242 0 n_9_4_9 0.12500000000000003
I243 0 n_9_4_10 0.12500000000000003
I244 0 n_9_4_11 0.12500000000000003
I245 0 n_9_4_12 0.12500000000000003
I246 0 n_9_4_13 0.12500000000000003
I247 0 n_9_4_14 0.12500000000000003
I248 0 n_9_5_4 7.096764883811275
I249 0 n_9_5_6 0.24999999999999994
I250 0 n_9_5_7 0.12499999999999999
I251 0 n_9_5_8 0.12499999999999999
I252 0 n_9_5_9 0.12499999999999999
I253 0 n_9_5_10 0.12499999999999999
I254 0 n_9_5_11 0.12499999999999996
I255 0 n_9_5_12 0.125
I256 0 n_9_5_13 0.12499999999999999
I257 0 n_9_5_14 0.12499999999999997
I258 0 n_9_6_4 0.12353284453783142
I259 0 n_9_7_4 0.12353284453783142
I260 0 n_9_8_4 7.096764883811275
I261 0 n_9_8_6 0.25
I262 0 n_9_8_7 0.125
I263 0 n_9_8_8 0.125
I264 0 n_9_8_9 0.125
I265 0 n_9_8_10 0.125
I266 0 n_9_8_11 0.125
I267 0 n_9_8_12 0.125
I268 0 n_9_8_13 0.125
I269 0 n_9_8_14 0.125
I270 0 n_9_9_4 7.096764883811275
I271 0 n_9_9_6 0.25
I272 0 n_9_9_7 0.125
I273 0 n_9_9_8 0.125
I274 0 n_9_9_9 0.125
I275 0 n_9_9_10 0.125
I276 0 n_9_9_11 0.125
I277 0 n_9_9_12 0.125
I278 0 n_9_9_13 0.125
I279 0 n_9_9_14 0.125
I280 0 n_9_10_4 0.12353286711699962
I281 0 n_9_11_4 0.12353286711699524
I282 0 n_9_12_4 2.724331564435857
I283 0 n_9_13_4 2.724331564435862
I284 0 n_10_0_4 0.07207026789218582
I285 0 n_10_1_4 0.07207026789218582
I286 0 n_10_2_4 0.0032679682851570716
I287 0 n_10_3_4 0.0032679682851570716
I288 0 n_10_4_4 0.1877398878218773
I289 0 n_10_5_4 0.1877398878218772
I290 0 n_10_6_4 0.0032679738945211785
I291 0 n_10_7_4 0.0032679738945211785
I292 0 n_10_8_4 0.1877398878218772
I293 0 n_10_9_4 0.1877398878218772
I294 0 n_10_10_4 0.0032679744918370783
I295 0 n_10_11_4 0.0032679744918369625
I296 0 n_10_12_4 0.07207026168550586
I297 0 n_10_13_4 0.07207026168550597
I298 0 n_11_0_4 0.07207026789218582
I299 0 n_11_1_4 0.07207026789218582
I300 0 n_11_2_4 0.0032679682851570716
I301 0 n_11_3_4 0.0032679682851570716
I302 0 n_11_4_4 0.1877398878218773
I303 0 n_11_5_4 0.1877398878218772
I304 0 n_11_6_4 0.0032679738945211785
I305 0 n_11_7_4 0.0032679738945211785
I306 0 n_11_8_4 0.1877398878218772
I307 0 n_11_9_4 0.1877398878218772
I308 0 n_11_10_4 0.0032679744918370783
I309 0 n_11_11_4 0.0032679744918369625
I310 0 n_11_12_4 0.07207026168550586
I311 0 n_11_13_4 0.07207026168550597
I312 0 n_12_0_4 2.724331799054879
I313 0 n_12_1_4 2.724331799054879
I314 0 n_12_2_4 0.12353263249797851
I315 0 n_12_3_4 0.12353263249797851
I316 0 n_12_4_4 7.09676488381128
I317 0 n_12_4_6 0.25000000000000017
I318 0 n_12_4_7 0.12500000000000008
I319 0 n_12_4_8 0.12500000000000008
I320 0 n_12_4_9 0.12500000000000008
I321 0 n_12_4_10 0.12500000000000008
I322 0 n_12_4_11 0.12500000000000008
I323 0 n_12_4_12 0.12500000000000008
I324 0 n_12_4_13 0.12500000000000008
I325 0 n_12_4_14 0.12500000000000006
I326 0 n_12_5_4 7.096764883811279
I327 0 n_12_5_6 0.2500000000000001
I328 0 n_12_5_7 0.12500000000000006
I329 0 n_12_5_8 0.12500000000000006
I330 0 n_12_5_9 0.12500000000000006
I331 0 n_12_5_10 0.12500000000000006
I332 0 n_12_5_11 0.12500000000000003
I333 0 n_12_5_12 0.12500000000000006
I334 0 n_12_5_13 0.12500000000000006
I335 0 n_12_5_14 0.12500000000000003
I336 0 n_12_6_4 0.12353284453783149
I337 0 n_12_7_4 0.12353284453783149
I338 0 n_12_8_4 7.096764883811279
I339 0 n_12_8_6 0.2500000000000001
I340 0 n_12_8_7 0.12500000000000006
I341 0 n_12_8_8 0.12500000000000006
I342 0 n_12_8_9 0.12500000000000006
I343 0 n_12_8_10 0.12500000000000006
I344 0 n_12_8_11 0.12500000000000006
I345 0 n_12_8_12 0.12500000000000006
I346 0 n_12_8_13 0.12500000000000008
I347 0 n_12_8_14 0.12500000000000006
I348 0 n_12_9_4 7.096764883811279
I349 0 n_12_9_6 0.2500000000000001
I350 0 n_12_9_7 0.12500000000000006
I351 0 n_12_9_8 0.12500000000000006
I352 0 n_12_9_9 0.12500000000000006
I353 0 n_12_9_10 0.12500000000000006
I354 0 n_12_9_11 0.12500000000000006
I355 0 n_12_9_12 0.12500000000000006
I356 0 n_12_9_13 0.12500000000000008
I357 0 n_12_9_14 0.12500000000000006
I358 0 n_12_10_4 0.12353286711699968
I359 0 n_12_11_4 0.12353286711699528
I360 0 n_12_12_4 2.7243315644358588
I361 0 n_12_13_4 2.724331564435863
I362 0 n_13_0_4 2.7243317990548763
I363 0 n_13_1_4 2.7243317990548763
I364 0 n_13_2_4 0.12353263249797837
I365 0 n_13_3_4 0.12353263249797837
I366 0 n_13_4_4 7.096764883811273
I367 0 n_13_4_6 0.24999999999999994
I368 0 n_13_4_7 0.12499999999999996
I369 0 n_13_4_8 0.12499999999999996
I370 0 n_13_4_9 0.12499999999999996
I371 0 n_13_4_10 0.12499999999999996
I372 0 n_13_4_11 0.12499999999999994
I373 0 n_13_4_12 0.12499999999999999
I374 0 n_13_4_13 0.12499999999999996
I375 0 n_13_4_14 0.12499999999999994
I376 0 n_13_5_4 7.096764883811271
I377 0 n_13_5_6 0.24999999999999986
I378 0 n_13_5_7 0.12499999999999993
I379 0 n_13_5_8 0.12499999999999993
I380 0 n_13_5_9 0.12499999999999993
I381 0 n_13_5_10 0.12499999999999993
I382 0 n_13_5_11 0.1249999999999999
I383 0 n_13_5_12 0.12499999999999993
I384 0 n_13_5_13 0.12499999999999993
I385 0 n_13_5_14 0.1249999999999999
I386 0 n_13_6_4 0.12353284453783134
I387 0 n_13_7_4 0.12353284453783134
I388 0 n_13_8_4 7.096764883811271
I389 0 n_13_8_6 0.24999999999999992
I390 0 n_13_8_7 0.12499999999999993
I391 0 n_13_8_8 0.12499999999999993
I392 0 n_13_8_9 0.12499999999999993
I393 0 n_13_8_10 0.12499999999999993
I394 0 n_13_8_11 0.12499999999999993
I395 0 n_13_8_12 0.12499999999999993
I396 0 n_13_8_13 0.12499999999999994
I397 0 n_13_8_14 0.12499999999999993
I398 0 n_13_9_4 7.096764883811271
I399 0 n_13_9_6 0.24999999999999992
I400 0 n_13_9_7 0.12499999999999993
I401 0 n_13_9_8 0.12499999999999993
I402 0 n_13_9_9 0.12499999999999993
I403 0 n_13_9_10 0.12499999999999993
I404 0 n_13_9_11 0.12499999999999993
I405 0 n_13_9_12 0.12499999999999993
I406 0 n_13_9_13 0.12499999999999994
I407 0 n_13_9_14 0.12499999999999993
I408 0 n_13_10_4 0.12353286711699957
I409 0 n_13_11_4 0.12353286711699518
I410 0 n_13_12_4 2.724331564435856
I411 0 n_13_13_4 2.7243315644358606
I412 0 n_14_0_4 0.07207026789218328
I413 0 n_14_1_4 0.07207026789218328
I414 0 n_14_2_4 0.0032679682851569553
I415 0 n_14_3_4 0.0032679682851569553
I416 0 n_14_4_4 0.18773988782187062
I417 0 n_14_5_4 0.18773988782187054
I418 0 n_14_6_4 0.003267973894521062
I419 0 n_14_7_4 0.003267973894521062
I420 0 n_14_8_4 0.18773988782187054
I421 0 n_14_9_4 0.18773988782187054
I422 0 n_14_10_4 0.0032679744918369625
I423 0 n_14_11_4 0.0032679744918368467
I424 0 n_14_12_4 0.07207026168550329
I425 0 n_14_13_4 0.07207026168550341
I426 0 n_15_0_4 0.07207026789218582
I427 0 n_15_1_4 0.07207026789218582
I428 0 n_15_2_4 0.0032679682851570716
I429 0 n_15_3_4 0.0032679682851570716
I430 0 n_15_4_4 0.1877398878218773
I431 0 n_15_5_4 0.1877398878218772
I432 0 n_15_6_4 0.0032679738945211785
I433 0 n_15_7_4 0.0032679738945211785
I434 0 n_15_8_4 0.1877398878218772
I435 0 n_15_9_4 0.1877398878218772
I436 0 n_15_10_4 0.0032679744918370783
I437 0 n_15_11_4 0.0032679744918369625
I438 0 n_15_12_4 0.07207026168550586
I439 0 n_15_13_4 0.07207026168550597
I440 0 n_16_0_4 0.36373323708640015
I441 0 n_16_1_4 0.36373323708640015
I442 0 n_16_2_4 0.016493190851379562
I443 0 n_16_3_4 0.016493190851379562
I444 0 n_16_4_4 0.9475091341389762
I445 0 n_16_5_4 0.947509134138976
I446 0 n_16_6_4 0.01649321916141953
I447 0 n_16_7_4 0.01649321916141953
I448 0 n_16_8_4 0.947509134138976
I449 0 n_16_9_4 0.947509134138976
I450 0 n_16_10_4 0.016493222176028086
I451 0 n_16_11_4 0.016493222176027496
I452 0 n_16_12_4 0.3637332057617518
I453 0 n_16_13_4 0.36373320576175233
I454 0 n_17_0_4 0.36373323708639765
I455 0 n_17_1_4 0.36373323708639765
I456 0 n_17_2_4 0.01649319085137945
I457 0 n_17_3_4 0.01649319085137945
I458 0 n_17_4_4 0.9475091341389695
I459 0 n_17_5_4 0.9475091341389692
I460 0 n_17_6_4 0.016493219161419416
I461 0 n_17_7_4 0.016493219161419416
I462 0 n_17_8_4 0.9475091341389692
I463 0 n_17_9_4 0.9475091341389692
I464 0 n_17_10_4 0.01649322217602797
I465 0 n_17_11_4 0.01649322217602738
I466 0 n_17_12_4 0.3637332057617492
I467 0 n_17_13_4 0.3637332057617498
.control
set filetype=ascii
op
write thermal_op.raw all
quit
.endc
.end
